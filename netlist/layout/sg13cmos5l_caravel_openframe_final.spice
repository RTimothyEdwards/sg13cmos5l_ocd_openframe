* NGSPICE file created from sg13cmos5l_caravel_openframe_final.ext - technology: ihp-sg13cmos5l

.subckt sg13cmos5l_DCPDiode anode cathode guard anode_uq0
X0 anode_uq0 cathode dpantenna l=1.26u w=27.78u
X1 anode cathode dpantenna l=1.26u w=27.78u
.ends

.subckt sg13cmos5l_Clamp_P2N2D iovss iovdd pad gate
X0 iovdd gate pad iovdd sg13_hv_pmos ad=3.1302p pd=14.26u as=3.9294p ps=7.84u w=6.66u l=0.6u
X1 iovdd gate pad iovdd sg13_hv_pmos ad=3.1302p pd=14.26u as=3.9294p ps=7.84u w=6.66u l=0.6u
X2 pad gate iovdd iovdd sg13_hv_pmos ad=3.9294p pd=7.84u as=3.1302p ps=14.26u w=6.66u l=0.6u
X3 gate iovdd dpantenna l=0.48u w=0.48u
X4 pad gate iovdd iovdd sg13_hv_pmos ad=3.9294p pd=7.84u as=3.1302p ps=14.26u w=6.66u l=0.6u
.ends

.subckt sg13cmos5l_Clamp_N2N2D iovss pad gate w_n124_n124#
X0 iovss gate pad iovss sg13_hv_nmos ad=2.068p pd=9.74u as=2.596p ps=5.58u w=4.4u l=0.6u
X1 pad gate iovss iovss sg13_hv_nmos ad=2.596p pd=5.58u as=2.068p ps=9.74u w=4.4u l=0.6u
X2 iovss gate dantenna l=0.78u w=0.78u
.ends

.subckt sg13cmos5l_SecondaryProtection iovdd iovss pad core
X0 core iovdd dpantenna l=0.64u w=4.98u
X1 core pad iovss rppd l=2u w=1u
X2 iovss core dantenna l=3.1u w=0.64u
.ends

.subckt sg13cmos5l_LevelDown vdd iovdd vss pad core
Xsg13cmos5l_SecondaryProtection_0 iovdd vss pad sg13cmos5l_SecondaryProtection_0/core
+ sg13cmos5l_SecondaryProtection
X0 vdd a_89_1790# core vdd sg13_lv_pmos ad=1.615p pd=10.18u as=1.615p ps=10.18u w=4.75u l=0.13u
X1 a_89_1790# sg13cmos5l_SecondaryProtection_0/core vss vss sg13_hv_nmos ad=0.901p pd=5.98u as=0.901p ps=5.98u w=2.65u l=0.45u
X2 vss a_89_1790# core vss sg13_lv_nmos ad=0.935p pd=6.18u as=0.935p ps=6.18u w=2.75u l=0.13u
X3 a_89_1790# sg13cmos5l_SecondaryProtection_0/core vdd vdd sg13_hv_pmos ad=1.581p pd=9.98u as=1.581p ps=9.98u w=4.65u l=0.45u
.ends

.subckt sg13cmos5l_io_inv_x1 vdd vss i nq
X0 nq i vss vss sg13_lv_nmos ad=1.3362p pd=8.54u as=1.3362p ps=8.54u w=3.93u l=0.13u
X1 nq i vdd vdd sg13_lv_pmos ad=1.4994p pd=9.5u as=1.4994p ps=9.5u w=4.41u l=0.13u
.ends

.subckt sg13cmos5l_LevelUp vdd iovdd vss i o
X0 a_89_470# i vss vss sg13_hv_nmos ad=0.646p pd=4.48u as=0.361p ps=2.28u w=1.9u l=0.45u
X1 iovdd a_89_470# a_21_506# iovdd sg13_hv_pmos ad=57f pd=0.68u as=0.102p ps=1.28u w=0.3u l=0.45u
X2 vdd i a_21_1826# vdd sg13_lv_pmos ad=1.615p pd=10.18u as=1.615p ps=10.18u w=4.75u l=0.13u
X3 a_89_470# a_21_506# iovdd iovdd sg13_hv_pmos ad=0.102p pd=1.28u as=57f ps=0.68u w=0.3u l=0.45u
X4 vss i a_21_1826# vss sg13_lv_nmos ad=0.935p pd=6.18u as=0.935p ps=6.18u w=2.75u l=0.13u
X5 vss a_21_1826# a_21_506# vss sg13_hv_nmos ad=0.361p pd=2.28u as=0.646p ps=4.48u w=1.9u l=0.45u
X6 o a_89_470# vss vss sg13_hv_nmos ad=0.646p pd=4.48u as=0.646p ps=4.48u w=1.9u l=0.45u
X7 o a_89_470# iovdd iovdd sg13_hv_pmos ad=1.326p pd=8.48u as=1.326p ps=8.48u w=3.9u l=0.45u
.ends

.subckt sg13cmos5l_io_nor2_x1 vdd vss nq i0 i1
X0 vss i1 nq vss sg13_lv_nmos ad=1.4148p pd=8.58u as=0.7467p ps=4.31u w=3.93u l=0.13u
X1 nq i0 vss vss sg13_lv_nmos ad=0.7467p pd=4.31u as=1.3362p ps=8.54u w=3.93u l=0.13u
X2 nq i1 a_115_1276# vdd sg13_lv_pmos ad=1.5876p pd=9.54u as=0.8379p ps=4.79u w=4.41u l=0.13u
X3 a_115_1276# i0 vdd vdd sg13_lv_pmos ad=0.8379p pd=4.79u as=1.4994p ps=9.5u w=4.41u l=0.13u
.ends

.subckt sg13cmos5l_io_nand2_x1 vdd vss nq i0 i1
X0 nq i1 a_115_242# vss sg13_lv_nmos ad=1.4148p pd=8.58u as=0.7467p ps=4.31u w=3.93u l=0.13u
X1 a_115_242# i0 vss vss sg13_lv_nmos ad=0.7467p pd=4.31u as=1.3362p ps=8.54u w=3.93u l=0.13u
X2 vdd i1 nq vdd sg13_lv_pmos ad=1.5876p pd=9.54u as=0.8379p ps=4.79u w=4.41u l=0.13u
X3 nq i0 vdd vdd sg13_lv_pmos ad=0.8379p pd=4.79u as=1.4994p ps=9.5u w=4.41u l=0.13u
.ends

.subckt sg13cmos5l_GateDecode iovdd core en ngate pgate vdd vss
Xsg13cmos5l_io_inv_x1_0 vdd vss en sg13cmos5l_io_inv_x1_0/nq sg13cmos5l_io_inv_x1
Xsg13cmos5l_LevelUp_0 vdd iovdd vss sg13cmos5l_LevelUp_0/i ngate sg13cmos5l_LevelUp
Xsg13cmos5l_LevelUp_1 vdd iovdd vss sg13cmos5l_LevelUp_1/i pgate sg13cmos5l_LevelUp
Xsg13cmos5l_io_nor2_x1_0 vdd vss sg13cmos5l_LevelUp_0/i core sg13cmos5l_io_inv_x1_0/nq
+ sg13cmos5l_io_nor2_x1
Xsg13cmos5l_io_nand2_x1_0 vdd vss sg13cmos5l_LevelUp_1/i core en sg13cmos5l_io_nand2_x1
.ends

.subckt sg13cmos5l_DCNDiode anode cathode guard cathode_uq0
X0 anode cathode_uq0 dantenna l=1.26u w=27.78u
X1 anode cathode dantenna l=1.26u w=27.78u
.ends

.subckt sg13cmos5l_IOPadInOut4mA vdd iovss iovdd p2c pad vss iovdd_uq0 c2p_en c2p
+ sg13cmos5l_DCNDiode_0/guard
Xsg13cmos5l_DCPDiode_0 pad iovdd_uq0 vss pad sg13cmos5l_DCPDiode
Xsg13cmos5l_Clamp_P2N2D_0 vss iovdd_uq0 pad sg13cmos5l_GateDecode_0/pgate sg13cmos5l_Clamp_P2N2D
Xsg13cmos5l_Clamp_N2N2D_0 vss pad sg13cmos5l_GateDecode_0/ngate sg13cmos5l_DCNDiode_0/guard
+ sg13cmos5l_Clamp_N2N2D
Xsg13cmos5l_LevelDown_0 vdd iovdd vss pad p2c sg13cmos5l_LevelDown
Xsg13cmos5l_GateDecode_0 iovdd c2p c2p_en sg13cmos5l_GateDecode_0/ngate sg13cmos5l_GateDecode_0/pgate
+ vdd vss sg13cmos5l_GateDecode
Xsg13cmos5l_DCNDiode_0 vss pad sg13cmos5l_DCNDiode_0/guard pad sg13cmos5l_DCNDiode
.ends

.subckt sg13cmos5l_tiehi L_HI VDD VSS
X0 L_HI a_222_366# VDD VDD sg13_lv_pmos ad=0.3927p pd=2.99u as=0.76727p ps=3.885u w=1.155u l=0.13u
X1 VDD a_23_195# a_23_429# VDD sg13_lv_pmos ad=0.76727p pd=3.885u as=0.2442p ps=2.06u w=0.66u l=0.13u
X2 a_222_366# a_23_429# VSS VSS sg13_lv_nmos ad=0.27427p pd=2.28u as=0.49637p ps=3.565u w=0.795u l=0.13u
X3 VSS a_23_195# a_23_195# VSS sg13_lv_nmos ad=0.49637p pd=3.565u as=0.111p ps=1.34u w=0.3u l=0.13u
.ends

.subckt sg13cmos5l_tielo L_LO VDD VSS
X0 L_LO a_223_58# VSS VSS sg13_lv_nmos ad=0.2992p pd=2.44u as=0.60422p ps=3.6u w=0.88u l=0.13u
X1 VDD a_59_418# a_59_418# VDD sg13_lv_pmos ad=0.62572p pd=3.785u as=0.102p ps=1.28u w=0.3u l=0.13u
X2 a_223_58# a_59_195# VDD VDD sg13_lv_pmos ad=0.3553p pd=2.77u as=0.62572p ps=3.785u w=1.045u l=0.13u
X3 VSS a_59_418# a_59_195# VSS sg13_lv_nmos ad=0.60422p pd=3.6u as=0.1309p ps=1.45u w=0.385u l=0.13u
.ends

.subckt sg13cmos5l_decap_4 VDD VSS
X0 VDD VSS VDD VDD sg13_lv_pmos ad=0.34p pd=2.68u as=0 ps=0 w=1u l=1u
X1 VSS VDD VSS VSS sg13_lv_nmos ad=0.1428p pd=1.52u as=0 ps=0 w=0.42u l=1u
.ends

.subckt sg13cmos5l_buf_8 X A VDD VSS
X0 VSS A a_27_118# VSS sg13_lv_nmos ad=0.1406p pd=1.12u as=0.1406p ps=1.12u w=0.74u l=0.13u
X1 VSS A a_27_118# VSS sg13_lv_nmos ad=0.1406p pd=1.12u as=0.2553p ps=2.17u w=0.74u l=0.13u
X2 VDD A a_27_118# VDD sg13_lv_pmos ad=0.2128p pd=1.5u as=0.2128p ps=1.5u w=1.12u l=0.13u
X3 X a_27_118# VSS VSS sg13_lv_nmos ad=0.1406p pd=1.12u as=0.1406p ps=1.12u w=0.74u l=0.13u
X4 VDD A a_27_118# VDD sg13_lv_pmos ad=0.2128p pd=1.5u as=0.3808p ps=2.92u w=1.12u l=0.13u
X5 X a_27_118# VDD VDD sg13_lv_pmos ad=0.2128p pd=1.5u as=0.2128p ps=1.5u w=1.12u l=0.13u
X6 VSS a_27_118# X VSS sg13_lv_nmos ad=0.1406p pd=1.12u as=0.1406p ps=1.12u w=0.74u l=0.13u
X7 VDD a_27_118# X VDD sg13_lv_pmos ad=0.2128p pd=1.5u as=0.2128p ps=1.5u w=1.12u l=0.13u
X8 X a_27_118# VSS VSS sg13_lv_nmos ad=0.1406p pd=1.12u as=0.1406p ps=1.12u w=0.74u l=0.13u
X9 X a_27_118# VDD VDD sg13_lv_pmos ad=0.2128p pd=1.5u as=0.2128p ps=1.5u w=1.12u l=0.13u
X10 VSS a_27_118# X VSS sg13_lv_nmos ad=0.1406p pd=1.12u as=0.1406p ps=1.12u w=0.74u l=0.13u
X11 X a_27_118# VSS VSS sg13_lv_nmos ad=0.1406p pd=1.12u as=0.1406p ps=1.12u w=0.74u l=0.13u
X12 VDD a_27_118# X VDD sg13_lv_pmos ad=0.2128p pd=1.5u as=0.2128p ps=1.5u w=1.12u l=0.13u
X13 X a_27_118# VDD VDD sg13_lv_pmos ad=0.2128p pd=1.5u as=0.2128p ps=1.5u w=1.12u l=0.13u
X14 VSS a_27_118# X VSS sg13_lv_nmos ad=0.1406p pd=1.12u as=0.1406p ps=1.12u w=0.74u l=0.13u
X15 VDD a_27_118# X VDD sg13_lv_pmos ad=0.2128p pd=1.5u as=0.2128p ps=1.5u w=1.12u l=0.13u
X16 X a_27_118# VSS VSS sg13_lv_nmos ad=0.1406p pd=1.12u as=0.1406p ps=1.12u w=0.74u l=0.13u
X17 VSS a_27_118# X VSS sg13_lv_nmos ad=0.2516p pd=2.16u as=0.1406p ps=1.12u w=0.74u l=0.13u
X18 X a_27_118# VDD VDD sg13_lv_pmos ad=0.2128p pd=1.5u as=0.2128p ps=1.5u w=1.12u l=0.13u
X19 VDD a_27_118# X VDD sg13_lv_pmos ad=0.3864p pd=2.93u as=0.2128p ps=1.5u w=1.12u l=0.13u
X20 a_27_118# A VSS VSS sg13_lv_nmos ad=0.1406p pd=1.12u as=0.1406p ps=1.12u w=0.74u l=0.13u
X21 a_27_118# A VDD VDD sg13_lv_pmos ad=0.2128p pd=1.5u as=0.2128p ps=1.5u w=1.12u l=0.13u
.ends

.subckt constant_block one zero vdd vss
Xsg13cmos5l_tiehi_0 sg13cmos5l_buf_8_0/A vdd vss sg13cmos5l_tiehi
Xsg13cmos5l_tielo_0 sg13cmos5l_buf_8_1/A vdd vss sg13cmos5l_tielo
Xsg13cmos5l_decap_4_0 vdd vss sg13cmos5l_decap_4
Xsg13cmos5l_decap_4_1 vdd vss sg13cmos5l_decap_4
Xsg13cmos5l_decap_4_2 vdd vss sg13cmos5l_decap_4
Xsg13cmos5l_buf_8_0 one sg13cmos5l_buf_8_0/A vdd vss sg13cmos5l_buf_8
Xsg13cmos5l_decap_4_3 vdd vss sg13cmos5l_decap_4
Xsg13cmos5l_buf_8_1 zero sg13cmos5l_buf_8_1/A vdd vss sg13cmos5l_buf_8
.ends

.subckt constant_block_vrouted vdd zero one vss
Xconstant_block_0 one zero vdd vss constant_block
.ends

.subckt constant_block_hrouted vdd zero one vss
Xconstant_block_0 one zero vdd vss constant_block
.ends

.subckt sg13cmos5l_IOPadIOVss vss vdd iovdd sg13cmos5l_DCNDiode_0/guard
Xsg13cmos5l_DCPDiode_0 vss iovdd vss vss sg13cmos5l_DCPDiode
Xsg13cmos5l_DCNDiode_0 vss vss sg13cmos5l_DCNDiode_0/guard vss sg13cmos5l_DCNDiode
.ends

.subckt sg13cmos5l_Clamp_P20N0D iovss iovdd pad pad_uq0 pad_uq1 pad_uq2 pad_uq3 pad_uq4
+ pad_uq5 pad_uq6 pad_uq7 pad_uq8
X0 iovdd a_5044_476# pad_uq3 iovdd sg13_hv_pmos ad=2.1312p pd=7.3u as=3.9294p ps=7.84u w=6.66u l=0.6u
X1 pad_uq5 a_5044_476# iovdd iovdd sg13_hv_pmos ad=3.9294p pd=7.84u as=2.1312p ps=7.3u w=6.66u l=0.6u
X2 iovdd a_5044_476# pad_uq1 iovdd sg13_hv_pmos ad=2.1312p pd=7.3u as=3.9294p ps=7.84u w=6.66u l=0.6u
X3 pad_uq7 a_5044_476# iovdd iovdd sg13_hv_pmos ad=3.9294p pd=7.84u as=2.1312p ps=7.3u w=6.66u l=0.6u
X4 pad_uq6 a_5044_476# iovdd iovdd sg13_hv_pmos ad=3.9294p pd=7.84u as=2.1312p ps=7.3u w=6.66u l=0.6u
X5 iovdd a_5044_476# pad_uq2 iovdd sg13_hv_pmos ad=2.1312p pd=7.3u as=3.9294p ps=7.84u w=6.66u l=0.6u
X6 a_5044_476# iovdd iovdd rppd l=12.9u w=0.5u
X7 pad_uq6 a_5044_476# iovdd iovdd sg13_hv_pmos ad=3.9294p pd=7.84u as=2.1312p ps=7.3u w=6.66u l=0.6u
X8 iovdd a_5044_476# pad_uq6 iovdd sg13_hv_pmos ad=2.1312p pd=7.3u as=3.9294p ps=7.84u w=6.66u l=0.6u
X9 pad_uq2 a_5044_476# iovdd iovdd sg13_hv_pmos ad=3.9294p pd=7.84u as=2.1312p ps=7.3u w=6.66u l=0.6u
X10 iovdd a_5044_476# pad iovdd sg13_hv_pmos ad=2.1312p pd=7.3u as=3.9294p ps=7.84u w=6.66u l=0.6u
X11 iovdd a_5044_476# pad_uq6 iovdd sg13_hv_pmos ad=2.1312p pd=7.3u as=3.9294p ps=7.84u w=6.66u l=0.6u
X12 pad_uq2 a_5044_476# iovdd iovdd sg13_hv_pmos ad=3.9294p pd=7.84u as=2.1312p ps=7.3u w=6.66u l=0.6u
X13 iovdd a_5044_476# pad_uq5 iovdd sg13_hv_pmos ad=2.1312p pd=7.3u as=3.9294p ps=7.84u w=6.66u l=0.6u
X14 iovdd a_5044_476# pad_uq1 iovdd sg13_hv_pmos ad=2.1312p pd=7.3u as=3.9294p ps=7.84u w=6.66u l=0.6u
X15 pad_uq3 a_5044_476# iovdd iovdd sg13_hv_pmos ad=3.9294p pd=7.84u as=2.1312p ps=7.3u w=6.66u l=0.6u
X16 pad_uq1 a_5044_476# iovdd iovdd sg13_hv_pmos ad=3.9294p pd=7.84u as=2.1312p ps=7.3u w=6.66u l=0.6u
X17 iovdd a_5044_476# pad_uq7 iovdd sg13_hv_pmos ad=2.1312p pd=7.3u as=3.9294p ps=7.84u w=6.66u l=0.6u
X18 pad_uq0 a_5044_476# iovdd iovdd sg13_hv_pmos ad=3.9294p pd=7.84u as=2.1312p ps=7.3u w=6.66u l=0.6u
X19 iovdd a_5044_476# pad_uq3 iovdd sg13_hv_pmos ad=2.1312p pd=7.3u as=3.9294p ps=7.84u w=6.66u l=0.6u
X20 pad_uq7 a_5044_476# iovdd iovdd sg13_hv_pmos ad=3.9294p pd=7.84u as=2.1312p ps=7.3u w=6.66u l=0.6u
X21 iovdd a_5044_476# pad_uq0 iovdd sg13_hv_pmos ad=3.1302p pd=14.26u as=3.9294p ps=7.84u w=6.66u l=0.6u
X22 pad_uq8 a_5044_476# iovdd iovdd sg13_hv_pmos ad=3.9294p pd=7.84u as=3.1302p ps=14.26u w=6.66u l=0.6u
X23 pad_uq8 a_5044_476# iovdd iovdd sg13_hv_pmos ad=3.9294p pd=7.84u as=3.1302p ps=14.26u w=6.66u l=0.6u
X24 iovdd a_5044_476# pad iovdd sg13_hv_pmos ad=2.1312p pd=7.3u as=3.9294p ps=7.84u w=6.66u l=0.6u
X25 pad_uq4 a_5044_476# iovdd iovdd sg13_hv_pmos ad=3.9294p pd=7.84u as=2.1312p ps=7.3u w=6.66u l=0.6u
X26 iovdd a_5044_476# pad_uq7 iovdd sg13_hv_pmos ad=2.1312p pd=7.3u as=3.9294p ps=7.84u w=6.66u l=0.6u
X27 pad_uq3 a_5044_476# iovdd iovdd sg13_hv_pmos ad=3.9294p pd=7.84u as=2.1312p ps=7.3u w=6.66u l=0.6u
X28 iovdd a_5044_476# pad_uq8 iovdd sg13_hv_pmos ad=2.1312p pd=7.3u as=3.9294p ps=7.84u w=6.66u l=0.6u
X29 pad_uq5 a_5044_476# iovdd iovdd sg13_hv_pmos ad=3.9294p pd=7.84u as=2.1312p ps=7.3u w=6.66u l=0.6u
X30 pad_uq0 a_5044_476# iovdd iovdd sg13_hv_pmos ad=3.9294p pd=7.84u as=2.1312p ps=7.3u w=6.66u l=0.6u
X31 iovdd a_5044_476# pad_uq0 iovdd sg13_hv_pmos ad=3.1302p pd=14.26u as=3.9294p ps=7.84u w=6.66u l=0.6u
X32 pad a_5044_476# iovdd iovdd sg13_hv_pmos ad=3.9294p pd=7.84u as=2.1312p ps=7.3u w=6.66u l=0.6u
X33 iovdd a_5044_476# pad_uq8 iovdd sg13_hv_pmos ad=2.1312p pd=7.3u as=3.9294p ps=7.84u w=6.66u l=0.6u
X34 iovdd a_5044_476# pad_uq4 iovdd sg13_hv_pmos ad=2.1312p pd=7.3u as=3.9294p ps=7.84u w=6.66u l=0.6u
X35 iovdd a_5044_476# pad_uq2 iovdd sg13_hv_pmos ad=2.1312p pd=7.3u as=3.9294p ps=7.84u w=6.66u l=0.6u
X36 iovdd a_5044_476# pad_uq4 iovdd sg13_hv_pmos ad=2.1312p pd=7.3u as=3.9294p ps=7.84u w=6.66u l=0.6u
X37 pad_uq4 a_5044_476# iovdd iovdd sg13_hv_pmos ad=3.9294p pd=7.84u as=2.1312p ps=7.3u w=6.66u l=0.6u
X38 pad a_5044_476# iovdd iovdd sg13_hv_pmos ad=3.9294p pd=7.84u as=2.1312p ps=7.3u w=6.66u l=0.6u
X39 iovdd a_5044_476# pad_uq5 iovdd sg13_hv_pmos ad=2.1312p pd=7.3u as=3.9294p ps=7.84u w=6.66u l=0.6u
X40 pad_uq1 a_5044_476# iovdd iovdd sg13_hv_pmos ad=3.9294p pd=7.84u as=2.1312p ps=7.3u w=6.66u l=0.6u
.ends

.subckt sg13cmos5l_Clamp_N20N0D iovss pad pad_uq0 pad_uq1 pad_uq2 pad_uq3 pad_uq4
+ pad_uq5 pad_uq6 pad_uq7 pad_uq8 w_n124_n124#
X0 pad_uq5 a_5044_476# iovss iovss sg13_hv_nmos ad=2.596p pd=5.58u as=1.408p ps=5.04u w=4.4u l=0.6u
X1 iovss a_5044_476# pad_uq1 iovss sg13_hv_nmos ad=1.408p pd=5.04u as=2.596p ps=5.58u w=4.4u l=0.6u
X2 pad_uq6 a_5044_476# iovss iovss sg13_hv_nmos ad=2.596p pd=5.58u as=1.408p ps=5.04u w=4.4u l=0.6u
X3 iovss a_5044_476# pad_uq2 iovss sg13_hv_nmos ad=1.408p pd=5.04u as=2.596p ps=5.58u w=4.4u l=0.6u
X4 a_5044_476# iovss iovss rppd l=3.54u w=0.5u
X5 iovss a_5044_476# pad_uq6 iovss sg13_hv_nmos ad=1.408p pd=5.04u as=2.596p ps=5.58u w=4.4u l=0.6u
X6 pad_uq2 a_5044_476# iovss iovss sg13_hv_nmos ad=2.596p pd=5.58u as=1.408p ps=5.04u w=4.4u l=0.6u
X7 pad_uq3 a_5044_476# iovss iovss sg13_hv_nmos ad=2.596p pd=5.58u as=1.408p ps=5.04u w=4.4u l=0.6u
X8 iovss a_5044_476# pad_uq7 iovss sg13_hv_nmos ad=1.408p pd=5.04u as=2.596p ps=5.58u w=4.4u l=0.6u
X9 pad_uq0 a_5044_476# iovss iovss sg13_hv_nmos ad=2.596p pd=5.58u as=1.408p ps=5.04u w=4.4u l=0.6u
X10 iovss a_5044_476# pad_uq3 iovss sg13_hv_nmos ad=1.408p pd=5.04u as=2.596p ps=5.58u w=4.4u l=0.6u
X11 pad_uq7 a_5044_476# iovss iovss sg13_hv_nmos ad=2.596p pd=5.58u as=1.408p ps=5.04u w=4.4u l=0.6u
X12 iovss a_5044_476# pad_uq0 iovss sg13_hv_nmos ad=2.068p pd=9.74u as=2.596p ps=5.58u w=4.4u l=0.6u
X13 pad_uq8 a_5044_476# iovss iovss sg13_hv_nmos ad=2.596p pd=5.58u as=2.068p ps=9.74u w=4.4u l=0.6u
X14 iovss a_5044_476# pad iovss sg13_hv_nmos ad=1.408p pd=5.04u as=2.596p ps=5.58u w=4.4u l=0.6u
X15 pad_uq4 a_5044_476# iovss iovss sg13_hv_nmos ad=2.596p pd=5.58u as=1.408p ps=5.04u w=4.4u l=0.6u
X16 iovss a_5044_476# pad_uq8 iovss sg13_hv_nmos ad=1.408p pd=5.04u as=2.596p ps=5.58u w=4.4u l=0.6u
X17 pad a_5044_476# iovss iovss sg13_hv_nmos ad=2.596p pd=5.58u as=1.408p ps=5.04u w=4.4u l=0.6u
X18 iovss a_5044_476# pad_uq4 iovss sg13_hv_nmos ad=1.408p pd=5.04u as=2.596p ps=5.58u w=4.4u l=0.6u
X19 iovss a_5044_476# pad_uq5 iovss sg13_hv_nmos ad=1.408p pd=5.04u as=2.596p ps=5.58u w=4.4u l=0.6u
X20 pad_uq1 a_5044_476# iovss iovss sg13_hv_nmos ad=2.596p pd=5.58u as=1.408p ps=5.04u w=4.4u l=0.6u
.ends

.subckt sg13cmos5l_IOPadAnalog vdd iovss iovdd pad padres iovdd_uq0 sg13cmos5l_DCNDiode_0/guard
+ vss
Xsg13cmos5l_SecondaryProtection_0 iovdd vss pad padres sg13cmos5l_SecondaryProtection
Xsg13cmos5l_DCPDiode_0 pad iovdd_uq0 vss pad sg13cmos5l_DCPDiode
Xsg13cmos5l_Clamp_P20N0D_0 vss iovdd_uq0 pad pad pad pad pad pad pad pad pad pad sg13cmos5l_Clamp_P20N0D
Xsg13cmos5l_DCNDiode_0 vss pad sg13cmos5l_DCNDiode_0/guard pad sg13cmos5l_DCNDiode
Xsg13cmos5l_Clamp_N20N0D_0 vss pad pad pad pad pad pad pad pad pad pad sg13cmos5l_DCNDiode_0/guard
+ sg13cmos5l_Clamp_N20N0D
.ends

.subckt sg13cmos5l_Clamp_N43N43D4R iovss pad gate pad_uq0 pad_uq1 pad_uq2 pad_uq3
+ pad_uq4 pad_uq5 pad_uq6 pad_uq7 pad_uq8 pad_uq9 pad_uq10 pad_uq11 pad_uq12 pad_uq13
+ pad_uq14 pad_uq15 pad_uq16 pad_uq17 pad_uq18 pad_uq19 pad_uq20 w_n124_n124#
X0 iovss gate pad_uq1 iovss sg13_hv_nmos ad=1.408p pd=5.04u as=2.596p ps=5.58u w=4.4u l=0.6u
X1 iovss gate pad_uq19 iovss sg13_hv_nmos ad=1.408p pd=5.04u as=2.596p ps=5.58u w=4.4u l=0.6u
X2 iovss gate pad_uq15 iovss sg13_hv_nmos ad=1.408p pd=5.04u as=2.596p ps=5.58u w=4.4u l=0.6u
X3 iovss gate pad_uq13 iovss sg13_hv_nmos ad=1.408p pd=5.04u as=2.596p ps=5.58u w=4.4u l=0.6u
X4 pad_uq17 gate iovss iovss sg13_hv_nmos ad=2.596p pd=5.58u as=1.408p ps=5.04u w=4.4u l=0.6u
X5 pad_uq15 gate iovss iovss sg13_hv_nmos ad=2.596p pd=5.58u as=1.408p ps=5.04u w=4.4u l=0.6u
X6 pad_uq0 gate iovss iovss sg13_hv_nmos ad=3.256p pd=10.28u as=1.408p ps=5.04u w=4.4u l=0.6u
X7 pad_uq12 gate iovss iovss sg13_hv_nmos ad=2.596p pd=5.58u as=1.408p ps=5.04u w=4.4u l=0.6u
X8 pad_uq5 gate iovss iovss sg13_hv_nmos ad=2.596p pd=5.58u as=1.408p ps=5.04u w=4.4u l=0.6u
X9 iovss gate pad_uq16 iovss sg13_hv_nmos ad=1.408p pd=5.04u as=2.596p ps=5.58u w=4.4u l=0.6u
X10 iovss gate pad_uq12 iovss sg13_hv_nmos ad=1.408p pd=5.04u as=2.596p ps=5.58u w=4.4u l=0.6u
X11 iovss gate pad_uq3 iovss sg13_hv_nmos ad=1.408p pd=5.04u as=2.596p ps=5.58u w=4.4u l=0.6u
X12 iovss gate pad_uq18 iovss sg13_hv_nmos ad=1.408p pd=5.04u as=2.596p ps=5.58u w=4.4u l=0.6u
X13 pad_uq6 gate iovss iovss sg13_hv_nmos ad=2.596p pd=5.58u as=1.408p ps=5.04u w=4.4u l=0.6u
X14 pad gate iovss iovss sg13_hv_nmos ad=2.596p pd=5.58u as=1.408p ps=5.04u w=4.4u l=0.6u
X15 iovss gate pad_uq5 iovss sg13_hv_nmos ad=1.408p pd=5.04u as=2.596p ps=5.58u w=4.4u l=0.6u
X16 iovss gate pad_uq20 iovss sg13_hv_nmos ad=1.408p pd=5.04u as=2.596p ps=5.58u w=4.4u l=0.6u
X17 pad_uq14 gate iovss iovss sg13_hv_nmos ad=2.596p pd=5.58u as=1.408p ps=5.04u w=4.4u l=0.6u
X18 pad_uq20 gate iovss iovss sg13_hv_nmos ad=2.596p pd=5.58u as=2.068p ps=9.74u w=4.4u l=0.6u
X19 pad_uq10 gate iovss iovss sg13_hv_nmos ad=2.596p pd=5.58u as=1.408p ps=5.04u w=4.4u l=0.6u
X20 iovss gate pad_uq9 iovss sg13_hv_nmos ad=1.408p pd=5.04u as=2.596p ps=5.58u w=4.4u l=0.6u
X21 pad_uq16 gate iovss iovss sg13_hv_nmos ad=2.596p pd=5.58u as=1.408p ps=5.04u w=4.4u l=0.6u
X22 iovss gate pad_uq8 iovss sg13_hv_nmos ad=1.408p pd=5.04u as=2.596p ps=5.58u w=4.4u l=0.6u
X23 iovss gate pad_uq6 iovss sg13_hv_nmos ad=1.408p pd=5.04u as=2.596p ps=5.58u w=4.4u l=0.6u
X24 iovss gate pad_uq14 iovss sg13_hv_nmos ad=1.408p pd=5.04u as=2.596p ps=5.58u w=4.4u l=0.6u
X25 pad_uq11 gate iovss iovss sg13_hv_nmos ad=2.596p pd=5.58u as=1.408p ps=5.04u w=4.4u l=0.6u
X26 iovss gate pad_uq2 iovss sg13_hv_nmos ad=1.408p pd=5.04u as=2.596p ps=5.58u w=4.4u l=0.6u
X27 iovss gate pad_uq10 iovss sg13_hv_nmos ad=1.408p pd=5.04u as=2.596p ps=5.58u w=4.4u l=0.6u
X28 pad_uq13 gate iovss iovss sg13_hv_nmos ad=2.596p pd=5.58u as=1.408p ps=5.04u w=4.4u l=0.6u
X29 pad_uq8 gate iovss iovss sg13_hv_nmos ad=2.596p pd=5.58u as=1.408p ps=5.04u w=4.4u l=0.6u
X30 pad gate iovss iovss sg13_hv_nmos ad=2.596p pd=5.58u as=1.408p ps=5.04u w=4.4u l=0.6u
X31 iovss gate pad_uq17 iovss sg13_hv_nmos ad=1.408p pd=5.04u as=2.596p ps=5.58u w=4.4u l=0.6u
X32 iovss gate pad_uq11 iovss sg13_hv_nmos ad=1.408p pd=5.04u as=2.596p ps=5.58u w=4.4u l=0.6u
X33 iovss gate pad_uq13 iovss sg13_hv_nmos ad=1.408p pd=5.04u as=2.596p ps=5.58u w=4.4u l=0.6u
X34 iovss gate pad_uq7 iovss sg13_hv_nmos ad=1.408p pd=5.04u as=2.596p ps=5.58u w=4.4u l=0.6u
X35 pad_uq1 gate iovss iovss sg13_hv_nmos ad=2.596p pd=5.58u as=1.408p ps=5.04u w=4.4u l=0.6u
X36 pad_uq1 gate iovss iovss sg13_hv_nmos ad=2.596p pd=5.58u as=1.408p ps=5.04u w=4.4u l=0.6u
X37 iovss gate pad_uq4 iovss sg13_hv_nmos ad=1.408p pd=5.04u as=2.596p ps=5.58u w=4.4u l=0.6u
X38 iovss gate pad_uq19 iovss sg13_hv_nmos ad=1.408p pd=5.04u as=2.596p ps=5.58u w=4.4u l=0.6u
X39 iovss gate pad_uq5 iovss sg13_hv_nmos ad=1.408p pd=5.04u as=2.596p ps=5.58u w=4.4u l=0.6u
X40 iovss gate pad_uq15 iovss sg13_hv_nmos ad=1.408p pd=5.04u as=2.596p ps=5.58u w=4.4u l=0.6u
X41 pad_uq3 gate iovss iovss sg13_hv_nmos ad=2.596p pd=5.58u as=1.408p ps=5.04u w=4.4u l=0.6u
X42 pad_uq15 gate iovss iovss sg13_hv_nmos ad=2.596p pd=5.58u as=1.408p ps=5.04u w=4.4u l=0.6u
X43 pad_uq14 gate iovss iovss sg13_hv_nmos ad=2.596p pd=5.58u as=1.408p ps=5.04u w=4.4u l=0.6u
X44 pad_uq9 gate iovss iovss sg13_hv_nmos ad=2.596p pd=5.58u as=1.408p ps=5.04u w=4.4u l=0.6u
X45 iovss gate pad_uq18 iovss sg13_hv_nmos ad=1.408p pd=5.04u as=2.596p ps=5.58u w=4.4u l=0.6u
X46 pad_uq4 gate iovss iovss sg13_hv_nmos ad=2.596p pd=5.58u as=1.408p ps=5.04u w=4.4u l=0.6u
X47 iovss gate pad_uq3 iovss sg13_hv_nmos ad=1.408p pd=5.04u as=2.596p ps=5.58u w=4.4u l=0.6u
X48 iovss gate pad_uq9 iovss sg13_hv_nmos ad=1.408p pd=5.04u as=2.596p ps=5.58u w=4.4u l=0.6u
X49 pad_uq6 gate iovss iovss sg13_hv_nmos ad=2.596p pd=5.58u as=1.408p ps=5.04u w=4.4u l=0.6u
X50 pad_uq18 gate iovss iovss sg13_hv_nmos ad=2.596p pd=5.58u as=1.408p ps=5.04u w=4.4u l=0.6u
X51 pad_uq12 gate iovss iovss sg13_hv_nmos ad=2.596p pd=5.58u as=1.408p ps=5.04u w=4.4u l=0.6u
X52 pad_uq8 gate iovss iovss sg13_hv_nmos ad=2.596p pd=5.58u as=1.408p ps=5.04u w=4.4u l=0.6u
X53 iovss gate pad_uq5 iovss sg13_hv_nmos ad=1.408p pd=5.04u as=2.596p ps=5.58u w=4.4u l=0.6u
X54 iovss gate pad_uq6 iovss sg13_hv_nmos ad=1.408p pd=5.04u as=2.596p ps=5.58u w=4.4u l=0.6u
X55 iovss gate pad iovss sg13_hv_nmos ad=1.408p pd=5.04u as=2.596p ps=5.58u w=4.4u l=0.6u
X56 iovss gate pad_uq1 iovss sg13_hv_nmos ad=1.408p pd=5.04u as=2.596p ps=5.58u w=4.4u l=0.6u
X57 pad_uq19 gate iovss iovss sg13_hv_nmos ad=2.596p pd=5.58u as=1.408p ps=5.04u w=4.4u l=0.6u
X58 pad_uq5 gate iovss iovss sg13_hv_nmos ad=2.596p pd=5.58u as=1.408p ps=5.04u w=4.4u l=0.6u
X59 pad_uq9 gate iovss iovss sg13_hv_nmos ad=2.596p pd=5.58u as=1.408p ps=5.04u w=4.4u l=0.6u
X60 iovss gate pad_uq8 iovss sg13_hv_nmos ad=1.408p pd=5.04u as=2.596p ps=5.58u w=4.4u l=0.6u
X61 pad_uq11 gate iovss iovss sg13_hv_nmos ad=2.596p pd=5.58u as=1.408p ps=5.04u w=4.4u l=0.6u
X62 iovss gate pad_uq14 iovss sg13_hv_nmos ad=1.408p pd=5.04u as=2.596p ps=5.58u w=4.4u l=0.6u
X63 pad_uq2 gate iovss iovss sg13_hv_nmos ad=2.596p pd=5.58u as=1.408p ps=5.04u w=4.4u l=0.6u
X64 iovss gate pad_uq10 iovss sg13_hv_nmos ad=1.408p pd=5.04u as=2.596p ps=5.58u w=4.4u l=0.6u
X65 iovss gate pad_uq14 iovss sg13_hv_nmos ad=1.408p pd=5.04u as=2.596p ps=5.58u w=4.4u l=0.6u
X66 iovss gate pad_uq17 iovss sg13_hv_nmos ad=1.408p pd=5.04u as=2.596p ps=5.58u w=4.4u l=0.6u
X67 pad_uq17 gate iovss iovss sg13_hv_nmos ad=2.596p pd=5.58u as=1.408p ps=5.04u w=4.4u l=0.6u
X68 pad_uq0 gate iovss iovss sg13_hv_nmos ad=3.256p pd=10.28u as=1.408p ps=5.04u w=4.4u l=0.6u
X69 pad_uq7 gate iovss iovss sg13_hv_nmos ad=2.596p pd=5.58u as=1.408p ps=5.04u w=4.4u l=0.6u
X70 pad_uq18 gate iovss iovss sg13_hv_nmos ad=2.596p pd=5.58u as=1.408p ps=5.04u w=4.4u l=0.6u
X71 pad_uq5 gate iovss iovss sg13_hv_nmos ad=2.596p pd=5.58u as=1.408p ps=5.04u w=4.4u l=0.6u
X72 iovss gate pad_uq4 iovss sg13_hv_nmos ad=1.408p pd=5.04u as=2.596p ps=5.58u w=4.4u l=0.6u
X73 pad_uq1 gate iovss iovss sg13_hv_nmos ad=2.596p pd=5.58u as=1.408p ps=5.04u w=4.4u l=0.6u
X74 pad_uq13 gate iovss iovss sg13_hv_nmos ad=2.596p pd=5.58u as=1.408p ps=5.04u w=4.4u l=0.6u
X75 iovss gate pad_uq18 iovss sg13_hv_nmos ad=1.408p pd=5.04u as=2.596p ps=5.58u w=4.4u l=0.6u
X76 pad_uq3 gate iovss iovss sg13_hv_nmos ad=2.596p pd=5.58u as=1.408p ps=5.04u w=4.4u l=0.6u
X77 iovss gate pad_uq2 iovss sg13_hv_nmos ad=1.408p pd=5.04u as=2.596p ps=5.58u w=4.4u l=0.6u
X78 pad_uq14 gate iovss iovss sg13_hv_nmos ad=2.596p pd=5.58u as=1.408p ps=5.04u w=4.4u l=0.6u
X79 pad_uq6 gate iovss iovss sg13_hv_nmos ad=2.596p pd=5.58u as=1.408p ps=5.04u w=4.4u l=0.6u
X80 iovss gate pad_uq20 iovss sg13_hv_nmos ad=1.408p pd=5.04u as=2.596p ps=5.58u w=4.4u l=0.6u
X81 iovss gate pad_uq1 iovss sg13_hv_nmos ad=1.408p pd=5.04u as=2.596p ps=5.58u w=4.4u l=0.6u
X82 pad_uq20 gate iovss iovss sg13_hv_nmos ad=2.596p pd=5.58u as=2.068p ps=9.74u w=4.4u l=0.6u
X83 pad_uq10 gate iovss iovss sg13_hv_nmos ad=2.596p pd=5.58u as=1.408p ps=5.04u w=4.4u l=0.6u
X84 iovss gate pad_uq9 iovss sg13_hv_nmos ad=1.408p pd=5.04u as=2.596p ps=5.58u w=4.4u l=0.6u
X85 pad_uq16 gate iovss iovss sg13_hv_nmos ad=2.596p pd=5.58u as=1.408p ps=5.04u w=4.4u l=0.6u
X86 pad_uq12 gate iovss iovss sg13_hv_nmos ad=2.596p pd=5.58u as=1.408p ps=5.04u w=4.4u l=0.6u
X87 pad_uq19 gate iovss iovss sg13_hv_nmos ad=2.596p pd=5.58u as=1.408p ps=5.04u w=4.4u l=0.6u
X88 pad_uq18 gate iovss iovss sg13_hv_nmos ad=2.596p pd=5.58u as=1.408p ps=5.04u w=4.4u l=0.6u
X89 iovss gate pad_uq10 iovss sg13_hv_nmos ad=1.408p pd=5.04u as=2.596p ps=5.58u w=4.4u l=0.6u
X90 pad_uq8 gate iovss iovss sg13_hv_nmos ad=2.596p pd=5.58u as=1.408p ps=5.04u w=4.4u l=0.6u
X91 iovss gate pad_uq16 iovss sg13_hv_nmos ad=1.408p pd=5.04u as=2.596p ps=5.58u w=4.4u l=0.6u
X92 iovss gate pad iovss sg13_hv_nmos ad=1.408p pd=5.04u as=2.596p ps=5.58u w=4.4u l=0.6u
X93 iovss gate pad_uq12 iovss sg13_hv_nmos ad=1.408p pd=5.04u as=2.596p ps=5.58u w=4.4u l=0.6u
X94 iovss gate pad_uq3 iovss sg13_hv_nmos ad=1.408p pd=5.04u as=2.596p ps=5.58u w=4.4u l=0.6u
X95 pad_uq2 gate iovss iovss sg13_hv_nmos ad=2.596p pd=5.58u as=1.408p ps=5.04u w=4.4u l=0.6u
X96 pad gate iovss iovss sg13_hv_nmos ad=2.596p pd=5.58u as=1.408p ps=5.04u w=4.4u l=0.6u
X97 pad_uq2 gate iovss iovss sg13_hv_nmos ad=2.596p pd=5.58u as=1.408p ps=5.04u w=4.4u l=0.6u
X98 iovss gate pad_uq13 iovss sg13_hv_nmos ad=1.408p pd=5.04u as=2.596p ps=5.58u w=4.4u l=0.6u
X99 iovss gate pad_uq11 iovss sg13_hv_nmos ad=1.408p pd=5.04u as=2.596p ps=5.58u w=4.4u l=0.6u
X100 iovss gate pad_uq19 iovss sg13_hv_nmos ad=1.408p pd=5.04u as=2.596p ps=5.58u w=4.4u l=0.6u
X101 iovss gate pad_uq6 iovss sg13_hv_nmos ad=1.408p pd=5.04u as=2.596p ps=5.58u w=4.4u l=0.6u
X102 pad_uq15 gate iovss iovss sg13_hv_nmos ad=2.596p pd=5.58u as=1.408p ps=5.04u w=4.4u l=0.6u
X103 iovss gate pad_uq15 iovss sg13_hv_nmos ad=1.408p pd=5.04u as=2.596p ps=5.58u w=4.4u l=0.6u
X104 iovss gate pad_uq2 iovss sg13_hv_nmos ad=1.408p pd=5.04u as=2.596p ps=5.58u w=4.4u l=0.6u
X105 iovss gate pad_uq17 iovss sg13_hv_nmos ad=1.408p pd=5.04u as=2.596p ps=5.58u w=4.4u l=0.6u
X106 pad_uq10 gate iovss iovss sg13_hv_nmos ad=2.596p pd=5.58u as=1.408p ps=5.04u w=4.4u l=0.6u
X107 pad_uq15 gate iovss iovss sg13_hv_nmos ad=2.596p pd=5.58u as=1.408p ps=5.04u w=4.4u l=0.6u
X108 iovss gate pad_uq19 iovss sg13_hv_nmos ad=1.408p pd=5.04u as=2.596p ps=5.58u w=4.4u l=0.6u
X109 pad_uq17 gate iovss iovss sg13_hv_nmos ad=2.596p pd=5.58u as=1.408p ps=5.04u w=4.4u l=0.6u
X110 pad_uq13 gate iovss iovss sg13_hv_nmos ad=2.596p pd=5.58u as=1.408p ps=5.04u w=4.4u l=0.6u
X111 pad_uq7 gate iovss iovss sg13_hv_nmos ad=2.596p pd=5.58u as=1.408p ps=5.04u w=4.4u l=0.6u
X112 iovss gate pad_uq3 iovss sg13_hv_nmos ad=1.408p pd=5.04u as=2.596p ps=5.58u w=4.4u l=0.6u
X113 iovss gate pad_uq11 iovss sg13_hv_nmos ad=1.408p pd=5.04u as=2.596p ps=5.58u w=4.4u l=0.6u
X114 pad_uq6 gate iovss iovss sg13_hv_nmos ad=2.596p pd=5.58u as=1.408p ps=5.04u w=4.4u l=0.6u
X115 iovss gate dantenna l=0.48u w=0.48u
X116 iovss gate pad_uq7 iovss sg13_hv_nmos ad=1.408p pd=5.04u as=2.596p ps=5.58u w=4.4u l=0.6u
X117 iovss gate pad_uq5 iovss sg13_hv_nmos ad=1.408p pd=5.04u as=2.596p ps=5.58u w=4.4u l=0.6u
X118 iovss gate pad_uq1 iovss sg13_hv_nmos ad=1.408p pd=5.04u as=2.596p ps=5.58u w=4.4u l=0.6u
X119 iovss gate pad_uq8 iovss sg13_hv_nmos ad=1.408p pd=5.04u as=2.596p ps=5.58u w=4.4u l=0.6u
X120 pad_uq11 gate iovss iovss sg13_hv_nmos ad=2.596p pd=5.58u as=1.408p ps=5.04u w=4.4u l=0.6u
X121 iovss gate pad_uq14 iovss sg13_hv_nmos ad=1.408p pd=5.04u as=2.596p ps=5.58u w=4.4u l=0.6u
X122 iovss gate pad_uq7 iovss sg13_hv_nmos ad=1.408p pd=5.04u as=2.596p ps=5.58u w=4.4u l=0.6u
X123 iovss gate pad_uq16 iovss sg13_hv_nmos ad=1.408p pd=5.04u as=2.596p ps=5.58u w=4.4u l=0.6u
X124 pad_uq4 gate iovss iovss sg13_hv_nmos ad=2.596p pd=5.58u as=1.408p ps=5.04u w=4.4u l=0.6u
X125 iovss gate pad_uq10 iovss sg13_hv_nmos ad=1.408p pd=5.04u as=2.596p ps=5.58u w=4.4u l=0.6u
X126 pad_uq11 gate iovss iovss sg13_hv_nmos ad=2.596p pd=5.58u as=1.408p ps=5.04u w=4.4u l=0.6u
X127 iovss gate pad_uq12 iovss sg13_hv_nmos ad=1.408p pd=5.04u as=2.596p ps=5.58u w=4.4u l=0.6u
X128 iovss gate pad_uq15 iovss sg13_hv_nmos ad=1.408p pd=5.04u as=2.596p ps=5.58u w=4.4u l=0.6u
X129 pad_uq0 gate iovss iovss sg13_hv_nmos ad=3.256p pd=10.28u as=1.408p ps=5.04u w=4.4u l=0.6u
X130 pad_uq1 gate iovss iovss sg13_hv_nmos ad=2.596p pd=5.58u as=1.408p ps=5.04u w=4.4u l=0.6u
X131 pad_uq19 gate iovss iovss sg13_hv_nmos ad=2.596p pd=5.58u as=1.408p ps=5.04u w=4.4u l=0.6u
X132 iovss gate pad_uq4 iovss sg13_hv_nmos ad=1.408p pd=5.04u as=2.596p ps=5.58u w=4.4u l=0.6u
X133 pad_uq9 gate iovss iovss sg13_hv_nmos ad=2.596p pd=5.58u as=1.408p ps=5.04u w=4.4u l=0.6u
X134 iovss gate pad_uq6 iovss sg13_hv_nmos ad=1.408p pd=5.04u as=2.596p ps=5.58u w=4.4u l=0.6u
X135 iovss gate pad_uq8 iovss sg13_hv_nmos ad=1.408p pd=5.04u as=2.596p ps=5.58u w=4.4u l=0.6u
X136 pad_uq3 gate iovss iovss sg13_hv_nmos ad=2.596p pd=5.58u as=1.408p ps=5.04u w=4.4u l=0.6u
X137 iovss gate pad_uq2 iovss sg13_hv_nmos ad=1.408p pd=5.04u as=2.596p ps=5.58u w=4.4u l=0.6u
X138 pad_uq7 gate iovss iovss sg13_hv_nmos ad=2.596p pd=5.58u as=1.408p ps=5.04u w=4.4u l=0.6u
X139 iovss gate pad_uq16 iovss sg13_hv_nmos ad=1.408p pd=5.04u as=2.596p ps=5.58u w=4.4u l=0.6u
X140 pad_uq20 gate iovss iovss sg13_hv_nmos ad=2.596p pd=5.58u as=2.068p ps=9.74u w=4.4u l=0.6u
X141 iovss gate pad_uq9 iovss sg13_hv_nmos ad=1.408p pd=5.04u as=2.596p ps=5.58u w=4.4u l=0.6u
X142 pad_uq12 gate iovss iovss sg13_hv_nmos ad=2.596p pd=5.58u as=1.408p ps=5.04u w=4.4u l=0.6u
X143 pad_uq18 gate iovss iovss sg13_hv_nmos ad=2.596p pd=5.58u as=1.408p ps=5.04u w=4.4u l=0.6u
X144 iovss gate pad_uq11 iovss sg13_hv_nmos ad=1.408p pd=5.04u as=2.596p ps=5.58u w=4.4u l=0.6u
X145 pad_uq8 gate iovss iovss sg13_hv_nmos ad=2.596p pd=5.58u as=1.408p ps=5.04u w=4.4u l=0.6u
X146 pad_uq0 gate iovss iovss sg13_hv_nmos ad=3.256p pd=10.28u as=1.408p ps=5.04u w=4.4u l=0.6u
X147 iovss gate pad_uq7 iovss sg13_hv_nmos ad=1.408p pd=5.04u as=2.596p ps=5.58u w=4.4u l=0.6u
X148 pad_uq5 gate iovss iovss sg13_hv_nmos ad=2.596p pd=5.58u as=1.408p ps=5.04u w=4.4u l=0.6u
X149 iovss gate pad_uq4 iovss sg13_hv_nmos ad=1.408p pd=5.04u as=2.596p ps=5.58u w=4.4u l=0.6u
X150 iovss gate pad iovss sg13_hv_nmos ad=1.408p pd=5.04u as=2.596p ps=5.58u w=4.4u l=0.6u
X151 iovss gate pad_uq18 iovss sg13_hv_nmos ad=1.408p pd=5.04u as=2.596p ps=5.58u w=4.4u l=0.6u
X152 iovss gate pad_uq20 iovss sg13_hv_nmos ad=1.408p pd=5.04u as=2.596p ps=5.58u w=4.4u l=0.6u
X153 pad_uq14 gate iovss iovss sg13_hv_nmos ad=2.596p pd=5.58u as=1.408p ps=5.04u w=4.4u l=0.6u
X154 pad_uq2 gate iovss iovss sg13_hv_nmos ad=2.596p pd=5.58u as=1.408p ps=5.04u w=4.4u l=0.6u
X155 pad_uq20 gate iovss iovss sg13_hv_nmos ad=2.596p pd=5.58u as=2.068p ps=9.74u w=4.4u l=0.6u
X156 pad_uq10 gate iovss iovss sg13_hv_nmos ad=2.596p pd=5.58u as=1.408p ps=5.04u w=4.4u l=0.6u
X157 pad_uq3 gate iovss iovss sg13_hv_nmos ad=2.596p pd=5.58u as=1.408p ps=5.04u w=4.4u l=0.6u
X158 pad_uq4 gate iovss iovss sg13_hv_nmos ad=2.596p pd=5.58u as=1.408p ps=5.04u w=4.4u l=0.6u
X159 pad_uq16 gate iovss iovss sg13_hv_nmos ad=2.596p pd=5.58u as=1.408p ps=5.04u w=4.4u l=0.6u
X160 iovss gate pad_uq12 iovss sg13_hv_nmos ad=1.408p pd=5.04u as=2.596p ps=5.58u w=4.4u l=0.6u
X161 iovss gate pad_uq17 iovss sg13_hv_nmos ad=1.408p pd=5.04u as=2.596p ps=5.58u w=4.4u l=0.6u
X162 pad_uq16 gate iovss iovss sg13_hv_nmos ad=2.596p pd=5.58u as=1.408p ps=5.04u w=4.4u l=0.6u
X163 pad_uq17 gate iovss iovss sg13_hv_nmos ad=2.596p pd=5.58u as=1.408p ps=5.04u w=4.4u l=0.6u
X164 pad_uq7 gate iovss iovss sg13_hv_nmos ad=2.596p pd=5.58u as=1.408p ps=5.04u w=4.4u l=0.6u
X165 pad_uq19 gate iovss iovss sg13_hv_nmos ad=2.596p pd=5.58u as=1.408p ps=5.04u w=4.4u l=0.6u
X166 iovss gate pad_uq20 iovss sg13_hv_nmos ad=1.408p pd=5.04u as=2.596p ps=5.58u w=4.4u l=0.6u
X167 pad_uq13 gate iovss iovss sg13_hv_nmos ad=2.596p pd=5.58u as=1.408p ps=5.04u w=4.4u l=0.6u
X168 pad_uq9 gate iovss iovss sg13_hv_nmos ad=2.596p pd=5.58u as=1.408p ps=5.04u w=4.4u l=0.6u
X169 pad gate iovss iovss sg13_hv_nmos ad=2.596p pd=5.58u as=1.408p ps=5.04u w=4.4u l=0.6u
X170 iovss gate pad iovss sg13_hv_nmos ad=1.408p pd=5.04u as=2.596p ps=5.58u w=4.4u l=0.6u
X171 pad_uq4 gate iovss iovss sg13_hv_nmos ad=2.596p pd=5.58u as=1.408p ps=5.04u w=4.4u l=0.6u
X172 iovss gate pad_uq13 iovss sg13_hv_nmos ad=1.408p pd=5.04u as=2.596p ps=5.58u w=4.4u l=0.6u
.ends

.subckt sg13cmos5l_RCClampInverter supply in out iovss
X0 iovss in iovss iovss sg13_hv_nmos ad=1.71p pd=9.38u as=0 ps=0 w=9u l=9.5u
X1 out in supply supply sg13_hv_pmos ad=1.33p pd=7.38u as=1.33p ps=7.38u w=7u l=0.5u
X2 iovss in out iovss sg13_hv_nmos ad=1.71p pd=9.38u as=1.71p ps=9.38u w=9u l=0.5u
X3 out in supply supply sg13_hv_pmos ad=1.33p pd=7.38u as=2.38p ps=14.68u w=7u l=0.5u
X4 out in supply supply sg13_hv_pmos ad=1.33p pd=7.38u as=1.33p ps=7.38u w=7u l=0.5u
X5 supply in out supply sg13_hv_pmos ad=1.33p pd=7.38u as=1.33p ps=7.38u w=7u l=0.5u
X6 supply in out supply sg13_hv_pmos ad=1.33p pd=7.38u as=1.33p ps=7.38u w=7u l=0.5u
X7 out in iovss iovss sg13_hv_nmos ad=1.71p pd=9.38u as=1.71p ps=9.38u w=9u l=0.5u
X8 supply in out supply sg13_hv_pmos ad=1.33p pd=7.38u as=1.33p ps=7.38u w=7u l=0.5u
X9 supply in out supply sg13_hv_pmos ad=1.33p pd=7.38u as=1.33p ps=7.38u w=7u l=0.5u
X10 supply in out supply sg13_hv_pmos ad=1.33p pd=7.38u as=1.33p ps=7.38u w=7u l=0.5u
X11 out in supply supply sg13_hv_pmos ad=1.33p pd=7.38u as=1.33p ps=7.38u w=7u l=0.5u
X12 out in supply supply sg13_hv_pmos ad=1.33p pd=7.38u as=1.33p ps=7.38u w=7u l=0.5u
X13 supply in out supply sg13_hv_pmos ad=1.33p pd=7.38u as=1.33p ps=7.38u w=7u l=0.5u
X14 supply in out supply sg13_hv_pmos ad=1.33p pd=7.38u as=1.33p ps=7.38u w=7u l=0.5u
X15 iovss in iovss iovss sg13_hv_nmos ad=3.06p pd=18.68u as=0 ps=0 w=9u l=9.5u
X16 out in iovss iovss sg13_hv_nmos ad=1.71p pd=9.38u as=1.71p ps=9.38u w=9u l=0.5u
X17 iovss in out iovss sg13_hv_nmos ad=3.06p pd=18.68u as=1.71p ps=9.38u w=9u l=0.5u
X18 iovss in iovss iovss sg13_hv_nmos ad=1.71p pd=9.38u as=0 ps=0 w=9u l=9.5u
X19 iovss in iovss iovss sg13_hv_nmos ad=3.06p pd=18.68u as=0 ps=0 w=9u l=9.5u
X20 iovss in iovss iovss sg13_hv_nmos ad=1.71p pd=9.38u as=0 ps=0 w=9u l=9.5u
X21 iovss in iovss iovss sg13_hv_nmos ad=1.71p pd=9.38u as=0 ps=0 w=9u l=9.5u
X22 supply in out supply sg13_hv_pmos ad=1.33p pd=7.38u as=1.33p ps=7.38u w=7u l=0.5u
X23 out in supply supply sg13_hv_pmos ad=1.33p pd=7.38u as=1.33p ps=7.38u w=7u l=0.5u
X24 out in supply supply sg13_hv_pmos ad=1.33p pd=7.38u as=1.33p ps=7.38u w=7u l=0.5u
X25 iovss in iovss iovss sg13_hv_nmos ad=1.71p pd=9.38u as=0 ps=0 w=9u l=9.5u
X26 out in supply supply sg13_hv_pmos ad=1.33p pd=7.38u as=1.33p ps=7.38u w=7u l=0.5u
X27 iovss in out iovss sg13_hv_nmos ad=1.71p pd=9.38u as=1.71p ps=9.38u w=9u l=0.5u
X28 out in supply supply sg13_hv_pmos ad=1.33p pd=7.38u as=1.33p ps=7.38u w=7u l=0.5u
X29 supply in out supply sg13_hv_pmos ad=1.33p pd=7.38u as=1.33p ps=7.38u w=7u l=0.5u
X30 out in supply supply sg13_hv_pmos ad=1.33p pd=7.38u as=1.33p ps=7.38u w=7u l=0.5u
X31 iovss in iovss iovss sg13_hv_nmos ad=1.71p pd=9.38u as=0 ps=0 w=9u l=9.5u
X32 out in supply supply sg13_hv_pmos ad=1.33p pd=7.38u as=1.33p ps=7.38u w=7u l=0.5u
X33 supply in out supply sg13_hv_pmos ad=1.33p pd=7.38u as=1.33p ps=7.38u w=7u l=0.5u
X34 out in iovss iovss sg13_hv_nmos ad=1.71p pd=9.38u as=1.71p ps=9.38u w=9u l=0.5u
X35 supply in out supply sg13_hv_pmos ad=1.33p pd=7.38u as=1.33p ps=7.38u w=7u l=0.5u
X36 out in supply supply sg13_hv_pmos ad=1.33p pd=7.38u as=1.33p ps=7.38u w=7u l=0.5u
X37 out in supply supply sg13_hv_pmos ad=1.33p pd=7.38u as=1.33p ps=7.38u w=7u l=0.5u
X38 out in supply supply sg13_hv_pmos ad=1.33p pd=7.38u as=1.33p ps=7.38u w=7u l=0.5u
X39 supply in out supply sg13_hv_pmos ad=1.33p pd=7.38u as=1.33p ps=7.38u w=7u l=0.5u
X40 out in supply supply sg13_hv_pmos ad=1.33p pd=7.38u as=1.33p ps=7.38u w=7u l=0.5u
X41 supply in out supply sg13_hv_pmos ad=1.33p pd=7.38u as=1.33p ps=7.38u w=7u l=0.5u
X42 iovss in iovss iovss sg13_hv_nmos ad=1.71p pd=9.38u as=0 ps=0 w=9u l=9.5u
X43 supply in out supply sg13_hv_pmos ad=1.33p pd=7.38u as=1.33p ps=7.38u w=7u l=0.5u
X44 out in supply supply sg13_hv_pmos ad=1.33p pd=7.38u as=1.33p ps=7.38u w=7u l=0.5u
X45 iovss in out iovss sg13_hv_nmos ad=1.71p pd=9.38u as=1.71p ps=9.38u w=9u l=0.5u
X46 iovss in iovss iovss sg13_hv_nmos ad=1.71p pd=9.38u as=0 ps=0 w=9u l=9.5u
X47 out in supply supply sg13_hv_pmos ad=1.33p pd=7.38u as=1.33p ps=7.38u w=7u l=0.5u
X48 supply in out supply sg13_hv_pmos ad=2.38p pd=14.68u as=1.33p ps=7.38u w=7u l=0.5u
X49 out in iovss iovss sg13_hv_nmos ad=1.71p pd=9.38u as=1.71p ps=9.38u w=9u l=0.5u
X50 supply in out supply sg13_hv_pmos ad=1.33p pd=7.38u as=1.33p ps=7.38u w=7u l=0.5u
X51 out in supply supply sg13_hv_pmos ad=1.33p pd=7.38u as=1.33p ps=7.38u w=7u l=0.5u
X52 out in supply supply sg13_hv_pmos ad=1.33p pd=7.38u as=1.33p ps=7.38u w=7u l=0.5u
X53 supply in out supply sg13_hv_pmos ad=1.33p pd=7.38u as=1.33p ps=7.38u w=7u l=0.5u
X54 iovss in iovss iovss sg13_hv_nmos ad=1.71p pd=9.38u as=0 ps=0 w=9u l=9.5u
X55 out in supply supply sg13_hv_pmos ad=1.33p pd=7.38u as=1.33p ps=7.38u w=7u l=0.5u
X56 supply in out supply sg13_hv_pmos ad=1.33p pd=7.38u as=1.33p ps=7.38u w=7u l=0.5u
X57 supply in out supply sg13_hv_pmos ad=1.33p pd=7.38u as=1.33p ps=7.38u w=7u l=0.5u
X58 supply in out supply sg13_hv_pmos ad=1.33p pd=7.38u as=1.33p ps=7.38u w=7u l=0.5u
X59 out in supply supply sg13_hv_pmos ad=1.33p pd=7.38u as=1.33p ps=7.38u w=7u l=0.5u
X60 supply in out supply sg13_hv_pmos ad=1.33p pd=7.38u as=1.33p ps=7.38u w=7u l=0.5u
X61 out in iovss iovss sg13_hv_nmos ad=1.71p pd=9.38u as=1.71p ps=9.38u w=9u l=0.5u
X62 out in supply supply sg13_hv_pmos ad=1.33p pd=7.38u as=1.33p ps=7.38u w=7u l=0.5u
X63 iovss in out iovss sg13_hv_nmos ad=1.71p pd=9.38u as=1.71p ps=9.38u w=9u l=0.5u
X64 supply in out supply sg13_hv_pmos ad=1.33p pd=7.38u as=1.33p ps=7.38u w=7u l=0.5u
X65 supply in out supply sg13_hv_pmos ad=1.33p pd=7.38u as=1.33p ps=7.38u w=7u l=0.5u
X66 out in supply supply sg13_hv_pmos ad=1.33p pd=7.38u as=1.33p ps=7.38u w=7u l=0.5u
X67 out in supply supply sg13_hv_pmos ad=1.33p pd=7.38u as=1.33p ps=7.38u w=7u l=0.5u
X68 iovss in iovss iovss sg13_hv_nmos ad=1.71p pd=9.38u as=0 ps=0 w=9u l=9.5u
X69 out in supply supply sg13_hv_pmos ad=1.33p pd=7.38u as=1.33p ps=7.38u w=7u l=0.5u
X70 supply in out supply sg13_hv_pmos ad=1.33p pd=7.38u as=1.33p ps=7.38u w=7u l=0.5u
X71 supply in out supply sg13_hv_pmos ad=1.33p pd=7.38u as=1.33p ps=7.38u w=7u l=0.5u
X72 iovss in out iovss sg13_hv_nmos ad=3.06p pd=18.68u as=1.71p ps=9.38u w=9u l=0.5u
X73 iovss in iovss iovss sg13_hv_nmos ad=1.71p pd=9.38u as=0 ps=0 w=9u l=9.5u
X74 iovss in iovss iovss sg13_hv_nmos ad=1.71p pd=9.38u as=0 ps=0 w=9u l=9.5u
X75 out in iovss iovss sg13_hv_nmos ad=1.71p pd=9.38u as=1.71p ps=9.38u w=9u l=0.5u
.ends

.subckt sg13cmos5l_RCClampResistor pin1 pin2 sub
X0 a_2640_4086# a_2970_0# sub rppd l=20u w=1u
X1 a_3300_4086# a_2970_0# sub rppd l=20u w=1u
X2 a_4620_4086# a_4950_0# sub rppd l=20u w=1u
X3 a_5280_4086# a_4950_0# sub rppd l=20u w=1u
X4 a_6600_4086# a_6930_0# sub rppd l=20u w=1u
X5 a_7260_4086# a_6930_0# sub rppd l=20u w=1u
X6 a_2640_4086# a_2310_0# sub rppd l=20u w=1u
X7 a_4620_4086# a_4290_0# sub rppd l=20u w=1u
X8 a_660_4086# a_990_0# sub rppd l=20u w=1u
X9 a_6600_4086# a_6270_0# sub rppd l=20u w=1u
X10 a_1980_4086# a_1650_0# sub rppd l=20u w=1u
X11 a_1980_4086# a_2310_0# sub rppd l=20u w=1u
X12 a_660_4086# a_330_0# sub rppd l=20u w=1u
X13 a_3960_4086# a_3630_0# sub rppd l=20u w=1u
X14 a_3960_4086# a_4290_0# sub rppd l=20u w=1u
X15 a_5940_4086# a_5610_0# sub rppd l=20u w=1u
X16 a_5940_4086# a_6270_0# sub rppd l=20u w=1u
X17 a_7920_4086# a_7590_0# sub rppd l=20u w=1u
X18 a_7920_4086# pin2 sub rppd l=20u w=1u
X19 a_0_4086# pin1 sub rppd l=20u w=1u
X20 a_1320_4086# a_1650_0# sub rppd l=20u w=1u
X21 a_3300_4086# a_3630_0# sub rppd l=20u w=1u
X22 a_0_4086# a_330_0# sub rppd l=20u w=1u
X23 a_5280_4086# a_5610_0# sub rppd l=20u w=1u
X24 a_7260_4086# a_7590_0# sub rppd l=20u w=1u
X25 a_1320_4086# a_990_0# sub rppd l=20u w=1u
.ends

.subckt sg13cmos5l_IOPadVdd vdd iovss iovdd iovdd_uq0 vss w_n124_1076#
Xsg13cmos5l_Clamp_N43N43D4R_0 vss vdd sg13cmos5l_RCClampInverter_0/out vdd vdd vdd
+ vdd vdd vdd vdd vdd vdd vdd vdd vdd vdd vdd vdd vdd vdd vdd vdd vdd vdd w_n124_1076#
+ sg13cmos5l_Clamp_N43N43D4R
Xsg13cmos5l_RCClampInverter_0 vdd sg13cmos5l_RCClampInverter_0/in sg13cmos5l_RCClampInverter_0/out
+ vss sg13cmos5l_RCClampInverter
Xsg13cmos5l_RCClampResistor_0 vdd sg13cmos5l_RCClampInverter_0/in vss sg13cmos5l_RCClampResistor
.ends

.subckt sg13cmos5l_IOPadIOVdd vdd iovss iovdd vss
Xsg13cmos5l_Clamp_N43N43D4R_0 vss iovdd sg13cmos5l_RCClampInverter_0/out iovdd iovdd
+ iovdd iovdd iovdd iovdd iovdd iovdd iovdd iovdd iovdd iovdd iovdd iovdd iovdd iovdd
+ iovdd iovdd iovdd iovdd iovdd iovdd sg13cmos5l_Clamp_N43N43D4R
Xsg13cmos5l_RCClampInverter_0 iovdd sg13cmos5l_RCClampInverter_0/in sg13cmos5l_RCClampInverter_0/out
+ vss sg13cmos5l_RCClampInverter
Xsg13cmos5l_RCClampResistor_0 iovdd sg13cmos5l_RCClampInverter_0/in vss sg13cmos5l_RCClampResistor
.ends

.subckt sg13cmos5l_IOPadIn vss vdd iovdd p2c pad sg13cmos5l_DCNDiode_0/guard
Xsg13cmos5l_DCPDiode_0 pad iovdd vss pad sg13cmos5l_DCPDiode
Xsg13cmos5l_LevelDown_0 vdd iovdd vss pad p2c sg13cmos5l_LevelDown
Xsg13cmos5l_DCNDiode_0 vss pad sg13cmos5l_DCNDiode_0/guard pad sg13cmos5l_DCNDiode
.ends

.subckt user_id_programming mask_rev[0] mask_rev[1] mask_rev[2] mask_rev[3] mask_rev[4]
+ mask_rev[5] mask_rev[6] mask_rev[7] mask_rev[8] mask_rev[9] mask_rev[10] mask_rev[11]
+ mask_rev[12] mask_rev[13] mask_rev[14] mask_rev[15] mask_rev[16] mask_rev[17] mask_rev[18]
+ mask_rev[19] mask_rev[20] mask_rev[21] mask_rev[22] mask_rev[23] mask_rev[24] mask_rev[25]
+ mask_rev[26] mask_rev[27] mask_rev[28] mask_rev[29] mask_rev[30] mask_rev[31] sub
+ sg13cmos5l_tielo_9/VDD
Xsg13cmos5l_tielo_24 mask_rev[15] sg13cmos5l_tielo_9/VDD sub sg13cmos5l_tielo
Xsg13cmos5l_tielo_13 mask_rev[26] sg13cmos5l_tielo_9/VDD sub sg13cmos5l_tielo
Xsg13cmos5l_tielo_25 mask_rev[13] sg13cmos5l_tielo_9/VDD sub sg13cmos5l_tielo
Xsg13cmos5l_tielo_14 mask_rev[28] sg13cmos5l_tielo_9/VDD sub sg13cmos5l_tielo
Xsg13cmos5l_decap_4_30 sg13cmos5l_tielo_9/VDD sub sg13cmos5l_decap_4
Xsg13cmos5l_tiehi_30 sg13cmos5l_tiehi_30/L_HI sg13cmos5l_tielo_9/VDD sub sg13cmos5l_tiehi
Xsg13cmos5l_tielo_26 mask_rev[11] sg13cmos5l_tielo_9/VDD sub sg13cmos5l_tielo
Xsg13cmos5l_tielo_15 mask_rev[30] sg13cmos5l_tielo_9/VDD sub sg13cmos5l_tielo
Xsg13cmos5l_decap_4_31 sg13cmos5l_tielo_9/VDD sub sg13cmos5l_decap_4
Xsg13cmos5l_tiehi_31 sg13cmos5l_tiehi_31/L_HI sg13cmos5l_tielo_9/VDD sub sg13cmos5l_tiehi
Xsg13cmos5l_tielo_27 sg13cmos5l_tielo_27/L_LO sg13cmos5l_tielo_9/VDD sub sg13cmos5l_tielo
Xsg13cmos5l_tiehi_20 sg13cmos5l_tiehi_20/L_HI sg13cmos5l_tielo_9/VDD sub sg13cmos5l_tiehi
Xsg13cmos5l_tielo_16 mask_rev[31] sg13cmos5l_tielo_9/VDD sub sg13cmos5l_tielo
Xsg13cmos5l_decap_4_21 sg13cmos5l_tielo_9/VDD sub sg13cmos5l_decap_4
Xsg13cmos5l_decap_4_32 sg13cmos5l_tielo_9/VDD sub sg13cmos5l_decap_4
Xsg13cmos5l_decap_4_10 sg13cmos5l_tielo_9/VDD sub sg13cmos5l_decap_4
Xsg13cmos5l_tiehi_21 mask_rev[21] sg13cmos5l_tielo_9/VDD sub sg13cmos5l_tiehi
Xsg13cmos5l_tiehi_10 sg13cmos5l_tiehi_10/L_HI sg13cmos5l_tielo_9/VDD sub sg13cmos5l_tiehi
Xsg13cmos5l_tielo_28 mask_rev[7] sg13cmos5l_tielo_9/VDD sub sg13cmos5l_tielo
Xsg13cmos5l_tielo_17 sg13cmos5l_tielo_17/L_LO sg13cmos5l_tielo_9/VDD sub sg13cmos5l_tielo
Xsg13cmos5l_decap_4_22 sg13cmos5l_tielo_9/VDD sub sg13cmos5l_decap_4
Xsg13cmos5l_decap_4_33 sg13cmos5l_tielo_9/VDD sub sg13cmos5l_decap_4
Xsg13cmos5l_decap_4_11 sg13cmos5l_tielo_9/VDD sub sg13cmos5l_decap_4
Xsg13cmos5l_tielo_29 sg13cmos5l_tielo_29/L_LO sg13cmos5l_tielo_9/VDD sub sg13cmos5l_tielo
Xsg13cmos5l_tiehi_22 sg13cmos5l_tiehi_22/L_HI sg13cmos5l_tielo_9/VDD sub sg13cmos5l_tiehi
Xsg13cmos5l_tiehi_11 sg13cmos5l_tiehi_11/L_HI sg13cmos5l_tielo_9/VDD sub sg13cmos5l_tiehi
Xsg13cmos5l_tielo_18 mask_rev[27] sg13cmos5l_tielo_9/VDD sub sg13cmos5l_tielo
Xsg13cmos5l_decap_4_34 sg13cmos5l_tielo_9/VDD sub sg13cmos5l_decap_4
Xsg13cmos5l_decap_4_12 sg13cmos5l_tielo_9/VDD sub sg13cmos5l_decap_4
Xsg13cmos5l_decap_4_23 sg13cmos5l_tielo_9/VDD sub sg13cmos5l_decap_4
Xsg13cmos5l_tiehi_23 mask_rev[17] sg13cmos5l_tielo_9/VDD sub sg13cmos5l_tiehi
Xsg13cmos5l_tiehi_12 sg13cmos5l_tiehi_12/L_HI sg13cmos5l_tielo_9/VDD sub sg13cmos5l_tiehi
Xsg13cmos5l_tielo_19 mask_rev[25] sg13cmos5l_tielo_9/VDD sub sg13cmos5l_tielo
Xsg13cmos5l_decap_4_35 sg13cmos5l_tielo_9/VDD sub sg13cmos5l_decap_4
Xsg13cmos5l_decap_4_13 sg13cmos5l_tielo_9/VDD sub sg13cmos5l_decap_4
Xsg13cmos5l_decap_4_24 sg13cmos5l_tielo_9/VDD sub sg13cmos5l_decap_4
Xsg13cmos5l_tiehi_24 sg13cmos5l_tiehi_24/L_HI sg13cmos5l_tielo_9/VDD sub sg13cmos5l_tiehi
Xsg13cmos5l_tiehi_13 sg13cmos5l_tiehi_13/L_HI sg13cmos5l_tielo_9/VDD sub sg13cmos5l_tiehi
Xsg13cmos5l_decap_4_36 sg13cmos5l_tielo_9/VDD sub sg13cmos5l_decap_4
Xsg13cmos5l_tiehi_25 sg13cmos5l_tiehi_25/L_HI sg13cmos5l_tielo_9/VDD sub sg13cmos5l_tiehi
Xsg13cmos5l_decap_4_25 sg13cmos5l_tielo_9/VDD sub sg13cmos5l_decap_4
Xsg13cmos5l_decap_4_14 sg13cmos5l_tielo_9/VDD sub sg13cmos5l_decap_4
Xsg13cmos5l_tiehi_14 sg13cmos5l_tiehi_14/L_HI sg13cmos5l_tielo_9/VDD sub sg13cmos5l_tiehi
Xsg13cmos5l_decap_4_37 sg13cmos5l_tielo_9/VDD sub sg13cmos5l_decap_4
Xsg13cmos5l_decap_4_26 sg13cmos5l_tielo_9/VDD sub sg13cmos5l_decap_4
Xsg13cmos5l_decap_4_15 sg13cmos5l_tielo_9/VDD sub sg13cmos5l_decap_4
Xsg13cmos5l_tiehi_15 sg13cmos5l_tiehi_15/L_HI sg13cmos5l_tielo_9/VDD sub sg13cmos5l_tiehi
Xsg13cmos5l_tiehi_26 sg13cmos5l_tiehi_26/L_HI sg13cmos5l_tielo_9/VDD sub sg13cmos5l_tiehi
Xsg13cmos5l_tiehi_16 sg13cmos5l_tiehi_16/L_HI sg13cmos5l_tielo_9/VDD sub sg13cmos5l_tiehi
Xsg13cmos5l_decap_4_38 sg13cmos5l_tielo_9/VDD sub sg13cmos5l_decap_4
Xsg13cmos5l_tiehi_27 mask_rev[9] sg13cmos5l_tielo_9/VDD sub sg13cmos5l_tiehi
Xsg13cmos5l_decap_4_27 sg13cmos5l_tielo_9/VDD sub sg13cmos5l_decap_4
Xsg13cmos5l_decap_4_16 sg13cmos5l_tielo_9/VDD sub sg13cmos5l_decap_4
Xsg13cmos5l_decap_4_17 sg13cmos5l_tielo_9/VDD sub sg13cmos5l_decap_4
Xsg13cmos5l_decap_4_39 sg13cmos5l_tielo_9/VDD sub sg13cmos5l_decap_4
Xsg13cmos5l_decap_4_28 sg13cmos5l_tielo_9/VDD sub sg13cmos5l_decap_4
Xsg13cmos5l_tiehi_28 sg13cmos5l_tiehi_28/L_HI sg13cmos5l_tielo_9/VDD sub sg13cmos5l_tiehi
Xsg13cmos5l_tiehi_17 mask_rev[29] sg13cmos5l_tielo_9/VDD sub sg13cmos5l_tiehi
Xsg13cmos5l_decap_4_18 sg13cmos5l_tielo_9/VDD sub sg13cmos5l_decap_4
Xsg13cmos5l_tiehi_29 mask_rev[5] sg13cmos5l_tielo_9/VDD sub sg13cmos5l_tiehi
Xsg13cmos5l_decap_4_29 sg13cmos5l_tielo_9/VDD sub sg13cmos5l_decap_4
Xsg13cmos5l_tiehi_18 sg13cmos5l_tiehi_18/L_HI sg13cmos5l_tielo_9/VDD sub sg13cmos5l_tiehi
Xsg13cmos5l_tiehi_19 sg13cmos5l_tiehi_19/L_HI sg13cmos5l_tielo_9/VDD sub sg13cmos5l_tiehi
Xsg13cmos5l_tiehi_0 sg13cmos5l_tiehi_0/L_HI sg13cmos5l_tielo_9/VDD sub sg13cmos5l_tiehi
Xsg13cmos5l_tiehi_1 sg13cmos5l_tiehi_1/L_HI sg13cmos5l_tielo_9/VDD sub sg13cmos5l_tiehi
Xsg13cmos5l_tiehi_2 mask_rev[4] sg13cmos5l_tielo_9/VDD sub sg13cmos5l_tiehi
Xsg13cmos5l_tiehi_3 sg13cmos5l_tiehi_3/L_HI sg13cmos5l_tielo_9/VDD sub sg13cmos5l_tiehi
Xsg13cmos5l_tielo_0 mask_rev[0] sg13cmos5l_tielo_9/VDD sub sg13cmos5l_tielo
Xsg13cmos5l_tiehi_4 mask_rev[8] sg13cmos5l_tielo_9/VDD sub sg13cmos5l_tiehi
Xsg13cmos5l_tielo_1 mask_rev[2] sg13cmos5l_tielo_9/VDD sub sg13cmos5l_tielo
Xsg13cmos5l_tiehi_5 sg13cmos5l_tiehi_5/L_HI sg13cmos5l_tielo_9/VDD sub sg13cmos5l_tiehi
Xsg13cmos5l_decap_4_0 sg13cmos5l_tielo_9/VDD sub sg13cmos5l_decap_4
Xsg13cmos5l_tielo_2 sg13cmos5l_tielo_2/L_LO sg13cmos5l_tielo_9/VDD sub sg13cmos5l_tielo
Xsg13cmos5l_tiehi_6 sg13cmos5l_tiehi_6/L_HI sg13cmos5l_tielo_9/VDD sub sg13cmos5l_tiehi
Xsg13cmos5l_decap_4_1 sg13cmos5l_tielo_9/VDD sub sg13cmos5l_decap_4
Xsg13cmos5l_tielo_3 mask_rev[6] sg13cmos5l_tielo_9/VDD sub sg13cmos5l_tielo
Xsg13cmos5l_tiehi_7 sg13cmos5l_tiehi_7/L_HI sg13cmos5l_tielo_9/VDD sub sg13cmos5l_tiehi
Xsg13cmos5l_decap_4_2 sg13cmos5l_tielo_9/VDD sub sg13cmos5l_decap_4
Xsg13cmos5l_tielo_4 sg13cmos5l_tielo_4/L_LO sg13cmos5l_tielo_9/VDD sub sg13cmos5l_tielo
Xsg13cmos5l_tiehi_8 sg13cmos5l_tiehi_8/L_HI sg13cmos5l_tielo_9/VDD sub sg13cmos5l_tiehi
Xsg13cmos5l_decap_4_3 sg13cmos5l_tielo_9/VDD sub sg13cmos5l_decap_4
Xsg13cmos5l_tielo_5 mask_rev[10] sg13cmos5l_tielo_9/VDD sub sg13cmos5l_tielo
Xsg13cmos5l_tiehi_9 mask_rev[18] sg13cmos5l_tielo_9/VDD sub sg13cmos5l_tiehi
Xsg13cmos5l_decap_4_4 sg13cmos5l_tielo_9/VDD sub sg13cmos5l_decap_4
Xsg13cmos5l_tielo_6 mask_rev[12] sg13cmos5l_tielo_9/VDD sub sg13cmos5l_tielo
Xsg13cmos5l_decap_4_5 sg13cmos5l_tielo_9/VDD sub sg13cmos5l_decap_4
Xsg13cmos5l_tielo_7 mask_rev[14] sg13cmos5l_tielo_9/VDD sub sg13cmos5l_tielo
Xsg13cmos5l_decap_4_6 sg13cmos5l_tielo_9/VDD sub sg13cmos5l_decap_4
Xsg13cmos5l_tielo_8 mask_rev[16] sg13cmos5l_tielo_9/VDD sub sg13cmos5l_tielo
Xsg13cmos5l_tielo_30 mask_rev[3] sg13cmos5l_tielo_9/VDD sub sg13cmos5l_tielo
Xsg13cmos5l_decap_4_7 sg13cmos5l_tielo_9/VDD sub sg13cmos5l_decap_4
Xsg13cmos5l_tielo_9 sg13cmos5l_tielo_9/L_LO sg13cmos5l_tielo_9/VDD sub sg13cmos5l_tielo
Xsg13cmos5l_tielo_31 mask_rev[1] sg13cmos5l_tielo_9/VDD sub sg13cmos5l_tielo
Xsg13cmos5l_decap_4_8 sg13cmos5l_tielo_9/VDD sub sg13cmos5l_decap_4
Xsg13cmos5l_tielo_20 mask_rev[23] sg13cmos5l_tielo_9/VDD sub sg13cmos5l_tielo
Xsg13cmos5l_decap_4_9 sg13cmos5l_tielo_9/VDD sub sg13cmos5l_decap_4
Xsg13cmos5l_tielo_21 sg13cmos5l_tielo_21/L_LO sg13cmos5l_tielo_9/VDD sub sg13cmos5l_tielo
Xsg13cmos5l_tielo_10 mask_rev[20] sg13cmos5l_tielo_9/VDD sub sg13cmos5l_tielo
Xsg13cmos5l_tielo_22 mask_rev[19] sg13cmos5l_tielo_9/VDD sub sg13cmos5l_tielo
Xsg13cmos5l_tielo_11 mask_rev[22] sg13cmos5l_tielo_9/VDD sub sg13cmos5l_tielo
Xsg13cmos5l_tielo_23 sg13cmos5l_tielo_23/L_LO sg13cmos5l_tielo_9/VDD sub sg13cmos5l_tielo
Xsg13cmos5l_tielo_12 mask_rev[24] sg13cmos5l_tielo_9/VDD sub sg13cmos5l_tielo
.ends

.subckt user_id_routing mask_rev[0] mask_rev[1] mask_rev[2] mask_rev[3] mask_rev[4]
+ mask_rev[5] mask_rev[6] mask_rev[7] mask_rev[8] mask_rev[9] mask_rev[10] mask_rev[11]
+ mask_rev[12] mask_rev[13] mask_rev[14] mask_rev[15] mask_rev[16] mask_rev[17] mask_rev[18]
+ mask_rev[19] mask_rev[20] mask_rev[21] mask_rev[22] mask_rev[23] mask_rev[24] mask_rev[25]
+ mask_rev[26] mask_rev[27] mask_rev[28] mask_rev[29] mask_rev[30] mask_rev[31] vdd
+ vss
Xuser_id_programming_0 mask_rev[0] mask_rev[1] mask_rev[2] mask_rev[3] mask_rev[4]
+ mask_rev[5] mask_rev[6] mask_rev[7] mask_rev[8] mask_rev[9] mask_rev[10] mask_rev[11]
+ mask_rev[12] mask_rev[13] mask_rev[14] mask_rev[15] mask_rev[16] mask_rev[17] mask_rev[18]
+ mask_rev[19] mask_rev[20] mask_rev[21] mask_rev[22] mask_rev[23] mask_rev[24] mask_rev[25]
+ mask_rev[26] mask_rev[27] mask_rev[28] mask_rev[29] mask_rev[30] mask_rev[31] vss
+ vdd user_id_programming
.ends

.subckt sg13cmos5l_IOPadVss vss vdd iovdd sg13cmos5l_DCNDiode_0/guard
Xsg13cmos5l_DCPDiode_0 vss iovdd vss vss sg13cmos5l_DCPDiode
Xsg13cmos5l_DCNDiode_0 vss vss sg13cmos5l_DCNDiode_0/guard vss sg13cmos5l_DCNDiode
.ends

.subckt sg13cmos5l_padframe gpio[38] gpio[39] gpio[40] gpio[5] gpio[10] gpio[11] gpio[16]
+ gpio[17] gpio[18] gpio[28] gpio[32] gpio[35] gpio[36] gpio[37] resetb_in flash_csb_in
+ flash_csb_ena flash_csb_out flash_clk_out flash_io0_in flash_io1_out gpio1_in gpio1_out
+ spi_SDO_in spi_SDI_in spi_SDI_ena spi_SDI_out spi_CSB_in spi_CSB_ena spi_CSB_out
+ spi_SCK_in UART_Rx_in UART_Rx_ena UART_Rx_out UART_Tx_out option_in flash_io2_in
+ flash_io2_out flash_io3_out analog_io_esd[0] analog_io_esd[1] analog_io_esd[2] analog_io_esd[3]
+ analog_io_esd[4] analog_io_esd[5] analog_io_esd[12] analog_io_esd[13] analog_io_esd[14]
+ analog_io_esd[15] analog_io_esd[17] analog_io_esd[18] analog_io_esd[19] analog_io_esd[21]
+ analog_io_esd[26] analog_io_esd[27] gpio[22] gpio[23] gpio[25] gpio[26] gpio[27]
+ flash_csb_zero flash_csb_one flash_clk_zero flash_clk_one flash_io0_zero flash_io0_one
+ flash_io1_zero flash_io1_one gpio0_zero gpio0_one gpio1_one spi_SDO_one spi_SCK_zero
+ UART_Rx_one UART_Tx_zero flash_io2_zero flash_io2_one flash_io3_zero flash_io3_one
+ mask_rev[7] mask_rev[8] mask_rev[9] mask_rev[10] mask_rev[11] mask_rev[12] mask_rev[13]
+ mask_rev[14] mask_rev[15] mask_rev[16] mask_rev[17] mask_rev[18] mask_rev[19] mask_rev[20]
+ mask_rev[21] mask_rev[22] mask_rev[23] mask_rev[24] mask_rev[25] mask_rev[26] mask_rev[30]
+ mask_rev[31] vddio vccd clock_in gpio[0] analog_io_esd[9] analog_io_esd[20] spi_SDO_zero
+ spi_SCK_ena analog_io_esd[8] gpio[2] spi_SDI_one analog_io_esd[25] spi_SDI_zero
+ spi_CSB_one analog_io_esd[7] flash_io1_in gpio[4] analog_io_esd[24] gpio[20] option
+ gpio[29] spi_CSB_zero gpio[8] analog_io_esd[6] spi_SCK_out gpio[6] analog_io_esd[23]
+ flash_io3_in gpio[1] gpio[41] mask_rev[27] flash_clk_ena UART_Tx_in gpio0_ena resetb
+ gpio[7] mask_rev[28] flash_io0_out gpio[14] spi_SDO_out flash_io3_ena gpio[15] gpio[24]
+ gpio[33] UART_Rx_zero gpio[42] spi_SDO_ena gpio[34] mask_rev[0] analog_io_esd[11]
+ mask_rev[29] gpio[31] gpio0_in mask_rev[1] gpio1_zero analog_io_esd[28] mask_rev[2]
+ gpio0_out gpio[12] gpio[21] gpio[30] analog_io_esd[22] mask_rev[3] flash_clk_in
+ UART_Tx_ena mask_rev[4] flash_io1_ena flash_io0_ena mask_rev[5] gpio[3] gpio[43]
+ gpio[13] UART_Tx_one analog_io_esd[16] spi_SCK_one gpio[9] flash_io2_ena mask_rev[6]
+ gpio[19] gpio1_ena vssd analog_io_esd[10]
Xpad_gpio_3 vccd vssd vddio spi_CSB_in gpio[3] vssd vddio spi_CSB_ena spi_CSB_out
+ vddio sg13cmos5l_IOPadInOut4mA
Xpad_gpio_4 vccd vssd vddio spi_SCK_in gpio[4] vssd vddio spi_SCK_ena spi_SCK_out
+ vddio sg13cmos5l_IOPadInOut4mA
Xconst_40 vccd flash_clk_zero flash_clk_one vssd constant_block_vrouted
Xpad_gpio_5 vccd vssd vddio UART_Rx_in gpio[5] vssd vddio UART_Rx_ena UART_Rx_out
+ vddio sg13cmos5l_IOPadInOut4mA
Xconst_41 vccd flash_io0_zero flash_io0_one vssd constant_block_vrouted
Xconst_0 vccd gpio1_zero gpio1_one vssd constant_block_hrouted
Xpad_gpio_6 vccd vssd vddio UART_Tx_in gpio[6] vssd vddio UART_Tx_ena UART_Tx_out
+ vddio sg13cmos5l_IOPadInOut4mA
Xpad_vssio_0 vssd vccd vddio vddio sg13cmos5l_IOPadIOVss
Xpad_gpio_7 vccd vssd vddio gpio[7] analog_io_esd[0] vddio vddio vssd sg13cmos5l_IOPadAnalog
Xconst_42 vccd flash_io1_zero flash_io1_one vssd constant_block_vrouted
Xconst_1 vccd spi_SDO_zero spi_SDO_one vssd constant_block_hrouted
Xpad_vssio_1 vssd vccd vddio vddio sg13cmos5l_IOPadIOVss
Xconst_43 vccd gpio0_zero gpio0_one vssd constant_block_vrouted
Xpad_gpio_8 vccd vssd vddio gpio[8] analog_io_esd[1] vddio vddio vssd sg13cmos5l_IOPadAnalog
Xconst_2 vccd spi_SDI_zero spi_SDI_one vssd constant_block_hrouted
Xpad_vssio_2 vssd vccd vddio vddio sg13cmos5l_IOPadIOVss
Xconst_3 vccd spi_CSB_zero spi_CSB_one vssd constant_block_hrouted
Xpad_vssio_3 vssd vccd vddio vddio sg13cmos5l_IOPadIOVss
Xpad_gpio_9 vccd vssd vddio gpio[9] analog_io_esd[2] vddio vddio vssd sg13cmos5l_IOPadAnalog
Xconst_4 vccd spi_SCK_zero spi_SCK_one vssd constant_block_hrouted
Xpad_vssio_4 vssd vccd vddio vddio sg13cmos5l_IOPadIOVss
Xconst_5 vccd UART_Rx_zero UART_Rx_one vssd constant_block_hrouted
Xpad_vssio_5 vssd vccd vddio vddio sg13cmos5l_IOPadIOVss
Xpad_vccd_0 vccd vssd vddio vddio vssd vddio sg13cmos5l_IOPadVdd
Xconst_36 vccd flash_io2_zero flash_io2_one vssd constant_block_hrouted
Xconst_6 vccd UART_Tx_zero UART_Tx_one vssd constant_block_hrouted
Xpad_vccd_1 vccd vssd vddio vddio vssd vddio sg13cmos5l_IOPadVdd
Xconst_37 vccd flash_io3_zero flash_io3_one vssd constant_block_hrouted
Xpad_vccd_2 vccd vssd vddio vddio vssd vddio sg13cmos5l_IOPadVdd
Xpad_vddio_0 vccd vssd vddio vssd sg13cmos5l_IOPadIOVdd
Xconst_39 vccd flash_csb_zero flash_csb_one vssd constant_block_vrouted
Xpad_option_0 vssd vccd vddio option_in option vddio sg13cmos5l_IOPadIn
Xpad_vddio_1 vccd vssd vddio vssd sg13cmos5l_IOPadIOVdd
Xproject_id mask_rev[0] mask_rev[1] mask_rev[2] mask_rev[3] mask_rev[4] mask_rev[5]
+ mask_rev[6] mask_rev[7] mask_rev[8] mask_rev[9] mask_rev[10] mask_rev[11] mask_rev[12]
+ mask_rev[13] mask_rev[14] mask_rev[15] mask_rev[16] mask_rev[17] mask_rev[18] mask_rev[19]
+ mask_rev[20] mask_rev[21] mask_rev[22] mask_rev[23] mask_rev[24] mask_rev[25] mask_rev[26]
+ mask_rev[27] mask_rev[28] mask_rev[29] mask_rev[30] mask_rev[31] vccd vssd user_id_routing
Xpad_vddio_2 vccd vssd vddio vssd sg13cmos5l_IOPadIOVdd
Xpad_vddio_3 vccd vssd vddio vssd sg13cmos5l_IOPadIOVdd
Xpad_vddio_4 vccd vssd vddio vssd sg13cmos5l_IOPadIOVdd
Xpad_vddio_5 vccd vssd vddio vssd sg13cmos5l_IOPadIOVdd
Xpad_resetb vssd vccd vddio resetb_in resetb vddio sg13cmos5l_IOPadIn
Xpad_gpio_40 vccd vssd vddio flash_clk_in gpio[40] vssd vddio flash_clk_ena flash_clk_out
+ vddio sg13cmos5l_IOPadInOut4mA
Xpad_gpio_30 vccd vssd vddio gpio[30] analog_io_esd[23] vddio vddio vssd sg13cmos5l_IOPadAnalog
Xpad_gpio_41 vccd vssd vddio flash_io0_in gpio[41] vssd vddio flash_io0_ena flash_io0_out
+ vddio sg13cmos5l_IOPadInOut4mA
Xpad_gpio_20 vccd vssd vddio gpio[20] analog_io_esd[13] vddio vddio vssd sg13cmos5l_IOPadAnalog
Xpad_gpio_31 vccd vssd vddio gpio[31] analog_io_esd[24] vddio vddio vssd sg13cmos5l_IOPadAnalog
Xpad_gpio_42 vccd vssd vddio flash_io1_in gpio[42] vssd vddio flash_io1_ena flash_io1_out
+ vddio sg13cmos5l_IOPadInOut4mA
Xpad_gpio_21 vccd vssd vddio gpio[21] analog_io_esd[14] vddio vddio vssd sg13cmos5l_IOPadAnalog
Xpad_gpio_10 vccd vssd vddio gpio[10] analog_io_esd[3] vddio vddio vssd sg13cmos5l_IOPadAnalog
Xpad_gpio_43 vccd vssd vddio gpio0_in gpio[43] vssd vddio gpio0_ena gpio0_out vddio
+ sg13cmos5l_IOPadInOut4mA
Xpad_gpio_32 vccd vssd vddio gpio[32] analog_io_esd[25] vddio vddio vssd sg13cmos5l_IOPadAnalog
Xpad_gpio_22 vccd vssd vddio gpio[22] analog_io_esd[15] vddio vddio vssd sg13cmos5l_IOPadAnalog
Xpad_gpio_11 vccd vssd vddio gpio[11] analog_io_esd[4] vddio vddio vssd sg13cmos5l_IOPadAnalog
Xpad_gpio_33 vccd vssd vddio gpio[33] analog_io_esd[26] vddio vddio vssd sg13cmos5l_IOPadAnalog
Xpad_gpio_23 vccd vssd vddio gpio[23] analog_io_esd[16] vddio vddio vssd sg13cmos5l_IOPadAnalog
Xpad_gpio_12 vccd vssd vddio gpio[12] analog_io_esd[5] vddio vddio vssd sg13cmos5l_IOPadAnalog
Xpad_gpio_34 vccd vssd vddio gpio[34] analog_io_esd[27] vddio vddio vssd sg13cmos5l_IOPadAnalog
Xpad_gpio_24 vccd vssd vddio gpio[24] analog_io_esd[17] vddio vddio vssd sg13cmos5l_IOPadAnalog
Xpad_gpio_13 vccd vssd vddio gpio[13] analog_io_esd[6] vddio vddio vssd sg13cmos5l_IOPadAnalog
Xpad_gpio_35 vccd vssd vddio gpio[35] analog_io_esd[28] vddio vddio vssd sg13cmos5l_IOPadAnalog
Xpad_gpio_14 vccd vssd vddio gpio[14] analog_io_esd[7] vddio vddio vssd sg13cmos5l_IOPadAnalog
Xpad_gpio_25 vccd vssd vddio gpio[25] analog_io_esd[18] vddio vddio vssd sg13cmos5l_IOPadAnalog
Xpad_vssd_0 vssd vccd vddio vddio sg13cmos5l_IOPadVss
Xpad_gpio_36 vccd vssd vddio flash_io2_in gpio[36] vssd vddio flash_io2_ena flash_io2_out
+ vddio sg13cmos5l_IOPadInOut4mA
Xpad_gpio_15 vccd vssd vddio gpio[15] analog_io_esd[8] vddio vddio vssd sg13cmos5l_IOPadAnalog
Xpad_gpio_26 vccd vssd vddio gpio[26] analog_io_esd[19] vddio vddio vssd sg13cmos5l_IOPadAnalog
Xpad_gpio_37 vccd vssd vddio flash_io3_in gpio[37] vssd vddio flash_io3_ena flash_io3_out
+ vddio sg13cmos5l_IOPadInOut4mA
Xpad_vssd_1 vssd vccd vddio vddio sg13cmos5l_IOPadVss
Xpad_gpio_16 vccd vssd vddio gpio[16] analog_io_esd[9] vddio vddio vssd sg13cmos5l_IOPadAnalog
Xpad_gpio_27 vccd vssd vddio gpio[27] analog_io_esd[20] vddio vddio vssd sg13cmos5l_IOPadAnalog
Xpad_gpio_38 vssd vccd vddio clock_in gpio[38] vddio sg13cmos5l_IOPadIn
Xpad_vssd_2 vssd vccd vddio vddio sg13cmos5l_IOPadVss
Xpad_gpio_17 vccd vssd vddio gpio[17] analog_io_esd[10] vddio vddio vssd sg13cmos5l_IOPadAnalog
Xpad_gpio_28 vccd vssd vddio gpio[28] analog_io_esd[21] vddio vddio vssd sg13cmos5l_IOPadAnalog
Xpad_gpio_39 vccd vssd vddio flash_csb_in gpio[39] vssd vddio flash_csb_ena flash_csb_out
+ vddio sg13cmos5l_IOPadInOut4mA
Xpad_gpio_18 vccd vssd vddio gpio[18] analog_io_esd[11] vddio vddio vssd sg13cmos5l_IOPadAnalog
Xpad_gpio_29 vccd vssd vddio gpio[29] analog_io_esd[22] vddio vddio vssd sg13cmos5l_IOPadAnalog
Xpad_gpio_19 vccd vssd vddio gpio[19] analog_io_esd[12] vddio vddio vssd sg13cmos5l_IOPadAnalog
Xpad_gpio_0 vccd vssd vddio gpio1_in gpio[0] vssd vddio gpio1_ena gpio1_out vddio
+ sg13cmos5l_IOPadInOut4mA
Xpad_gpio_1 vccd vssd vddio spi_SDO_in gpio[1] vssd vddio spi_SDO_ena spi_SDO_out
+ vddio sg13cmos5l_IOPadInOut4mA
Xpad_gpio_2 vccd vssd vddio spi_SDI_in gpio[2] vssd vddio spi_SDI_ena spi_SDI_out
+ vddio sg13cmos5l_IOPadInOut4mA
.ends

.subckt sg13cmos5l_antennanp A VDD VSS
X0 A VDD dpantenna l=1.34u w=1.05u
X1 VSS A dantenna l=0.78u w=0.78u
.ends

.subckt pnpMPA_9DZCCL C B E
X0 C B E pnpMPA a=1.4p p=5.4u
.ends

.subckt sg13_hv_pmos_DNCZKC D0 G0 S1 G1 w_n330_n224# a_138_n100#
X0 a_138_n100# G1 S1 w_n330_n224# sg13_hv_pmos ad=0.34p pd=2.68u as=0.19p ps=1.38u w=1u l=0.5u
X1 S1 G0 D0 w_n330_n224# sg13_hv_pmos ad=0.19p pd=1.38u as=0.34p ps=2.68u w=1u l=0.5u
.ends

.subckt sg13_hv_nmos_QHASHE D0 G0 S1 G1 a_138_n400# sub
X0 S1 G0 D0 sub sg13_hv_nmos ad=0.76p pd=4.38u as=1.36p ps=8.68u w=4u l=0.5u
X1 a_138_n400# G1 S1 sub sg13_hv_nmos ad=1.36p pd=8.68u as=0.76p ps=4.38u w=4u l=0.5u
.ends

.subckt sg13_hv_nmos_QBGVHE D0 G0 S1 G1 a_138_n100# sub
X0 a_138_n100# G1 S1 sub sg13_hv_nmos ad=0.34p pd=2.68u as=0.19p ps=1.38u w=1u l=0.5u
X1 S1 G0 D0 sub sg13_hv_nmos ad=0.19p pd=1.38u as=0.34p ps=2.68u w=1u l=0.5u
.ends

.subckt sg13_hv_pmos_ZPCZKC D0 G0 S1 G1 D2 S2 G2 w_n418_n324#
X0 S1 G0 D0 w_n418_n324# sg13_hv_pmos ad=0.38p pd=2.38u as=0.68p ps=4.68u w=2u l=0.5u
X1 S2 G2 D2 w_n418_n324# sg13_hv_pmos ad=0.68p pd=4.68u as=0.38p ps=2.38u w=2u l=0.5u
X2 D2 G1 S1 w_n418_n324# sg13_hv_pmos ad=0.38p pd=2.38u as=0.38p ps=2.38u w=2u l=0.5u
.ends

.subckt level_shift in_n in_p vdd out vss
Xsg13_hv_pmos_DNCZKC_0 XM2/G1 XM7/G0 vdd XM2/G1 vdd XM7/G0 sg13_hv_pmos_DNCZKC
XXM1 XM2/G1 in_p vss in_p XM2/G1 vss sg13_hv_nmos_QHASHE
XXM2 XM2/G1 XM7/G0 vdd XM2/G1 vdd XM7/G0 sg13_hv_pmos_DNCZKC
XXM3 XM7/G0 in_n vss in_n XM7/G0 vss sg13_hv_nmos_QHASHE
XXM6 vss XM7/G0 XM7/G2 XM7/G0 vss vss sg13_hv_nmos_QBGVHE
XXM7 XM7/G2 XM7/G0 vdd XM7/G2 out vdd XM7/G2 vdd sg13_hv_pmos_ZPCZKC
Xsg13_hv_nmos_QBGVHE_0 vss XM7/G2 out XM7/G2 vss vss sg13_hv_nmos_QBGVHE
Xsg13_hv_nmos_QBGVHE_1 vss XM7/G2 out XM7/G2 vss vss sg13_hv_nmos_QBGVHE
Xsg13_hv_pmos_ZPCZKC_0 XM7/G2 XM7/G0 vdd XM7/G2 out vdd XM7/G2 vdd sg13_hv_pmos_ZPCZKC
.ends

.subckt sg13_hv_pmos_NNMDLU D0 S0 G0 D1 S1 G1 D2 S2 G2 D3 S3 G3 w_n292_n2006#
X0 S2 G2 D2 w_n292_n2006# sg13_hv_pmos ad=1.36p pd=8.68u as=1.36p ps=8.68u w=4u l=1u
X1 S1 G1 D1 w_n292_n2006# sg13_hv_pmos ad=1.36p pd=8.68u as=1.36p ps=8.68u w=4u l=1u
X2 S0 G0 D0 w_n292_n2006# sg13_hv_pmos ad=1.36p pd=8.68u as=1.36p ps=8.68u w=4u l=1u
X3 S3 G3 D3 w_n292_n2006# sg13_hv_pmos ad=1.36p pd=8.68u as=1.36p ps=8.68u w=4u l=1u
.ends

.subckt sg13_hv_pmos_ZKTCY2 D0 S0 G0 D1 S1 G1 D2 S2 G2 D3 S3 G3 D4 S4 G4 D5 S5 G5
+ D6 S6 G6 D7 S7 G7 D8 S8 G8 D9 S9 G9 D10 S10 G10 D11 S11 G11 D12 S12 G12 D13 S13
+ G13 D14 S14 G14 D15 S15 G15 w_n3127_n224#
X0 D7 G7 S7 w_n3127_n224# sg13_hv_pmos ad=0.34p pd=2.68u as=0.34p ps=2.68u w=1u l=1u
X1 D15 G15 S15 w_n3127_n224# sg13_hv_pmos ad=0.34p pd=2.68u as=0.34p ps=2.68u w=1u l=1u
X2 S8 G8 D8 w_n3127_n224# sg13_hv_pmos ad=0.34p pd=2.68u as=0.34p ps=2.68u w=1u l=1u
X3 S14 G14 D14 w_n3127_n224# sg13_hv_pmos ad=0.34p pd=2.68u as=0.34p ps=2.68u w=1u l=1u
X4 S0 G0 D0 w_n3127_n224# sg13_hv_pmos ad=0.34p pd=2.68u as=0.34p ps=2.68u w=1u l=1u
X5 D1 G1 S1 w_n3127_n224# sg13_hv_pmos ad=0.34p pd=2.68u as=0.34p ps=2.68u w=1u l=1u
X6 S2 G2 D2 w_n3127_n224# sg13_hv_pmos ad=0.34p pd=2.68u as=0.34p ps=2.68u w=1u l=1u
X7 D13 G13 S13 w_n3127_n224# sg13_hv_pmos ad=0.34p pd=2.68u as=0.34p ps=2.68u w=1u l=1u
X8 S10 G10 D10 w_n3127_n224# sg13_hv_pmos ad=0.34p pd=2.68u as=0.34p ps=2.68u w=1u l=1u
X9 S12 G12 D12 w_n3127_n224# sg13_hv_pmos ad=0.34p pd=2.68u as=0.34p ps=2.68u w=1u l=1u
X10 D9 G9 S9 w_n3127_n224# sg13_hv_pmos ad=0.34p pd=2.68u as=0.34p ps=2.68u w=1u l=1u
X11 D11 G11 S11 w_n3127_n224# sg13_hv_pmos ad=0.34p pd=2.68u as=0.34p ps=2.68u w=1u l=1u
X12 D3 G3 S3 w_n3127_n224# sg13_hv_pmos ad=0.34p pd=2.68u as=0.34p ps=2.68u w=1u l=1u
X13 S4 G4 D4 w_n3127_n224# sg13_hv_pmos ad=0.34p pd=2.68u as=0.34p ps=2.68u w=1u l=1u
X14 D5 G5 S5 w_n3127_n224# sg13_hv_pmos ad=0.34p pd=2.68u as=0.34p ps=2.68u w=1u l=1u
X15 S6 G6 D6 w_n3127_n224# sg13_hv_pmos ad=0.34p pd=2.68u as=0.34p ps=2.68u w=1u l=1u
.ends

.subckt sg13_hv_pmos_NWNELU D0_0 S0_0 G0_0 D0_1 S0_1 G0_1 D0_2 S0_2 G0_2 D0_3 S0_3
+ G0_3 D1_0 S1_0 G1_0 D1_1 S1_1 G1_1 D1_2 S1_2 G1_2 D1_3 S1_3 G1_3 w_n481_n2006#
X0 S0_0 G0_0 D0_0 w_n481_n2006# sg13_hv_pmos ad=1.36p pd=8.68u as=1.36p ps=8.68u w=4u l=1u
X1 S0_2 G0_2 D0_2 w_n481_n2006# sg13_hv_pmos ad=1.36p pd=8.68u as=1.36p ps=8.68u w=4u l=1u
X2 S0_1 G0_1 D0_1 w_n481_n2006# sg13_hv_pmos ad=1.36p pd=8.68u as=1.36p ps=8.68u w=4u l=1u
X3 D1_1 G1_1 S1_1 w_n481_n2006# sg13_hv_pmos ad=1.36p pd=8.68u as=1.36p ps=8.68u w=4u l=1u
X4 D1_0 G1_0 S1_0 w_n481_n2006# sg13_hv_pmos ad=1.36p pd=8.68u as=1.36p ps=8.68u w=4u l=1u
X5 D1_2 G1_2 S1_2 w_n481_n2006# sg13_hv_pmos ad=1.36p pd=8.68u as=1.36p ps=8.68u w=4u l=1u
X6 D1_3 G1_3 S1_3 w_n481_n2006# sg13_hv_pmos ad=1.36p pd=8.68u as=1.36p ps=8.68u w=4u l=1u
X7 S0_3 G0_3 D0_3 w_n481_n2006# sg13_hv_pmos ad=1.36p pd=8.68u as=1.36p ps=8.68u w=4u l=1u
.ends

.subckt sg13_hv_nmos_XAAXMC D0 S0 G0 D1 S1 G1 D2 S2 G2 D3 S3 G3 D4 S4 G4 D5 S5 G5
+ D6 S6 G6 D7 S7 G7 D8 S8 G8 D9 S9 G9 D10 S10 G10 D11 S11 G11 D12 S12 G12 D13 S13
+ G13 D14 S14 G14 D15 S15 G15 sub
X0 D15 G15 S15 sub sg13_hv_nmos ad=0.34p pd=2.68u as=0.34p ps=2.68u w=1u l=1u
X1 S8 G8 D8 sub sg13_hv_nmos ad=0.34p pd=2.68u as=0.34p ps=2.68u w=1u l=1u
X2 S14 G14 D14 sub sg13_hv_nmos ad=0.34p pd=2.68u as=0.34p ps=2.68u w=1u l=1u
X3 S0 G0 D0 sub sg13_hv_nmos ad=0.34p pd=2.68u as=0.34p ps=2.68u w=1u l=1u
X4 D1 G1 S1 sub sg13_hv_nmos ad=0.34p pd=2.68u as=0.34p ps=2.68u w=1u l=1u
X5 S2 G2 D2 sub sg13_hv_nmos ad=0.34p pd=2.68u as=0.34p ps=2.68u w=1u l=1u
X6 D13 G13 S13 sub sg13_hv_nmos ad=0.34p pd=2.68u as=0.34p ps=2.68u w=1u l=1u
X7 S10 G10 D10 sub sg13_hv_nmos ad=0.34p pd=2.68u as=0.34p ps=2.68u w=1u l=1u
X8 S12 G12 D12 sub sg13_hv_nmos ad=0.34p pd=2.68u as=0.34p ps=2.68u w=1u l=1u
X9 D9 G9 S9 sub sg13_hv_nmos ad=0.34p pd=2.68u as=0.34p ps=2.68u w=1u l=1u
X10 D11 G11 S11 sub sg13_hv_nmos ad=0.34p pd=2.68u as=0.34p ps=2.68u w=1u l=1u
X11 D3 G3 S3 sub sg13_hv_nmos ad=0.34p pd=2.68u as=0.34p ps=2.68u w=1u l=1u
X12 S4 G4 D4 sub sg13_hv_nmos ad=0.34p pd=2.68u as=0.34p ps=2.68u w=1u l=1u
X13 D5 G5 S5 sub sg13_hv_nmos ad=0.34p pd=2.68u as=0.34p ps=2.68u w=1u l=1u
X14 S6 G6 D6 sub sg13_hv_nmos ad=0.34p pd=2.68u as=0.34p ps=2.68u w=1u l=1u
X15 D7 G7 S7 sub sg13_hv_nmos ad=0.34p pd=2.68u as=0.34p ps=2.68u w=1u l=1u
.ends

.subckt sg13_hv_nmos_TYJME3 D0 S0 G0 D1 S1 G1 D2 S2 G2 D3 S3 G3 D4 S4 G4 D5 S5 G5
+ D6 S6 G6 D7 S7 G7 sub
X0 S4 G4 D4 sub sg13_hv_nmos ad=0.34p pd=2.68u as=0.34p ps=2.68u w=1u l=4u
X1 S0 G0 D0 sub sg13_hv_nmos ad=0.34p pd=2.68u as=0.34p ps=2.68u w=1u l=4u
X2 D1 G1 S1 sub sg13_hv_nmos ad=0.34p pd=2.68u as=0.34p ps=2.68u w=1u l=4u
X3 D3 G3 S3 sub sg13_hv_nmos ad=0.34p pd=2.68u as=0.34p ps=2.68u w=1u l=4u
X4 S2 G2 D2 sub sg13_hv_nmos ad=0.34p pd=2.68u as=0.34p ps=2.68u w=1u l=4u
X5 D7 G7 S7 sub sg13_hv_nmos ad=0.34p pd=2.68u as=0.34p ps=2.68u w=1u l=4u
X6 S6 G6 D6 sub sg13_hv_nmos ad=0.34p pd=2.68u as=0.34p ps=2.68u w=1u l=4u
X7 D5 G5 S5 sub sg13_hv_nmos ad=0.34p pd=2.68u as=0.34p ps=2.68u w=1u l=4u
.ends

.subckt sg13_hv_pmos_H5F6DG D0_0 S0_0 G0_0 D0_1 S0_1 G0_1 D1_0 S1_0 G1_0 D1_1 S1_1
+ G1_1 w_n1081_n618#
X0 S0_0 G0_0 D0_0 w_n1081_n618# sg13_hv_pmos ad=0.68p pd=4.68u as=0.68p ps=4.68u w=2u l=4u
X1 D1_1 G1_1 S1_1 w_n1081_n618# sg13_hv_pmos ad=0.68p pd=4.68u as=0.68p ps=4.68u w=2u l=4u
X2 D1_0 G1_0 S1_0 w_n1081_n618# sg13_hv_pmos ad=0.68p pd=4.68u as=0.68p ps=4.68u w=2u l=4u
X3 S0_1 G0_1 D0_1 w_n1081_n618# sg13_hv_pmos ad=0.68p pd=4.68u as=0.68p ps=4.68u w=2u l=4u
.ends

.subckt sg13_hv_pmos_HLS6DG D0 S0 G0 D1 S1 G1 D2 S2 G2 D3 S3 G3 D4 S4 G4 D5 S5 G5
+ D6 S6 G6 D7 S7 G7 w_n4015_n324#
X0 S2 G2 D2 w_n4015_n324# sg13_hv_pmos ad=0.68p pd=4.68u as=0.68p ps=4.68u w=2u l=4u
X1 D1 G1 S1 w_n4015_n324# sg13_hv_pmos ad=0.68p pd=4.68u as=0.68p ps=4.68u w=2u l=4u
X2 S0 G0 D0 w_n4015_n324# sg13_hv_pmos ad=0.68p pd=4.68u as=0.68p ps=4.68u w=2u l=4u
X3 D3 G3 S3 w_n4015_n324# sg13_hv_pmos ad=0.68p pd=4.68u as=0.68p ps=4.68u w=2u l=4u
X4 S4 G4 D4 w_n4015_n324# sg13_hv_pmos ad=0.68p pd=4.68u as=0.68p ps=4.68u w=2u l=4u
X5 D5 G5 S5 w_n4015_n324# sg13_hv_pmos ad=0.68p pd=4.68u as=0.68p ps=4.68u w=2u l=4u
X6 S6 G6 D6 w_n4015_n324# sg13_hv_pmos ad=0.68p pd=4.68u as=0.68p ps=4.68u w=2u l=4u
X7 D7 G7 S7 w_n4015_n324# sg13_hv_pmos ad=0.68p pd=4.68u as=0.68p ps=4.68u w=2u l=4u
.ends

.subckt sg13_hv_pmos_NQUDLU D0 S0 G0 D1 S1 G1 D2 S2 G2 D3 S3 G3 w_n859_n224#
X0 D1 G1 S1 w_n859_n224# sg13_hv_pmos ad=0.34p pd=2.68u as=0.34p ps=2.68u w=1u l=1u
X1 S2 G2 D2 w_n859_n224# sg13_hv_pmos ad=0.34p pd=2.68u as=0.34p ps=2.68u w=1u l=1u
X2 D3 G3 S3 w_n859_n224# sg13_hv_pmos ad=0.34p pd=2.68u as=0.34p ps=2.68u w=1u l=1u
X3 S0 G0 D0 w_n859_n224# sg13_hv_pmos ad=0.34p pd=2.68u as=0.34p ps=2.68u w=1u l=1u
.ends

.subckt sg13_hv_nmos_TGUME3 D0_0 S0_0 G0_0 D0_1 S0_1 G0_1 D1_0 S1_0 G1_0 D1_1 S1_1
+ G1_1 sub
X0 D1_0 G1_0 S1_0 sub sg13_hv_nmos ad=0.34p pd=2.68u as=0.34p ps=2.68u w=1u l=4u
X1 D1_1 G1_1 S1_1 sub sg13_hv_nmos ad=0.34p pd=2.68u as=0.34p ps=2.68u w=1u l=4u
X2 S0_1 G0_1 D0_1 sub sg13_hv_nmos ad=0.34p pd=2.68u as=0.34p ps=2.68u w=1u l=4u
X3 S0_0 G0_0 D0_0 sub sg13_hv_nmos ad=0.34p pd=2.68u as=0.34p ps=2.68u w=1u l=4u
.ends

.subckt sg13_hv_nmos_BE9VUZ D0_0 S0_0 G0_0 D0_1 S0_1 G0_1 D1_0 S1_0 G1_0 D1_1 S1_1
+ G1_1 sub
X0 D1_0 G1_0 S1_0 sub sg13_hv_nmos ad=0.34p pd=2.68u as=0.34p ps=2.68u w=1u l=1u
X1 S0_1 G0_1 D0_1 sub sg13_hv_nmos ad=0.34p pd=2.68u as=0.34p ps=2.68u w=1u l=1u
X2 S0_0 G0_0 D0_0 sub sg13_hv_nmos ad=0.34p pd=2.68u as=0.34p ps=2.68u w=1u l=1u
X3 D1_1 G1_1 S1_1 sub sg13_hv_nmos ad=0.34p pd=2.68u as=0.34p ps=2.68u w=1u l=1u
.ends

.subckt sg13_hv_nmos_BEMUUZ D0_0 S0_0 G0_0 D0_1 S0_1 G0_1 D1_0 S1_0 G1_0 D1_1 S1_1
+ G1_1 D2_0 S2_0 G2_0 D2_1 S2_1 G2_1 sub
X0 D1_0 G1_0 S1_0 sub sg13_hv_nmos ad=0.34p pd=2.68u as=0.34p ps=2.68u w=1u l=1u
X1 D1_1 G1_1 S1_1 sub sg13_hv_nmos ad=0.34p pd=2.68u as=0.34p ps=2.68u w=1u l=1u
X2 S0_0 G0_0 D0_0 sub sg13_hv_nmos ad=0.34p pd=2.68u as=0.34p ps=2.68u w=1u l=1u
X3 S2_1 G2_1 D2_1 sub sg13_hv_nmos ad=0.34p pd=2.68u as=0.34p ps=2.68u w=1u l=1u
X4 S0_1 G0_1 D0_1 sub sg13_hv_nmos ad=0.34p pd=2.68u as=0.34p ps=2.68u w=1u l=1u
X5 S2_0 G2_0 D2_0 sub sg13_hv_nmos ad=0.34p pd=2.68u as=0.34p ps=2.68u w=1u l=1u
.ends

.subckt sg13_hv_pmos_N8UDLU D0 S0 G0 D1 S1 G1 w_n481_n224#
X0 S0 G0 D0 w_n481_n224# sg13_hv_pmos ad=0.34p pd=2.68u as=0.34p ps=2.68u w=1u l=1u
X1 D1 G1 S1 w_n481_n224# sg13_hv_pmos ad=0.34p pd=2.68u as=0.34p ps=2.68u w=1u l=1u
.ends

.subckt sg13_hv_nmos_BEDTUZ D0_0 S0_0 G0_0 D0_1 S0_1 G0_1 D1_0 S1_0 G1_0 D1_1 S1_1
+ G1_1 D2_0 S2_0 G2_0 D2_1 S2_1 G2_1 D3_0 S3_0 G3_0 D3_1 S3_1 G3_1 D4_0 S4_0 G4_0
+ D4_1 S4_1 G4_1 sub
X0 S2_0 G2_0 D2_0 sub sg13_hv_nmos ad=0.34p pd=2.68u as=0.34p ps=2.68u w=1u l=1u
X1 S2_1 G2_1 D2_1 sub sg13_hv_nmos ad=0.34p pd=2.68u as=0.34p ps=2.68u w=1u l=1u
X2 S4_1 G4_1 D4_1 sub sg13_hv_nmos ad=0.34p pd=2.68u as=0.34p ps=2.68u w=1u l=1u
X3 S0_1 G0_1 D0_1 sub sg13_hv_nmos ad=0.34p pd=2.68u as=0.34p ps=2.68u w=1u l=1u
X4 D1_0 G1_0 S1_0 sub sg13_hv_nmos ad=0.34p pd=2.68u as=0.34p ps=2.68u w=1u l=1u
X5 S0_0 G0_0 D0_0 sub sg13_hv_nmos ad=0.34p pd=2.68u as=0.34p ps=2.68u w=1u l=1u
X6 D3_1 G3_1 S3_1 sub sg13_hv_nmos ad=0.34p pd=2.68u as=0.34p ps=2.68u w=1u l=1u
X7 D1_1 G1_1 S1_1 sub sg13_hv_nmos ad=0.34p pd=2.68u as=0.34p ps=2.68u w=1u l=1u
X8 D3_0 G3_0 S3_0 sub sg13_hv_nmos ad=0.34p pd=2.68u as=0.34p ps=2.68u w=1u l=1u
X9 S4_0 G4_0 D4_0 sub sg13_hv_nmos ad=0.34p pd=2.68u as=0.34p ps=2.68u w=1u l=1u
.ends

.subckt se_folded_cascode_p out bias ena_b inn inp vdd vss
XXM3DUM vdd vdd vdd vdd vdd vdd vdd vdd vdd vdd vdd vdd vdd sg13_hv_pmos_NNMDLU
XXM1 vdd XM1/S8 vbp1 XM1/S8 vdd vbp1 vdd XM1/S8 vbp1 XM1/S8 vdd vbp1 vdd XM1/S8 vbp1
+ XM1/S8 vdd vbp1 vdd XM1/S8 vbp1 XM1/S8 vdd vbp1 vdd XM1/S8 vbp1 XM1/S8 vdd vbp1
+ vdd XM1/S8 vbp1 XM1/S8 vdd vbp1 vdd XM1/S8 vbp1 XM1/S8 vdd vbp1 vdd XM1/S8 vbp1
+ XM1/S8 vdd vbp1 vdd sg13_hv_pmos_ZKTCY2
XXM2 XM1/S8 out1n inp XM1/S8 out1p inn XM1/S8 out1n inp XM1/S8 out1p inn out1p XM1/S8
+ inn out1n XM1/S8 inp out1p XM1/S8 inn out1n XM1/S8 inp vdd sg13_hv_pmos_NWNELU
XXM3 XM1/S8 out1n inp XM1/S8 out1p inn XM1/S8 out1n inp XM1/S8 out1p inn out1p XM1/S8
+ inn out1n XM1/S8 inp out1p XM1/S8 inn out1n XM1/S8 inp vdd sg13_hv_pmos_NWNELU
XXM4 vss out1p vbn1 out1n vss vbn1 vss out1p vbn1 out1n vss vbn1 vss out1p vbn1 out1n
+ vss vbn1 vss out1p vbn1 out1n vss vbn1 vss out1p vbn1 out1n vss vbn1 vss out1p vbn1
+ out1n vss vbn1 vss out1p vbn1 out1n vss vbn1 vss out1p vbn1 out1n vss vbn1 vss sg13_hv_nmos_XAAXMC
XXM5 vss out1n vbn1 out1p vss vbn1 vss out1n vbn1 out1p vss vbn1 vss out1n vbn1 out1p
+ vss vbn1 vss out1n vbn1 out1p vss vbn1 vss out1n vbn1 out1p vss vbn1 vss out1n vbn1
+ out1p vss vbn1 vss out1n vbn1 out1p vss vbn1 vss out1n vbn1 out1p vss vbn1 vss sg13_hv_nmos_XAAXMC
XXM6 out1n XM9/S6 vbn2 out out1p vbn2 out1n XM9/S6 vbn2 out out1p vbn2 out1n XM9/S6
+ vbn2 out out1p vbn2 out1n XM9/S6 vbn2 out out1p vbn2 vss sg13_hv_nmos_TYJME3
XXM7 out1p out vbn2 XM9/S6 out1n vbn2 out1p out vbn2 XM9/S6 out1n vbn2 out1p out vbn2
+ XM9/S6 out1n vbn2 out1p out vbn2 XM9/S6 out1n vbn2 vss sg13_hv_nmos_TYJME3
XXMB1 vbp2 vbp1 vbp2 vbp2 vbp1 vbp2 vbp1 vbp2 vbp2 vbp1 vbp2 vbp2 vdd sg13_hv_pmos_H5F6DG
XXM8 XM9/S7 out vbp2 XM9/S6 XM9/D6 vbp2 XM9/S7 out vbp2 XM9/S6 XM9/D6 vbp2 XM9/S7
+ out vbp2 XM9/S6 XM9/D6 vbp2 XM9/S7 out vbp2 XM9/S6 XM9/D6 vbp2 vdd sg13_hv_pmos_HLS6DG
XXMB2 vdd vbp1 vbp1 vbn2 vdd vbp1 vdd vbp1 vbp1 vbn2 vdd vbp1 vdd sg13_hv_pmos_NQUDLU
XXM9 XM9/D6 XM9/S6 vbp2 out XM9/S7 vbp2 XM9/D6 XM9/S6 vbp2 out XM9/S7 vbp2 XM9/D6
+ XM9/S6 vbp2 out XM9/S7 vbp2 XM9/D6 XM9/S6 vbp2 out XM9/S7 vbp2 vdd sg13_hv_pmos_HLS6DG
XXMB3 vdd vbp1 vbp1 vbn2 vdd vbp1 vdd vbp1 vbp1 vbn2 vdd vbp1 vdd sg13_hv_pmos_NQUDLU
XXMB4 vbn2 vbn1 vbn2 vbn2 vbn1 vbn2 vbn1 vbn2 vbn2 vbn1 vbn2 vbn2 vss sg13_hv_nmos_TGUME3
XXMB5 vss vss vss vss vss vss vss vss vss vss vss vss vss sg13_hv_nmos_BE9VUZ
XXMB5DUM vss vbn1 vbn1 vss vbn1 vbn1 vbn1 vss vbn1 vbn1 vss vbn1 vss vss vss vss vss
+ vss vss sg13_hv_nmos_BEMUUZ
XXM1DUM vdd vdd vdd vdd vdd vdd vdd sg13_hv_pmos_N8UDLU
XXMB6 vbp2 bias ena_b vbp2 bias ena_b bias vbp2 ena_b bias vbp2 ena_b vdd sg13_hv_pmos_H5F6DG
XXM4DUM vss vss vss vss vss vss vss vss vss vss vss vss vss vss vss vss vss vss vss
+ vss vss vss vss vss vss vss vss vss vss vss vss sg13_hv_nmos_BEDTUZ
XXM10 XM9/S7 vdd XM9/S6 vdd XM9/D6 XM9/S6 XM9/S7 vdd XM9/S6 vdd XM9/D6 XM9/S6 XM9/S7
+ vdd XM9/S6 vdd XM9/D6 XM9/S6 XM9/S7 vdd XM9/S6 vdd XM9/D6 XM9/S6 vdd sg13_hv_pmos_HLS6DG
XXM2DUM vdd vdd vdd vdd vdd vdd vdd vdd vdd vdd vdd vdd vdd sg13_hv_pmos_NNMDLU
XXM11 XM9/D6 vdd XM9/S6 vdd XM9/S7 XM9/S6 XM9/D6 vdd XM9/S6 vdd XM9/S7 XM9/S6 XM9/D6
+ vdd XM9/S6 vdd XM9/S7 XM9/S6 XM9/D6 vdd XM9/S6 vdd XM9/S7 XM9/S6 vdd sg13_hv_pmos_HLS6DG
.ends

.subckt sg13cmos5l_inv_2 Y A VDD VSS
X0 Y A VSS VSS sg13_lv_nmos ad=0.1406p pd=1.12u as=0.2516p ps=2.16u w=0.74u l=0.13u
X1 Y A VDD VDD sg13_lv_pmos ad=0.2128p pd=1.5u as=0.3808p ps=2.92u w=1.12u l=0.13u
X2 VSS A Y VSS sg13_lv_nmos ad=0.2516p pd=2.16u as=0.1406p ps=1.12u w=0.74u l=0.13u
X3 VDD A Y VDD sg13_lv_pmos ad=0.3864p pd=2.93u as=0.2128p ps=1.5u w=1.12u l=0.13u
.ends

.subckt rhigh_SUDY2Y R1 R2 sub
X0 R1 R2 sub rhigh l=20u w=0.69u
.ends

.subckt bg_res b a d c vss e f g h j k
XXR1[0] k j vss rhigh_SUDY2Y
XXR1[1] XR1[3]/R1 a vss rhigh_SUDY2Y
XXR1[2] XR1[4]/R1 b vss rhigh_SUDY2Y
XXR1[3] XR1[3]/R1 XR1[5]/R2 vss rhigh_SUDY2Y
XXR1[4] XR1[4]/R1 XR1[6]/R2 vss rhigh_SUDY2Y
XXR1[5] XR1[7]/R1 XR1[5]/R2 vss rhigh_SUDY2Y
XXR1[6] XR1[8]/R1 XR1[6]/R2 vss rhigh_SUDY2Y
XXR1[7] XR1[7]/R1 XR1[9]/R2 vss rhigh_SUDY2Y
XXR1[8] XR1[8]/R1 XR1[8]/R2 vss rhigh_SUDY2Y
XXR1[9] XR1[9]/R1 XR1[9]/R2 vss rhigh_SUDY2Y
XXR1[10] XR1[12]/R1 XR1[8]/R2 vss rhigh_SUDY2Y
XXR1[11] XR1[9]/R1 XR1[13]/R2 vss rhigh_SUDY2Y
XXR1[12] XR1[12]/R1 XR1[14]/R2 vss rhigh_SUDY2Y
XXR1[13] XR1[15]/R1 XR1[13]/R2 vss rhigh_SUDY2Y
XXR1[14] XR1[16]/R1 XR1[14]/R2 vss rhigh_SUDY2Y
XXR1[15] XR1[15]/R1 XR1[17]/R2 vss rhigh_SUDY2Y
XXR1[16] XR1[16]/R1 XR1[18]/R2 vss rhigh_SUDY2Y
XXR1[17] XR1[19]/R1 XR1[17]/R2 vss rhigh_SUDY2Y
XXR1[18] XR1[20]/R1 XR1[18]/R2 vss rhigh_SUDY2Y
XXR1[19] XR1[19]/R1 c vss rhigh_SUDY2Y
XXR1[20] XR1[20]/R1 d vss rhigh_SUDY2Y
XXR1[21] f e vss rhigh_SUDY2Y
XXR1[22] h g vss rhigh_SUDY2Y
.ends

.subckt sg13_hv_pmos_NWA9LU D0 S0 G0 D1 S1 G1 w_n481_n524#
X0 D1 G1 S1 w_n481_n524# sg13_hv_pmos ad=1.36p pd=8.68u as=1.36p ps=8.68u w=4u l=1u
X1 S0 G0 D0 w_n481_n524# sg13_hv_pmos ad=1.36p pd=8.68u as=1.36p ps=8.68u w=4u l=1u
.ends

.subckt sg13_hv_nmos_BEVMZW D S G sub
X0 S G D sub sg13_hv_nmos ad=0.34p pd=2.68u as=0.34p ps=2.68u w=1u l=1u
.ends

.subckt sg13_hv_pmos_WYN5QB D S G w_n292_n224#
X0 S G D w_n292_n224# sg13_hv_pmos ad=0.34p pd=2.68u as=0.34p ps=2.68u w=1u l=1u
.ends

.subckt capacitor_KFUPMY c1 c2
C0 c1 c2 1.6871p
.ends

.subckt capacitor_BC6V6V c1 c2
C0 c1 c2 0.20319p
.ends

.subckt sg13_hv_nmos_2UD3QN D S G sub
X0 S G D sub sg13_hv_nmos ad=0.68p pd=4.68u as=0.68p ps=4.68u w=2u l=0.5u
.ends

.subckt rhigh_EDTASR R1 R2 sub
X0 R1 R2 sub rhigh l=3.4u w=1.41u
.ends

.subckt bg_trim top bot ctrl[15] ctrl[14] ctrl[13] ctrl[12] ctrl[11] ctrl[10] ctrl[9]
+ ctrl[8] ctrl[7] ctrl[6] ctrl[5] ctrl[4] ctrl[3] ctrl[2] ctrl[1] ctrl[0] vss
XXM0[0] vss vss vss vss sg13_hv_nmos_2UD3QN
XXM0[1] bot XM0[1]/S ctrl[0] vss sg13_hv_nmos_2UD3QN
XXM0[2] bot XM0[2]/S ctrl[1] vss sg13_hv_nmos_2UD3QN
XXM0[3] bot XM0[3]/S ctrl[2] vss sg13_hv_nmos_2UD3QN
XXM0[4] bot XM0[4]/S ctrl[3] vss sg13_hv_nmos_2UD3QN
XXM0[5] bot XM0[5]/S ctrl[4] vss sg13_hv_nmos_2UD3QN
XXM0[6] bot XM0[6]/S ctrl[5] vss sg13_hv_nmos_2UD3QN
XXM0[7] bot XM0[7]/S ctrl[6] vss sg13_hv_nmos_2UD3QN
XXM0[8] bot XM0[8]/S ctrl[7] vss sg13_hv_nmos_2UD3QN
XXM0[9] bot XM0[9]/S ctrl[8] vss sg13_hv_nmos_2UD3QN
XXM0[10] bot XM0[10]/S ctrl[9] vss sg13_hv_nmos_2UD3QN
XXM0[11] bot XM0[11]/S ctrl[10] vss sg13_hv_nmos_2UD3QN
XXM0[12] bot XM0[12]/S ctrl[11] vss sg13_hv_nmos_2UD3QN
XXM0[13] bot XM0[13]/S ctrl[12] vss sg13_hv_nmos_2UD3QN
XXM0[14] bot XM0[14]/S ctrl[13] vss sg13_hv_nmos_2UD3QN
XXM0[15] bot XM0[15]/S ctrl[14] vss sg13_hv_nmos_2UD3QN
XXM0[16] bot top ctrl[15] vss sg13_hv_nmos_2UD3QN
XXM0[17] vss vss vss vss sg13_hv_nmos_2UD3QN
XXR15[0] vss vss vss rhigh_EDTASR
XXR15[1] XM0[1]/S bot vss rhigh_EDTASR
XXR15[2] XM0[2]/S XM0[1]/S vss rhigh_EDTASR
XXR15[3] XM0[3]/S XM0[2]/S vss rhigh_EDTASR
XXR15[4] XM0[4]/S XM0[3]/S vss rhigh_EDTASR
XXR15[5] XM0[5]/S XM0[4]/S vss rhigh_EDTASR
XXR15[6] XM0[6]/S XM0[5]/S vss rhigh_EDTASR
XXR15[7] XM0[7]/S XM0[6]/S vss rhigh_EDTASR
XXR15[8] XM0[8]/S XM0[7]/S vss rhigh_EDTASR
XXR15[9] XM0[9]/S XM0[8]/S vss rhigh_EDTASR
XXR15[10] XM0[10]/S XM0[9]/S vss rhigh_EDTASR
XXR15[11] XM0[11]/S XM0[10]/S vss rhigh_EDTASR
XXR15[12] XM0[12]/S XM0[11]/S vss rhigh_EDTASR
XXR15[13] XM0[13]/S XM0[12]/S vss rhigh_EDTASR
XXR15[14] XM0[14]/S XM0[13]/S vss rhigh_EDTASR
XXR15[15] XM0[15]/S XM0[14]/S vss rhigh_EDTASR
XXR15[16] top XM0[15]/S vss rhigh_EDTASR
XXR15[17] top top vss rhigh_EDTASR
.ends

.subckt capacitor_SURZLD c1 c2
C0 c1 c2 0.44032p
.ends

.subckt bandgap_unbuffered vbg bias trim[15] trim[14] trim[13] trim[11] trim[10] trim[9]
+ trim[8] trim[7] trim[6] trim[5] trim[4] trim[3] trim[2] trim[1] trim[0] dvdd ena
+ ena_b_h trim[12] dvss vdd vss
Xsg13cmos5l_antennanp_16 ena dvdd dvss sg13cmos5l_antennanp
XXQ2_1 vss vss xtr/bot pnpMPA_9DZCCL
Xx1[0] ena x1[0]/in_p vdd ena_b_h vss level_shift
Xx1[1] x1[1]/in_n trim[15] vdd x1[1]/out vss level_shift
Xx1[2] x1[2]/in_n trim[13] vdd x1[2]/out vss level_shift
Xx1[3] x1[3]/in_n trim[11] vdd x1[3]/out vss level_shift
Xx1[4] x1[4]/in_n trim[9] vdd x1[4]/out vss level_shift
Xx1[5] x1[5]/in_n trim[7] vdd x1[5]/out vss level_shift
Xx1[6] x1[6]/in_n trim[5] vdd x1[6]/out vss level_shift
Xx1[7] x1[7]/in_n trim[3] vdd x1[7]/out vss level_shift
Xx1[8] x1[8]/in_n trim[1] vdd x1[8]/out vss level_shift
Xxamp XM4/S bias ena_b_h XQ1/E xres/e vdd vss se_folded_cascode_p
Xsg13cmos5l_inv_2_0 x1[1]/in_n trim[15] dvdd dvss sg13cmos5l_inv_2
XXQ2_2 vss vss xtr/bot pnpMPA_9DZCCL
Xsg13cmos5l_inv_2_1 sg13cmos5l_inv_2_1/Y trim[14] dvdd dvss sg13cmos5l_inv_2
XXQ2_3 vss vss xtr/bot pnpMPA_9DZCCL
Xxres vbg xres/a xres/e XQ1/E vss xres/e xres/f vss vss vss vss bg_res
Xsg13cmos5l_inv_2_2 x1[2]/in_n trim[13] dvdd dvss sg13cmos5l_inv_2
XXQ2_4 vss vss xtr/bot pnpMPA_9DZCCL
XXQ2_5 vss vss xtr/bot pnpMPA_9DZCCL
Xsg13cmos5l_inv_2_3 sg13cmos5l_inv_2_3/Y trim[12] dvdd dvss sg13cmos5l_inv_2
Xsg13cmos5l_inv_2_4 x1[3]/in_n trim[11] dvdd dvss sg13cmos5l_inv_2
XXQ2_6 vss vss xtr/bot pnpMPA_9DZCCL
XXQ2_7 vss vss xtr/bot pnpMPA_9DZCCL
Xsg13cmos5l_inv_2_5 sg13cmos5l_inv_2_5/Y trim[10] dvdd dvss sg13cmos5l_inv_2
Xsg13cmos5l_inv_2_6 x1[4]/in_n trim[9] dvdd dvss sg13cmos5l_inv_2
XXQ1 vss vss XQ1/E pnpMPA_9DZCCL
Xsg13cmos5l_inv_2_7 sg13cmos5l_inv_2_7/Y trim[8] dvdd dvss sg13cmos5l_inv_2
Xsg13cmos5l_inv_2_8 x1[5]/in_n trim[7] dvdd dvss sg13cmos5l_inv_2
Xsg13cmos5l_inv_2_9 sg13cmos5l_inv_2_9/Y trim[6] dvdd dvss sg13cmos5l_inv_2
XXM1 vdd xres/a XM4/S vbg vdd XM4/S vdd sg13_hv_pmos_NWA9LU
XXM2 vdd xres/a XM4/S vbg vdd XM4/S vdd sg13_hv_pmos_NWA9LU
Xsg13cmos5l_antennanp_0 trim[15] dvdd dvss sg13cmos5l_antennanp
Xsg13cmos5l_antennanp_1 trim[14] dvdd dvss sg13cmos5l_antennanp
XXM3 vss vs1 vbg vss sg13_hv_nmos_BEVMZW
XXM4 vss XM4/S vs1 vss sg13_hv_nmos_BEVMZW
Xsg13cmos5l_antennanp_2 trim[13] dvdd dvss sg13cmos5l_antennanp
Xsg13cmos5l_antennanp_3 trim[12] dvdd dvss sg13cmos5l_antennanp
XXM5 vdd vs1 vs2 vdd sg13_hv_pmos_WYN5QB
XXM6 vdd vs2 vs2 vdd sg13_hv_pmos_WYN5QB
Xsg13cmos5l_antennanp_4 trim[11] dvdd dvss sg13cmos5l_antennanp
Xsg13cmos5l_antennanp_5 trim[10] dvdd dvss sg13cmos5l_antennanp
XC1 vss XM4/S capacitor_KFUPMY
XXM7 vs2 vss vdd vs2 sg13_hv_pmos_WYN5QB
XC2 vss vs2 capacitor_BC6V6V
Xsg13cmos5l_antennanp_6 trim[9] dvdd dvss sg13cmos5l_antennanp
Xsg13cmos5l_antennanp_7 trim[8] dvdd dvss sg13cmos5l_antennanp
Xsg13cmos5l_antennanp_8 trim[7] dvdd dvss sg13cmos5l_antennanp
Xsg13cmos5l_antennanp_9 trim[6] dvdd dvss sg13cmos5l_antennanp
Xlevel_shift_0[0] sg13cmos5l_inv_2_1/Y trim[14] vdd xtr/ctrl[14] vss level_shift
Xlevel_shift_0[1] sg13cmos5l_inv_2_3/Y trim[12] vdd xtr/ctrl[12] vss level_shift
Xlevel_shift_0[2] sg13cmos5l_inv_2_5/Y trim[10] vdd xtr/ctrl[10] vss level_shift
Xlevel_shift_0[3] sg13cmos5l_inv_2_7/Y trim[8] vdd xtr/ctrl[8] vss level_shift
Xlevel_shift_0[4] sg13cmos5l_inv_2_9/Y trim[6] vdd xtr/ctrl[6] vss level_shift
Xlevel_shift_0[5] sg13cmos5l_inv_2_11/Y trim[4] vdd xtr/ctrl[4] vss level_shift
Xlevel_shift_0[6] sg13cmos5l_inv_2_13/Y trim[2] vdd xtr/ctrl[2] vss level_shift
Xlevel_shift_0[7] sg13cmos5l_inv_2_15/Y trim[0] vdd xtr/ctrl[0] vss level_shift
Xxtr xres/f xtr/bot x1[1]/out xtr/ctrl[14] x1[2]/out xtr/ctrl[12] x1[3]/out xtr/ctrl[10]
+ x1[4]/out xtr/ctrl[8] x1[5]/out xtr/ctrl[6] x1[6]/out xtr/ctrl[4] x1[7]/out xtr/ctrl[2]
+ x1[8]/out xtr/ctrl[0] vss bg_trim
Xsg13cmos5l_decap_4_0 dvdd dvss sg13cmos5l_decap_4
Xsg13cmos5l_decap_4_3 dvdd dvss sg13cmos5l_decap_4
Xsg13cmos5l_inv_2_10 x1[6]/in_n trim[5] dvdd dvss sg13cmos5l_inv_2
Xsg13cmos5l_decap_4_5 dvdd dvss sg13cmos5l_decap_4
Xsg13cmos5l_antennanp_10 trim[5] dvdd dvss sg13cmos5l_antennanp
Xsg13cmos5l_inv_2_11 sg13cmos5l_inv_2_11/Y trim[4] dvdd dvss sg13cmos5l_inv_2
Xsg13cmos5l_antennanp_11 trim[4] dvdd dvss sg13cmos5l_antennanp
Xsg13cmos5l_decap_4_7 dvdd dvss sg13cmos5l_decap_4
Xsg13cmos5l_inv_2_12 x1[7]/in_n trim[3] dvdd dvss sg13cmos5l_inv_2
Xsg13cmos5l_antennanp_12 trim[3] dvdd dvss sg13cmos5l_antennanp
Xsg13cmos5l_inv_2_13 sg13cmos5l_inv_2_13/Y trim[2] dvdd dvss sg13cmos5l_inv_2
Xsg13cmos5l_decap_4_8 dvdd dvss sg13cmos5l_decap_4
Xsg13cmos5l_antennanp_13 trim[2] dvdd dvss sg13cmos5l_antennanp
Xsg13cmos5l_inv_2_14 x1[8]/in_n trim[1] dvdd dvss sg13cmos5l_inv_2
Xsg13cmos5l_antennanp_14 trim[1] dvdd dvss sg13cmos5l_antennanp
Xsg13cmos5l_inv_2_15 sg13cmos5l_inv_2_15/Y trim[0] dvdd dvss sg13cmos5l_inv_2
Xcapacitor_SURZLD_0 vss vs2 capacitor_SURZLD
Xsg13cmos5l_antennanp_15 trim[0] dvdd dvss sg13cmos5l_antennanp
XXQ2_0 vss vss xtr/bot pnpMPA_9DZCCL
Xsg13cmos5l_inv_2_16 x1[0]/in_p ena dvdd dvss sg13cmos5l_inv_2
.ends

.subckt sg13_hv_pmos_QWE845 D0_0 S0_0 G0_0 D0_1 S0_1 G0_1 D1_0 S1_0 G1_0 D1_1 S1_1
+ G1_1 w_n1081_n1018#
X0 S0_0 G0_0 D0_0 w_n1081_n1018# sg13_hv_pmos ad=1.36p pd=8.68u as=1.36p ps=8.68u w=4u l=4u
X1 D1_0 G1_0 S1_0 w_n1081_n1018# sg13_hv_pmos ad=1.36p pd=8.68u as=1.36p ps=8.68u w=4u l=4u
X2 D1_1 G1_1 S1_1 w_n1081_n1018# sg13_hv_pmos ad=1.36p pd=8.68u as=1.36p ps=8.68u w=4u l=4u
X3 S0_1 G0_1 D0_1 w_n1081_n1018# sg13_hv_pmos ad=1.36p pd=8.68u as=1.36p ps=8.68u w=4u l=4u
.ends

.subckt sg13_hv_nmos_BEHQUZ D0 S0 G0 D1 S1 G1 D2 S2 G2 D3 S3 G3 D4 S4 G4 D5 S5 G5
+ D6 S6 G6 D7 S7 G7 sub
X0 S4 G4 D4 sub sg13_hv_nmos ad=0.34p pd=2.68u as=0.34p ps=2.68u w=1u l=1u
X1 S6 G6 D6 sub sg13_hv_nmos ad=0.34p pd=2.68u as=0.34p ps=2.68u w=1u l=1u
X2 D5 G5 S5 sub sg13_hv_nmos ad=0.34p pd=2.68u as=0.34p ps=2.68u w=1u l=1u
X3 D7 G7 S7 sub sg13_hv_nmos ad=0.34p pd=2.68u as=0.34p ps=2.68u w=1u l=1u
X4 S0 G0 D0 sub sg13_hv_nmos ad=0.34p pd=2.68u as=0.34p ps=2.68u w=1u l=1u
X5 D1 G1 S1 sub sg13_hv_nmos ad=0.34p pd=2.68u as=0.34p ps=2.68u w=1u l=1u
X6 S2 G2 D2 sub sg13_hv_nmos ad=0.34p pd=2.68u as=0.34p ps=2.68u w=1u l=1u
X7 D3 G3 S3 sub sg13_hv_nmos ad=0.34p pd=2.68u as=0.34p ps=2.68u w=1u l=1u
.ends

.subckt sg13_hv_nmos_BEZCVZ D0 S0 G0 D1 S1 G1 D2 S2 G2 D3 S3 G3 sub
X0 S2 G2 D2 sub sg13_hv_nmos ad=0.34p pd=2.68u as=0.34p ps=2.68u w=1u l=1u
X1 D3 G3 S3 sub sg13_hv_nmos ad=0.34p pd=2.68u as=0.34p ps=2.68u w=1u l=1u
X2 S0 G0 D0 sub sg13_hv_nmos ad=0.34p pd=2.68u as=0.34p ps=2.68u w=1u l=1u
X3 D1 G1 S1 sub sg13_hv_nmos ad=0.34p pd=2.68u as=0.34p ps=2.68u w=1u l=1u
.ends

.subckt sg13_hv_pmos_ZK4LW2 D0 S0 G0 D1 S1 G1 D2 S2 G2 D3 S3 G3 D4 S4 G4 D5 S5 G5
+ D6 S6 G6 D7 S7 G7 D8 S8 G8 D9 S9 G9 D10 S10 G10 D11 S11 G11 w_n2371_n224#
X0 D5 G5 S5 w_n2371_n224# sg13_hv_pmos ad=0.34p pd=2.68u as=0.34p ps=2.68u w=1u l=1u
X1 S6 G6 D6 w_n2371_n224# sg13_hv_pmos ad=0.34p pd=2.68u as=0.34p ps=2.68u w=1u l=1u
X2 S0 G0 D0 w_n2371_n224# sg13_hv_pmos ad=0.34p pd=2.68u as=0.34p ps=2.68u w=1u l=1u
X3 D11 G11 S11 w_n2371_n224# sg13_hv_pmos ad=0.34p pd=2.68u as=0.34p ps=2.68u w=1u l=1u
X4 S8 G8 D8 w_n2371_n224# sg13_hv_pmos ad=0.34p pd=2.68u as=0.34p ps=2.68u w=1u l=1u
X5 S10 G10 D10 w_n2371_n224# sg13_hv_pmos ad=0.34p pd=2.68u as=0.34p ps=2.68u w=1u l=1u
X6 D7 G7 S7 w_n2371_n224# sg13_hv_pmos ad=0.34p pd=2.68u as=0.34p ps=2.68u w=1u l=1u
X7 D9 G9 S9 w_n2371_n224# sg13_hv_pmos ad=0.34p pd=2.68u as=0.34p ps=2.68u w=1u l=1u
X8 D1 G1 S1 w_n2371_n224# sg13_hv_pmos ad=0.34p pd=2.68u as=0.34p ps=2.68u w=1u l=1u
X9 S2 G2 D2 w_n2371_n224# sg13_hv_pmos ad=0.34p pd=2.68u as=0.34p ps=2.68u w=1u l=1u
X10 D3 G3 S3 w_n2371_n224# sg13_hv_pmos ad=0.34p pd=2.68u as=0.34p ps=2.68u w=1u l=1u
X11 S4 G4 D4 w_n2371_n224# sg13_hv_pmos ad=0.34p pd=2.68u as=0.34p ps=2.68u w=1u l=1u
.ends

.subckt sg13_hv_pmos_DFT6DG D0_0 S0_0 G0_0 D0_1 S0_1 G0_1 D0_2 S0_2 G0_2 D0_3 S0_3
+ G0_3 D1_0 S1_0 G1_0 D1_1 S1_1 G1_1 D1_2 S1_2 G1_2 D1_3 S1_3 G1_3 D2_0 S2_0 G2_0
+ D2_1 S2_1 G2_1 D2_2 S2_2 G2_2 D2_3 S2_3 G2_3 D3_0 S3_0 G3_0 D3_1 S3_1 G3_1 D3_2
+ S3_2 G3_2 D3_3 S3_3 G3_3 w_n2059_n806#
X0 S0_3 G0_3 D0_3 w_n2059_n806# sg13_hv_pmos ad=0.34p pd=2.68u as=0.34p ps=2.68u w=1u l=4u
X1 S0_0 G0_0 D0_0 w_n2059_n806# sg13_hv_pmos ad=0.34p pd=2.68u as=0.34p ps=2.68u w=1u l=4u
X2 D1_0 G1_0 S1_0 w_n2059_n806# sg13_hv_pmos ad=0.34p pd=2.68u as=0.34p ps=2.68u w=1u l=4u
X3 D3_2 G3_2 S3_2 w_n2059_n806# sg13_hv_pmos ad=0.34p pd=2.68u as=0.34p ps=2.68u w=1u l=4u
X4 S2_1 G2_1 D2_1 w_n2059_n806# sg13_hv_pmos ad=0.34p pd=2.68u as=0.34p ps=2.68u w=1u l=4u
X5 D3_1 G3_1 S3_1 w_n2059_n806# sg13_hv_pmos ad=0.34p pd=2.68u as=0.34p ps=2.68u w=1u l=4u
X6 S0_2 G0_2 D0_2 w_n2059_n806# sg13_hv_pmos ad=0.34p pd=2.68u as=0.34p ps=2.68u w=1u l=4u
X7 S2_2 G2_2 D2_2 w_n2059_n806# sg13_hv_pmos ad=0.34p pd=2.68u as=0.34p ps=2.68u w=1u l=4u
X8 S0_1 G0_1 D0_1 w_n2059_n806# sg13_hv_pmos ad=0.34p pd=2.68u as=0.34p ps=2.68u w=1u l=4u
X9 D3_3 G3_3 S3_3 w_n2059_n806# sg13_hv_pmos ad=0.34p pd=2.68u as=0.34p ps=2.68u w=1u l=4u
X10 D3_0 G3_0 S3_0 w_n2059_n806# sg13_hv_pmos ad=0.34p pd=2.68u as=0.34p ps=2.68u w=1u l=4u
X11 S2_0 G2_0 D2_0 w_n2059_n806# sg13_hv_pmos ad=0.34p pd=2.68u as=0.34p ps=2.68u w=1u l=4u
X12 S2_3 G2_3 D2_3 w_n2059_n806# sg13_hv_pmos ad=0.34p pd=2.68u as=0.34p ps=2.68u w=1u l=4u
X13 D1_2 G1_2 S1_2 w_n2059_n806# sg13_hv_pmos ad=0.34p pd=2.68u as=0.34p ps=2.68u w=1u l=4u
X14 D1_1 G1_1 S1_1 w_n2059_n806# sg13_hv_pmos ad=0.34p pd=2.68u as=0.34p ps=2.68u w=1u l=4u
X15 D1_3 G1_3 S1_3 w_n2059_n806# sg13_hv_pmos ad=0.34p pd=2.68u as=0.34p ps=2.68u w=1u l=4u
.ends

.subckt sg13_hv_nmos_T2KQE3 D0 S0 G0 D1 S1 G1 D2 S2 G2 D3 S3 G3 sub
X0 S0 G0 D0 sub sg13_hv_nmos ad=0.68p pd=4.68u as=0.68p ps=4.68u w=2u l=4u
X1 S2 G2 D2 sub sg13_hv_nmos ad=0.68p pd=4.68u as=0.68p ps=4.68u w=2u l=4u
X2 S3 G3 D3 sub sg13_hv_nmos ad=0.68p pd=4.68u as=0.68p ps=4.68u w=2u l=4u
X3 S1 G1 D1 sub sg13_hv_nmos ad=0.68p pd=4.68u as=0.68p ps=4.68u w=2u l=4u
.ends

.subckt sg13_hv_nmos_TAZSE3 D0_0 S0_0 G0_0 D0_1 S0_1 G0_1 D0_2 S0_2 G0_2 D0_3 S0_3
+ G0_3 D1_0 S1_0 G1_0 D1_1 S1_1 G1_1 D1_2 S1_2 G1_2 D1_3 S1_3 G1_3 D2_0 S2_0 G2_0
+ D2_1 S2_1 G2_1 D2_2 S2_2 G2_2 D2_3 S2_3 G2_3 D3_0 S3_0 G3_0 D3_1 S3_1 G3_1 D3_2
+ S3_2 G3_2 D3_3 S3_3 G3_3 sub
X0 S0_1 G0_1 D0_1 sub sg13_hv_nmos ad=0.68p pd=4.68u as=0.68p ps=4.68u w=2u l=4u
X1 S2_0 G2_0 D2_0 sub sg13_hv_nmos ad=0.68p pd=4.68u as=0.68p ps=4.68u w=2u l=4u
X2 D3_3 G3_3 S3_3 sub sg13_hv_nmos ad=0.68p pd=4.68u as=0.68p ps=4.68u w=2u l=4u
X3 S2_3 G2_3 D2_3 sub sg13_hv_nmos ad=0.68p pd=4.68u as=0.68p ps=4.68u w=2u l=4u
X4 D1_0 G1_0 S1_0 sub sg13_hv_nmos ad=0.68p pd=4.68u as=0.68p ps=4.68u w=2u l=4u
X5 D1_1 G1_1 S1_1 sub sg13_hv_nmos ad=0.68p pd=4.68u as=0.68p ps=4.68u w=2u l=4u
X6 D1_3 G1_3 S1_3 sub sg13_hv_nmos ad=0.68p pd=4.68u as=0.68p ps=4.68u w=2u l=4u
X7 D3_2 G3_2 S3_2 sub sg13_hv_nmos ad=0.68p pd=4.68u as=0.68p ps=4.68u w=2u l=4u
X8 S0_3 G0_3 D0_3 sub sg13_hv_nmos ad=0.68p pd=4.68u as=0.68p ps=4.68u w=2u l=4u
X9 S0_2 G0_2 D0_2 sub sg13_hv_nmos ad=0.68p pd=4.68u as=0.68p ps=4.68u w=2u l=4u
X10 S0_0 G0_0 D0_0 sub sg13_hv_nmos ad=0.68p pd=4.68u as=0.68p ps=4.68u w=2u l=4u
X11 S2_2 G2_2 D2_2 sub sg13_hv_nmos ad=0.68p pd=4.68u as=0.68p ps=4.68u w=2u l=4u
X12 D3_0 G3_0 S3_0 sub sg13_hv_nmos ad=0.68p pd=4.68u as=0.68p ps=4.68u w=2u l=4u
X13 S2_1 G2_1 D2_1 sub sg13_hv_nmos ad=0.68p pd=4.68u as=0.68p ps=4.68u w=2u l=4u
X14 D3_1 G3_1 S3_1 sub sg13_hv_nmos ad=0.68p pd=4.68u as=0.68p ps=4.68u w=2u l=4u
X15 D1_2 G1_2 S1_2 sub sg13_hv_nmos ad=0.68p pd=4.68u as=0.68p ps=4.68u w=2u l=4u
.ends

.subckt sg13_hv_pmos_NQD9LU D0_0 S0_0 G0_0 D0_1 S0_1 G0_1 D1_0 S1_0 G1_0 D1_1 S1_1
+ G1_1 D2_0 S2_0 G2_0 D2_1 S2_1 G2_1 D3_0 S3_0 G3_0 D3_1 S3_1 G3_1 D4_0 S4_0 G4_0
+ D4_1 S4_1 G4_1 D5_0 S5_0 G5_0 D5_1 S5_1 G5_1 D6_0 S6_0 G6_0 D6_1 S6_1 G6_1 D7_0
+ S7_0 G7_0 D7_1 S7_1 G7_1 w_n1615_n418#
X0 S6_0 G6_0 D6_0 w_n1615_n418# sg13_hv_pmos ad=0.34p pd=2.68u as=0.34p ps=2.68u w=1u l=1u
X1 D5_1 G5_1 S5_1 w_n1615_n418# sg13_hv_pmos ad=0.34p pd=2.68u as=0.34p ps=2.68u w=1u l=1u
X2 S2_1 G2_1 D2_1 w_n1615_n418# sg13_hv_pmos ad=0.34p pd=2.68u as=0.34p ps=2.68u w=1u l=1u
X3 D7_0 G7_0 S7_0 w_n1615_n418# sg13_hv_pmos ad=0.34p pd=2.68u as=0.34p ps=2.68u w=1u l=1u
X4 D1_1 G1_1 S1_1 w_n1615_n418# sg13_hv_pmos ad=0.34p pd=2.68u as=0.34p ps=2.68u w=1u l=1u
X5 D7_1 G7_1 S7_1 w_n1615_n418# sg13_hv_pmos ad=0.34p pd=2.68u as=0.34p ps=2.68u w=1u l=1u
X6 D3_1 G3_1 S3_1 w_n1615_n418# sg13_hv_pmos ad=0.34p pd=2.68u as=0.34p ps=2.68u w=1u l=1u
X7 D3_0 G3_0 S3_0 w_n1615_n418# sg13_hv_pmos ad=0.34p pd=2.68u as=0.34p ps=2.68u w=1u l=1u
X8 S4_0 G4_0 D4_0 w_n1615_n418# sg13_hv_pmos ad=0.34p pd=2.68u as=0.34p ps=2.68u w=1u l=1u
X9 S2_0 G2_0 D2_0 w_n1615_n418# sg13_hv_pmos ad=0.34p pd=2.68u as=0.34p ps=2.68u w=1u l=1u
X10 S4_1 G4_1 D4_1 w_n1615_n418# sg13_hv_pmos ad=0.34p pd=2.68u as=0.34p ps=2.68u w=1u l=1u
X11 S6_1 G6_1 D6_1 w_n1615_n418# sg13_hv_pmos ad=0.34p pd=2.68u as=0.34p ps=2.68u w=1u l=1u
X12 D1_0 G1_0 S1_0 w_n1615_n418# sg13_hv_pmos ad=0.34p pd=2.68u as=0.34p ps=2.68u w=1u l=1u
X13 D5_0 G5_0 S5_0 w_n1615_n418# sg13_hv_pmos ad=0.34p pd=2.68u as=0.34p ps=2.68u w=1u l=1u
X14 S0_1 G0_1 D0_1 w_n1615_n418# sg13_hv_pmos ad=0.34p pd=2.68u as=0.34p ps=2.68u w=1u l=1u
X15 S0_0 G0_0 D0_0 w_n1615_n418# sg13_hv_pmos ad=0.34p pd=2.68u as=0.34p ps=2.68u w=1u l=1u
.ends

.subckt sg13_hv_pmos_V3Q6DG D0 S0 G0 D1 S1 G1 D2 S2 G2 D3 S3 G3 w_n592_n806#
X0 S0 G0 D0 w_n592_n806# sg13_hv_pmos ad=0.34p pd=2.68u as=0.34p ps=2.68u w=1u l=4u
X1 S2 G2 D2 w_n592_n806# sg13_hv_pmos ad=0.34p pd=2.68u as=0.34p ps=2.68u w=1u l=4u
X2 S3 G3 D3 w_n592_n806# sg13_hv_pmos ad=0.34p pd=2.68u as=0.34p ps=2.68u w=1u l=4u
X3 S1 G1 D1 w_n592_n806# sg13_hv_pmos ad=0.34p pd=2.68u as=0.34p ps=2.68u w=1u l=4u
.ends

.subckt sg13_hv_pmos_NED9LU D0_0 S0_0 G0_0 D0_1 S0_1 G0_1 D1_0 S1_0 G1_0 D1_1 S1_1
+ G1_1 D2_0 S2_0 G2_0 D2_1 S2_1 G2_1 D3_0 S3_0 G3_0 D3_1 S3_1 G3_1 w_n859_n1018#
X0 D3_0 G3_0 S3_0 w_n859_n1018# sg13_hv_pmos ad=1.36p pd=8.68u as=1.36p ps=8.68u w=4u l=1u
X1 D3_1 G3_1 S3_1 w_n859_n1018# sg13_hv_pmos ad=1.36p pd=8.68u as=1.36p ps=8.68u w=4u l=1u
X2 S0_1 G0_1 D0_1 w_n859_n1018# sg13_hv_pmos ad=1.36p pd=8.68u as=1.36p ps=8.68u w=4u l=1u
X3 D1_1 G1_1 S1_1 w_n859_n1018# sg13_hv_pmos ad=1.36p pd=8.68u as=1.36p ps=8.68u w=4u l=1u
X4 D1_0 G1_0 S1_0 w_n859_n1018# sg13_hv_pmos ad=1.36p pd=8.68u as=1.36p ps=8.68u w=4u l=1u
X5 S2_0 G2_0 D2_0 w_n859_n1018# sg13_hv_pmos ad=1.36p pd=8.68u as=1.36p ps=8.68u w=4u l=1u
X6 S2_1 G2_1 D2_1 w_n859_n1018# sg13_hv_pmos ad=1.36p pd=8.68u as=1.36p ps=8.68u w=4u l=1u
X7 S0_0 G0_0 D0_0 w_n859_n1018# sg13_hv_pmos ad=1.36p pd=8.68u as=1.36p ps=8.68u w=4u l=1u
.ends

.subckt sg13_hv_nmos_BENXUZ D0_0 S0_0 G0_0 D0_1 S0_1 G0_1 D1_0 S1_0 G1_0 D1_1 S1_1
+ G1_1 D2_0 S2_0 G2_0 D2_1 S2_1 G2_1 D3_0 S3_0 G3_0 D3_1 S3_1 G3_1 sub
X0 D3_1 G3_1 S3_1 sub sg13_hv_nmos ad=0.68p pd=4.68u as=0.68p ps=4.68u w=2u l=1u
X1 S0_1 G0_1 D0_1 sub sg13_hv_nmos ad=0.68p pd=4.68u as=0.68p ps=4.68u w=2u l=1u
X2 D3_0 G3_0 S3_0 sub sg13_hv_nmos ad=0.68p pd=4.68u as=0.68p ps=4.68u w=2u l=1u
X3 D1_1 G1_1 S1_1 sub sg13_hv_nmos ad=0.68p pd=4.68u as=0.68p ps=4.68u w=2u l=1u
X4 S2_1 G2_1 D2_1 sub sg13_hv_nmos ad=0.68p pd=4.68u as=0.68p ps=4.68u w=2u l=1u
X5 S2_0 G2_0 D2_0 sub sg13_hv_nmos ad=0.68p pd=4.68u as=0.68p ps=4.68u w=2u l=1u
X6 D1_0 G1_0 S1_0 sub sg13_hv_nmos ad=0.68p pd=4.68u as=0.68p ps=4.68u w=2u l=1u
X7 S0_0 G0_0 D0_0 sub sg13_hv_nmos ad=0.68p pd=4.68u as=0.68p ps=4.68u w=2u l=1u
.ends

.subckt capacitor_W9X9FK sub c1 c2
C0 c1 c2 1.29745p
.ends

.subckt sg13_hv_nmos_XAS6UC D0_0 S0_0 G0_0 D0_1 S0_1 G0_1 D1_0 S1_0 G1_0 D1_1 S1_1
+ G1_1 D2_0 S2_0 G2_0 D2_1 S2_1 G2_1 D3_0 S3_0 G3_0 D3_1 S3_1 G3_1 D4_0 S4_0 G4_0
+ D4_1 S4_1 G4_1 D5_0 S5_0 G5_0 D5_1 S5_1 G5_1 D6_0 S6_0 G6_0 D6_1 S6_1 G6_1 D7_0
+ S7_0 G7_0 D7_1 S7_1 G7_1 D8_0 S8_0 G8_0 D8_1 S8_1 G8_1 D9_0 S9_0 G9_0 D9_1 S9_1
+ G9_1 D10_0 S10_0 G10_0 D10_1 S10_1 G10_1 D11_0 S11_0 G11_0 D11_1 S11_1 G11_1 sub
X0 S0_1 G0_1 D0_1 sub sg13_hv_nmos ad=0.34p pd=2.68u as=0.34p ps=2.68u w=1u l=1u
X1 D7_1 G7_1 S7_1 sub sg13_hv_nmos ad=0.34p pd=2.68u as=0.34p ps=2.68u w=1u l=1u
X2 S4_1 G4_1 D4_1 sub sg13_hv_nmos ad=0.34p pd=2.68u as=0.34p ps=2.68u w=1u l=1u
X3 D9_0 G9_0 S9_0 sub sg13_hv_nmos ad=0.34p pd=2.68u as=0.34p ps=2.68u w=1u l=1u
X4 D3_1 G3_1 S3_1 sub sg13_hv_nmos ad=0.34p pd=2.68u as=0.34p ps=2.68u w=1u l=1u
X5 D11_1 G11_1 S11_1 sub sg13_hv_nmos ad=0.34p pd=2.68u as=0.34p ps=2.68u w=1u l=1u
X6 S10_0 G10_0 D10_0 sub sg13_hv_nmos ad=0.34p pd=2.68u as=0.34p ps=2.68u w=1u l=1u
X7 D9_1 G9_1 S9_1 sub sg13_hv_nmos ad=0.34p pd=2.68u as=0.34p ps=2.68u w=1u l=1u
X8 S6_0 G6_0 D6_0 sub sg13_hv_nmos ad=0.34p pd=2.68u as=0.34p ps=2.68u w=1u l=1u
X9 D11_0 G11_0 S11_0 sub sg13_hv_nmos ad=0.34p pd=2.68u as=0.34p ps=2.68u w=1u l=1u
X10 D5_1 G5_1 S5_1 sub sg13_hv_nmos ad=0.34p pd=2.68u as=0.34p ps=2.68u w=1u l=1u
X11 D5_0 G5_0 S5_0 sub sg13_hv_nmos ad=0.34p pd=2.68u as=0.34p ps=2.68u w=1u l=1u
X12 S0_0 G0_0 D0_0 sub sg13_hv_nmos ad=0.34p pd=2.68u as=0.34p ps=2.68u w=1u l=1u
X13 S4_0 G4_0 D4_0 sub sg13_hv_nmos ad=0.34p pd=2.68u as=0.34p ps=2.68u w=1u l=1u
X14 D1_1 G1_1 S1_1 sub sg13_hv_nmos ad=0.34p pd=2.68u as=0.34p ps=2.68u w=1u l=1u
X15 S6_1 G6_1 D6_1 sub sg13_hv_nmos ad=0.34p pd=2.68u as=0.34p ps=2.68u w=1u l=1u
X16 S8_1 G8_1 D8_1 sub sg13_hv_nmos ad=0.34p pd=2.68u as=0.34p ps=2.68u w=1u l=1u
X17 D3_0 G3_0 S3_0 sub sg13_hv_nmos ad=0.34p pd=2.68u as=0.34p ps=2.68u w=1u l=1u
X18 D7_0 G7_0 S7_0 sub sg13_hv_nmos ad=0.34p pd=2.68u as=0.34p ps=2.68u w=1u l=1u
X19 S2_0 G2_0 D2_0 sub sg13_hv_nmos ad=0.34p pd=2.68u as=0.34p ps=2.68u w=1u l=1u
X20 S2_1 G2_1 D2_1 sub sg13_hv_nmos ad=0.34p pd=2.68u as=0.34p ps=2.68u w=1u l=1u
X21 S10_1 G10_1 D10_1 sub sg13_hv_nmos ad=0.34p pd=2.68u as=0.34p ps=2.68u w=1u l=1u
X22 D1_0 G1_0 S1_0 sub sg13_hv_nmos ad=0.34p pd=2.68u as=0.34p ps=2.68u w=1u l=1u
X23 S8_0 G8_0 D8_0 sub sg13_hv_nmos ad=0.34p pd=2.68u as=0.34p ps=2.68u w=1u l=1u
.ends

.subckt sg13_hv_nmos_2G82VR D0_0 S0_0 G0_0 D0_1 S0_1 G0_1 D1_0 S1_0 G1_0 D1_1 S1_1
+ G1_1 sub
X0 S0_0 G0_0 D0_0 sub sg13_hv_nmos ad=1.36p pd=8.68u as=1.36p ps=8.68u w=4u l=4u
X1 D1_0 G1_0 S1_0 sub sg13_hv_nmos ad=1.36p pd=8.68u as=1.36p ps=8.68u w=4u l=4u
X2 D1_1 G1_1 S1_1 sub sg13_hv_nmos ad=1.36p pd=8.68u as=1.36p ps=8.68u w=4u l=4u
X3 S0_1 G0_1 D0_1 sub sg13_hv_nmos ad=1.36p pd=8.68u as=1.36p ps=8.68u w=4u l=4u
.ends

.subckt se_folded_cascode_np_ab vdd out bias ena_b inn vss inp
XXMOP out vdd XM9/S3_2 out vdd XM9/S3_2 vdd out XM9/S3_2 vdd out XM9/S3_2 vdd sg13_hv_pmos_QWE845
Xsg13_hv_nmos_BEHQUZ_0 vss vss vss vss vss vss vss vss vss vss vss vss vss vss vss
+ vss vss vss vss vss vss vss vss vss vss sg13_hv_nmos_BEHQUZ
Xsg13_hv_nmos_BEZCVZ_0 vss vss vss vss vss vss vss vss vss vss vss vss vss sg13_hv_nmos_BEZCVZ
XXM4 vdd outa1n outa1n outa1p vdd outa1n vdd outa1n outa1n outa1p vdd outa1n vdd outa1n
+ outa1n outa1p vdd outa1n vdd outa1n outa1n outa1p vdd outa1n vdd outa1n outa1n outa1p
+ vdd outa1n vdd outa1n outa1n outa1p vdd outa1n vdd sg13_hv_pmos_ZK4LW2
XXM5 vdd outa1n outa1n outa1p vdd outa1n vdd outa1n outa1n outa1p vdd outa1n vdd outa1n
+ outa1n outa1p vdd outa1n vdd outa1n outa1n outa1p vdd outa1n vdd outa1n outa1n outa1p
+ vdd outa1n vdd outa1n outa1n outa1p vdd outa1n vdd sg13_hv_pmos_ZK4LW2
XXM6 XM9/S3_2 outa1p XM9/S3_3 outa1n XM9/S3_3 XM9/S3_3 XM9/S3_2 outa1p XM9/S3_3 outa1n
+ XM9/S3_3 XM9/S3_3 XM9/S3_3 outa1n XM9/S3_3 outa1p XM9/S3_2 XM9/S3_3 XM9/S3_3 outa1n
+ XM9/S3_3 outa1p XM9/S3_2 XM9/S3_3 XM9/S3_2 outa1p XM9/S3_3 outa1n XM9/S3_3 XM9/S3_3
+ XM9/S3_2 outa1p XM9/S3_3 outa1n XM9/S3_3 XM9/S3_3 XM9/S3_3 outa1n XM9/S3_3 outa1p
+ XM9/S3_2 XM9/S3_3 XM9/S3_3 outa1n XM9/S3_3 outa1p XM9/S3_2 XM9/S3_3 vdd sg13_hv_pmos_DFT6DG
XXM7 XM9/S3_2 outa1p XM9/S3_3 outa1n XM9/S3_3 XM9/S3_3 XM9/S3_2 outa1p XM9/S3_3 outa1n
+ XM9/S3_3 XM9/S3_3 XM9/S3_3 outa1n XM9/S3_3 outa1p XM9/S3_2 XM9/S3_3 XM9/S3_3 outa1n
+ XM9/S3_3 outa1p XM9/S3_2 XM9/S3_3 XM9/S3_2 outa1p XM9/S3_3 outa1n XM9/S3_3 XM9/S3_3
+ XM9/S3_2 outa1p XM9/S3_3 outa1n XM9/S3_3 XM9/S3_3 XM9/S3_3 outa1n XM9/S3_3 outa1p
+ XM9/S3_2 XM9/S3_3 XM9/S3_3 outa1n XM9/S3_3 outa1p XM9/S3_2 XM9/S3_3 vdd sg13_hv_pmos_DFT6DG
XXMB1 vbn1 vbn2 vbn2 vbn1 vbn2 vbn2 vbn1 vbn2 vbn2 vbn1 vbn2 vbn2 vss sg13_hv_nmos_T2KQE3
XXM8 XM9/S3_3 outb1n vbn2 XM9/S3_2 outb1p vbn2 XM9/S3_3 outb1n vbn2 XM9/S3_2 outb1p
+ vbn2 outb1p XM9/S3_2 vbn2 outb1n XM9/S3_3 vbn2 outb1p XM9/S3_2 vbn2 outb1n XM9/S3_3
+ vbn2 XM9/S3_3 outb1n vbn2 XM9/S3_2 outb1p vbn2 XM9/S3_3 outb1n vbn2 XM9/S3_2 outb1p
+ vbn2 outb1p XM9/S3_2 vbn2 outb1n XM9/S3_3 vbn2 outb1p XM9/S3_2 vbn2 outb1n XM9/S3_3
+ vbn2 vss sg13_hv_nmos_TAZSE3
XXMB2 vss vbn1 vbn1 vbn1 vss vbn1 vss vbn1 vbn1 vbn1 vss vbn1 vss sg13_hv_nmos_BEZCVZ
XXMIP1 vdd diffb vbp1 vdd diffb vbp1 diffb vdd vbp1 diffb vdd vbp1 vdd diffb vbp1
+ vdd diffb vbp1 diffb vdd vbp1 diffb vdd vbp1 vdd diffb vbp1 vdd diffb vbp1 diffb
+ vdd vbp1 diffb vdd vbp1 vdd diffb vbp1 vdd diffb vbp1 diffb vdd vbp1 diffb vdd vbp1
+ vdd sg13_hv_pmos_NQD9LU
XXM9 XM9/S3_3 outb1n vbn2 XM9/S3_2 outb1p vbn2 XM9/S3_3 outb1n vbn2 XM9/S3_2 outb1p
+ vbn2 outb1p XM9/S3_2 vbn2 outb1n XM9/S3_3 vbn2 outb1p XM9/S3_2 vbn2 outb1n XM9/S3_3
+ vbn2 XM9/S3_3 outb1n vbn2 XM9/S3_2 outb1p vbn2 XM9/S3_3 outb1n vbn2 XM9/S3_2 outb1p
+ vbn2 outb1p XM9/S3_2 vbn2 outb1n XM9/S3_3 vbn2 outb1p XM9/S3_2 vbn2 outb1n XM9/S3_3
+ vbn2 vss sg13_hv_nmos_TAZSE3
XXMB3 XMB4/S3 bias ena_b XMB4/S3 bias ena_b XMB4/S3 bias ena_b XMB4/S3 bias ena_b
+ vdd sg13_hv_pmos_V3Q6DG
XXMIP2 outb1n diffb inn outb1p diffb inp diffb outb1p inp diffb outb1n inn outb1n
+ diffb inn outb1p diffb inp diffb outb1p inp diffb outb1n inn vdd sg13_hv_pmos_NED9LU
XXMB4 vbp1 XMB4/S3 XMB4/S3 vbp1 XMB4/S3 XMB4/S3 vbp1 XMB4/S3 XMB4/S3 vbp1 XMB4/S3
+ XMB4/S3 vdd sg13_hv_pmos_V3Q6DG
XXMIP3 outb1n diffb inn outb1p diffb inp diffb outb1p inp diffb outb1n inn outb1n
+ diffb inn outb1p diffb inp diffb outb1p inp diffb outb1n inn vdd sg13_hv_pmos_NED9LU
XXMIN1 vss diffa vbn1 diffa vss vbn1 vss diffa vbn1 diffa vss vbn1 vss diffa vbn1
+ diffa vss vbn1 vss diffa vbn1 diffa vss vbn1 vss sg13_hv_nmos_BEHQUZ
XXMB5 vdd vbn2 vbp1 vbp1 vdd vbp1 vdd vbn2 vbp1 vbp1 vdd vbp1 vdd sg13_hv_pmos_NQUDLU
XXMIN2 outa1n diffa inn outa1p diffa inp diffa outa1p inp diffa outa1n inn outa1n
+ diffa inn outa1p diffa inp diffa outa1p inp diffa outa1n inn vss sg13_hv_nmos_BENXUZ
XXMB6 vdd vbn2 vbp1 vbp1 vdd vbp1 vdd vbn2 vbp1 vbp1 vdd vbp1 vdd sg13_hv_pmos_NQUDLU
XXMIN3 outa1n diffa inn outa1p diffa inp diffa outa1p inp diffa outa1n inn outa1n
+ diffa inn outa1p diffa inp diffa outa1p inp diffa outa1n inn vss sg13_hv_nmos_BENXUZ
XC1[1] vss XM9/S3_2 out capacitor_W9X9FK
XC1[0] vss XM9/S3_2 out capacitor_W9X9FK
XXM10 vss outb1p vbn1 vss outb1p vbn1 outb1n vss vbn1 outb1n vss vbn1 vss outb1p vbn1
+ vss outb1p vbn1 outb1n vss vbn1 outb1n vss vbn1 vss outb1p vbn1 vss outb1p vbn1
+ outb1n vss vbn1 outb1n vss vbn1 vss outb1p vbn1 vss outb1p vbn1 outb1n vss vbn1
+ outb1n vss vbn1 vss outb1p vbn1 vss outb1p vbn1 outb1n vss vbn1 outb1n vss vbn1
+ vss outb1p vbn1 vss outb1p vbn1 outb1n vss vbn1 outb1n vss vbn1 vss sg13_hv_nmos_XAS6UC
XXMON out vss XM9/S3_2 out vss XM9/S3_2 vss out XM9/S3_2 vss out XM9/S3_2 vss sg13_hv_nmos_2G82VR
Xsg13_hv_nmos_T2KQE3_0 vss vss vbn2 vss vss vbn2 vss vss vbn2 vss vss vbn2 vss sg13_hv_nmos_T2KQE3
XXM11 vss outb1p vbn1 vss outb1p vbn1 outb1n vss vbn1 outb1n vss vbn1 vss outb1p vbn1
+ vss outb1p vbn1 outb1n vss vbn1 outb1n vss vbn1 vss outb1p vbn1 vss outb1p vbn1
+ outb1n vss vbn1 outb1n vss vbn1 vss outb1p vbn1 vss outb1p vbn1 outb1n vss vbn1
+ outb1n vss vbn1 vss outb1p vbn1 vss outb1p vbn1 outb1n vss vbn1 outb1n vss vbn1
+ vss outb1p vbn1 vss outb1p vbn1 outb1n vss vbn1 outb1n vss vbn1 vss sg13_hv_nmos_XAS6UC
.ends

.subckt sg13cmos5l_ocd_ip__bandgap vdd ibias1_250n trim[15] trim[14] trim[13] trim[12]
+ trim[11] trim[10] trim[9] trim[8] trim[7] trim[6] trim[5] trim[4] trim[3] trim[2]
+ trim[1] trim[0] ena dvdd ibias2_1u vss vbg dvss
Xx1 x2/inp ibias1_250n trim[15] trim[14] trim[13] trim[11] trim[10] trim[9] trim[8]
+ trim[7] trim[6] trim[5] trim[4] trim[3] trim[2] trim[1] trim[0] dvdd ena x2/ena_b
+ trim[12] dvss vdd vss bandgap_unbuffered
Xx2 vdd vbg ibias2_1u x2/ena_b vbg vss x2/inp se_folded_cascode_np_ab
.ends

.subckt sg13_hv_pmos_CVGX38 D S G w_n232_n305#
X0 S G D w_n232_n305# sg13_hv_pmos ad=0.68p pd=4.68u as=0.68p ps=4.68u w=2u l=0.4u
.ends

.subckt sg13_hv_nmos_83DLAQ D S G sub
X0 S G D sub sg13_hv_nmos ad=0.34p pd=2.68u as=0.34p ps=2.68u w=1u l=0.45u
.ends

.subckt hv_inv_1 vdd X vss A
XXM1 X vdd A vdd sg13_hv_pmos_CVGX38
XXM2 vss X A vss sg13_hv_nmos_83DLAQ
.ends

.subckt sg13_hv_pmos_XLVYT6 B D S G
X0 S G D B sg13_hv_pmos ad=0.68p pd=4.68u as=0.68p ps=4.68u w=2u l=0.5u
.ends

.subckt sg13_hv_nmos_MRZNPN B D S G
X0 S G D B sg13_hv_nmos ad=0.68p pd=4.68u as=0.68p ps=4.68u w=2u l=0.5u
.ends

.subckt xgate ena_b in out ena vss vdd
XXM1 vdd in out ena_b sg13_hv_pmos_XLVYT6
XXM2 vss in out ena sg13_hv_nmos_MRZNPN
.ends

.subckt rhigh_NFPZ4T B R1_0 R2_0 R1_1 R2_1 R1_2 R2_2 R1_3 R2_3 R1_4 R2_4 R1_5 R2_5
+ R1_6 R2_6 R1_7 R2_7 R1_8 R2_8 R1_9 R2_9
X0 R1_3 R2_3 B rhigh l=2.5u w=0.5u
X1 R1_6 R2_6 B rhigh l=2.5u w=0.5u
X2 R1_5 R2_5 B rhigh l=2.5u w=0.5u
X3 R1_2 R2_2 B rhigh l=2.5u w=0.5u
X4 R1_0 R2_0 B rhigh l=2.5u w=0.5u
X5 R1_9 R2_9 B rhigh l=2.5u w=0.5u
X6 R1_4 R2_4 B rhigh l=2.5u w=0.5u
X7 R1_7 R2_7 B rhigh l=2.5u w=0.5u
X8 R1_1 R2_1 B rhigh l=2.5u w=0.5u
X9 R1_8 R2_8 B rhigh l=2.5u w=0.5u
.ends

.subckt sg13_hv_pmos_QH8WBX B D S G
X0 S G D B sg13_hv_pmos ad=0.68p pd=4.68u as=0.68p ps=4.68u w=2u l=0.5u
.ends

.subckt sg13cmos5l_nand3_1 Y A B C VDD VSS
X0 Y C VDD VDD sg13_lv_pmos ad=0.2128p pd=1.5u as=0.3808p ps=2.92u w=1.12u l=0.13u
X1 VDD B Y VDD sg13_lv_pmos ad=0.2128p pd=1.5u as=0.2128p ps=1.5u w=1.12u l=0.13u
X2 Y A VDD VDD sg13_lv_pmos ad=0.3808p pd=2.92u as=0.2128p ps=1.5u w=1.12u l=0.13u
X3 a_146_122# C VSS VSS sg13_lv_nmos ad=0.1406p pd=1.12u as=0.2886p ps=2.26u w=0.74u l=0.13u
X4 a_248_122# B a_146_122# VSS sg13_lv_nmos ad=0.1406p pd=1.12u as=0.1406p ps=1.12u w=0.74u l=0.13u
X5 Y A a_248_122# VSS sg13_lv_nmos ad=0.2516p pd=2.16u as=0.1406p ps=1.12u w=0.74u l=0.13u
.ends

.subckt capacitor_78Y85C c1 c2
C0 c1 c2 1.64243p
.ends

.subckt sg13_hv_pmos_MW6CUW D0 G0 S1 G1 D2 G2 S3 G3 D4 G4 S5 G5 D6 G6 S7 G7 D8 G8
+ S9 G9 D10 G10 S11 G11 D12 G12 S13 G13 D14 G14 S15 G15 D16 G16 S17 G17 D18 G18 S19
+ G19 w_n1914_n224# a_1722_n100#
X0 D12 G11 S11 w_n1914_n224# sg13_hv_pmos ad=0.19p pd=1.38u as=0.19p ps=1.38u w=1u l=0.5u
X1 D4 G3 S3 w_n1914_n224# sg13_hv_pmos ad=0.19p pd=1.38u as=0.19p ps=1.38u w=1u l=0.5u
X2 S19 G18 D18 w_n1914_n224# sg13_hv_pmos ad=0.19p pd=1.38u as=0.19p ps=1.38u w=1u l=0.5u
X3 S5 G4 D4 w_n1914_n224# sg13_hv_pmos ad=0.19p pd=1.38u as=0.19p ps=1.38u w=1u l=0.5u
X4 S11 G10 D10 w_n1914_n224# sg13_hv_pmos ad=0.19p pd=1.38u as=0.19p ps=1.38u w=1u l=0.5u
X5 D14 G13 S13 w_n1914_n224# sg13_hv_pmos ad=0.19p pd=1.38u as=0.19p ps=1.38u w=1u l=0.5u
X6 a_1722_n100# G19 S19 w_n1914_n224# sg13_hv_pmos ad=0.34p pd=2.68u as=0.19p ps=1.38u w=1u l=0.5u
X7 S3 G2 D2 w_n1914_n224# sg13_hv_pmos ad=0.19p pd=1.38u as=0.19p ps=1.38u w=1u l=0.5u
X8 D10 G9 S9 w_n1914_n224# sg13_hv_pmos ad=0.19p pd=1.38u as=0.19p ps=1.38u w=1u l=0.5u
X9 S15 G14 D14 w_n1914_n224# sg13_hv_pmos ad=0.19p pd=1.38u as=0.19p ps=1.38u w=1u l=0.5u
X10 D2 G1 S1 w_n1914_n224# sg13_hv_pmos ad=0.19p pd=1.38u as=0.19p ps=1.38u w=1u l=0.5u
X11 D8 G7 S7 w_n1914_n224# sg13_hv_pmos ad=0.19p pd=1.38u as=0.19p ps=1.38u w=1u l=0.5u
X12 S9 G8 D8 w_n1914_n224# sg13_hv_pmos ad=0.19p pd=1.38u as=0.19p ps=1.38u w=1u l=0.5u
X13 D16 G15 S15 w_n1914_n224# sg13_hv_pmos ad=0.19p pd=1.38u as=0.19p ps=1.38u w=1u l=0.5u
X14 S17 G16 D16 w_n1914_n224# sg13_hv_pmos ad=0.19p pd=1.38u as=0.19p ps=1.38u w=1u l=0.5u
X15 S1 G0 D0 w_n1914_n224# sg13_hv_pmos ad=0.19p pd=1.38u as=0.34p ps=2.68u w=1u l=0.5u
X16 S7 G6 D6 w_n1914_n224# sg13_hv_pmos ad=0.19p pd=1.38u as=0.19p ps=1.38u w=1u l=0.5u
X17 D18 G17 S17 w_n1914_n224# sg13_hv_pmos ad=0.19p pd=1.38u as=0.19p ps=1.38u w=1u l=0.5u
X18 S13 G12 D12 w_n1914_n224# sg13_hv_pmos ad=0.19p pd=1.38u as=0.19p ps=1.38u w=1u l=0.5u
X19 D6 G5 S5 w_n1914_n224# sg13_hv_pmos ad=0.19p pd=1.38u as=0.19p ps=1.38u w=1u l=0.5u
.ends

.subckt sg13_hv_nmos_6DERAL D0 S0 G0 D1 S1 G1 D2 S2 G2 D3 S3 G3 D4 S4 G4 D5 S5 G5
+ D6 S6 G6 D7 S7 G7 D8 S8 G8 D9 S9 G9 D10 S10 G10 D11 S11 G11 sub
X0 S6 G6 D6 sub sg13_hv_nmos ad=0.34p pd=2.68u as=0.34p ps=2.68u w=1u l=0.5u
X1 S8 G8 D8 sub sg13_hv_nmos ad=0.34p pd=2.68u as=0.34p ps=2.68u w=1u l=0.5u
X2 D1 G1 S1 sub sg13_hv_nmos ad=0.34p pd=2.68u as=0.34p ps=2.68u w=1u l=0.5u
X3 S0 G0 D0 sub sg13_hv_nmos ad=0.34p pd=2.68u as=0.34p ps=2.68u w=1u l=0.5u
X4 D5 G5 S5 sub sg13_hv_nmos ad=0.34p pd=2.68u as=0.34p ps=2.68u w=1u l=0.5u
X5 D9 G9 S9 sub sg13_hv_nmos ad=0.34p pd=2.68u as=0.34p ps=2.68u w=1u l=0.5u
X6 S4 G4 D4 sub sg13_hv_nmos ad=0.34p pd=2.68u as=0.34p ps=2.68u w=1u l=0.5u
X7 D3 G3 S3 sub sg13_hv_nmos ad=0.34p pd=2.68u as=0.34p ps=2.68u w=1u l=0.5u
X8 S10 G10 D10 sub sg13_hv_nmos ad=0.34p pd=2.68u as=0.34p ps=2.68u w=1u l=0.5u
X9 D11 G11 S11 sub sg13_hv_nmos ad=0.34p pd=2.68u as=0.34p ps=2.68u w=1u l=0.5u
X10 D7 G7 S7 sub sg13_hv_nmos ad=0.34p pd=2.68u as=0.34p ps=2.68u w=1u l=0.5u
X11 S2 G2 D2 sub sg13_hv_nmos ad=0.34p pd=2.68u as=0.34p ps=2.68u w=1u l=0.5u
.ends

.subckt sg13_hv_pmos_W338R3 D0_0 S0_0 G0_0 D0_1 S0_1 G0_1 D1_0 S1_0 G1_0 D1_1 S1_1
+ G1_1 D2_0 S2_0 G2_0 D2_1 S2_1 G2_1 D3_0 S3_0 G3_0 D3_1 S3_1 G3_1 D4_0 S4_0 G4_0
+ D4_1 S4_1 G4_1 D5_0 S5_0 G5_0 D5_1 S5_1 G5_1 D6_0 S6_0 G6_0 D6_1 S6_1 G6_1 D7_0
+ S7_0 G7_0 D7_1 S7_1 G7_1 D8_0 S8_0 G8_0 D8_1 S8_1 G8_1 D9_0 S9_0 G9_0 D9_1 S9_1
+ G9_1 w_n1993_n416#
X0 D7_1 G7_1 S7_1 w_n1993_n416# sg13_hv_pmos ad=0.34p pd=2.68u as=0.34p ps=2.68u w=1u l=1u
X1 S2_0 G2_0 D2_0 w_n1993_n416# sg13_hv_pmos ad=0.34p pd=2.68u as=0.34p ps=2.68u w=1u l=1u
X2 S6_0 G6_0 D6_0 w_n1993_n416# sg13_hv_pmos ad=0.34p pd=2.68u as=0.34p ps=2.68u w=1u l=1u
X3 D1_0 G1_0 S1_0 w_n1993_n416# sg13_hv_pmos ad=0.34p pd=2.68u as=0.34p ps=2.68u w=1u l=1u
X4 D1_1 G1_1 S1_1 w_n1993_n416# sg13_hv_pmos ad=0.34p pd=2.68u as=0.34p ps=2.68u w=1u l=1u
X5 D9_1 G9_1 S9_1 w_n1993_n416# sg13_hv_pmos ad=0.34p pd=2.68u as=0.34p ps=2.68u w=1u l=1u
X6 S0_0 G0_0 D0_0 w_n1993_n416# sg13_hv_pmos ad=0.34p pd=2.68u as=0.34p ps=2.68u w=1u l=1u
X7 D7_0 G7_0 S7_0 w_n1993_n416# sg13_hv_pmos ad=0.34p pd=2.68u as=0.34p ps=2.68u w=1u l=1u
X8 S6_1 G6_1 D6_1 w_n1993_n416# sg13_hv_pmos ad=0.34p pd=2.68u as=0.34p ps=2.68u w=1u l=1u
X9 D3_1 G3_1 S3_1 w_n1993_n416# sg13_hv_pmos ad=0.34p pd=2.68u as=0.34p ps=2.68u w=1u l=1u
X10 S8_0 G8_0 D8_0 w_n1993_n416# sg13_hv_pmos ad=0.34p pd=2.68u as=0.34p ps=2.68u w=1u l=1u
X11 S2_1 G2_1 D2_1 w_n1993_n416# sg13_hv_pmos ad=0.34p pd=2.68u as=0.34p ps=2.68u w=1u l=1u
X12 D9_0 G9_0 S9_0 w_n1993_n416# sg13_hv_pmos ad=0.34p pd=2.68u as=0.34p ps=2.68u w=1u l=1u
X13 S8_1 G8_1 D8_1 w_n1993_n416# sg13_hv_pmos ad=0.34p pd=2.68u as=0.34p ps=2.68u w=1u l=1u
X14 D5_0 G5_0 S5_0 w_n1993_n416# sg13_hv_pmos ad=0.34p pd=2.68u as=0.34p ps=2.68u w=1u l=1u
X15 S4_1 G4_1 D4_1 w_n1993_n416# sg13_hv_pmos ad=0.34p pd=2.68u as=0.34p ps=2.68u w=1u l=1u
X16 S4_0 G4_0 D4_0 w_n1993_n416# sg13_hv_pmos ad=0.34p pd=2.68u as=0.34p ps=2.68u w=1u l=1u
X17 D3_0 G3_0 S3_0 w_n1993_n416# sg13_hv_pmos ad=0.34p pd=2.68u as=0.34p ps=2.68u w=1u l=1u
X18 S0_1 G0_1 D0_1 w_n1993_n416# sg13_hv_pmos ad=0.34p pd=2.68u as=0.34p ps=2.68u w=1u l=1u
X19 D5_1 G5_1 S5_1 w_n1993_n416# sg13_hv_pmos ad=0.34p pd=2.68u as=0.34p ps=2.68u w=1u l=1u
.ends

.subckt p_amp_large avss out inn inp avdd ena_b ibias
Xsg13_hv_pmos_MW6CUW_1 sg13_hv_pmos_MW6CUW_2/D8 inp sg13_hv_pmos_MW6CUW_2/S7 inp sg13_hv_pmos_MW6CUW_2/D8
+ inn out inn sg13_hv_pmos_MW6CUW_2/D8 inp sg13_hv_pmos_MW6CUW_2/S7 inp sg13_hv_pmos_MW6CUW_2/D8
+ inn out inn sg13_hv_pmos_MW6CUW_2/D8 inp sg13_hv_pmos_MW6CUW_2/S7 inp sg13_hv_pmos_MW6CUW_2/D8
+ inn out inn sg13_hv_pmos_MW6CUW_2/D8 inp sg13_hv_pmos_MW6CUW_2/S7 inp sg13_hv_pmos_MW6CUW_2/D8
+ inn out inn sg13_hv_pmos_MW6CUW_2/D8 inp sg13_hv_pmos_MW6CUW_2/S7 inp sg13_hv_pmos_MW6CUW_2/D8
+ inn out inn avdd sg13_hv_pmos_MW6CUW_2/D8 sg13_hv_pmos_MW6CUW
Xsg13_hv_pmos_MW6CUW_2 sg13_hv_pmos_MW6CUW_2/D8 inn out inn sg13_hv_pmos_MW6CUW_2/D8
+ inp sg13_hv_pmos_MW6CUW_2/S7 inp sg13_hv_pmos_MW6CUW_2/D8 inn out inn sg13_hv_pmos_MW6CUW_2/D8
+ inp sg13_hv_pmos_MW6CUW_2/S7 inp sg13_hv_pmos_MW6CUW_2/D8 inn out inn sg13_hv_pmos_MW6CUW_2/D8
+ inp sg13_hv_pmos_MW6CUW_2/S7 inp sg13_hv_pmos_MW6CUW_2/D8 inn out inn sg13_hv_pmos_MW6CUW_2/D8
+ inp sg13_hv_pmos_MW6CUW_2/S7 inp sg13_hv_pmos_MW6CUW_2/D8 inn out inn sg13_hv_pmos_MW6CUW_2/D8
+ inp sg13_hv_pmos_MW6CUW_2/S7 inp avdd sg13_hv_pmos_MW6CUW_2/D8 sg13_hv_pmos_MW6CUW
Xsg13_hv_nmos_6DERAL_0 avss avss avss out avss sg13_hv_pmos_MW6CUW_2/S7 avss sg13_hv_pmos_MW6CUW_2/S7
+ sg13_hv_pmos_MW6CUW_2/S7 out avss sg13_hv_pmos_MW6CUW_2/S7 avss sg13_hv_pmos_MW6CUW_2/S7
+ sg13_hv_pmos_MW6CUW_2/S7 out avss sg13_hv_pmos_MW6CUW_2/S7 avss sg13_hv_pmos_MW6CUW_2/S7
+ sg13_hv_pmos_MW6CUW_2/S7 out avss sg13_hv_pmos_MW6CUW_2/S7 avss sg13_hv_pmos_MW6CUW_2/S7
+ sg13_hv_pmos_MW6CUW_2/S7 out avss sg13_hv_pmos_MW6CUW_2/S7 avss sg13_hv_pmos_MW6CUW_2/S7
+ sg13_hv_pmos_MW6CUW_2/S7 avss avss avss avss sg13_hv_nmos_6DERAL
Xsg13_hv_nmos_6DERAL_1 avss avss avss sg13_hv_pmos_MW6CUW_2/S7 avss sg13_hv_pmos_MW6CUW_2/S7
+ avss out sg13_hv_pmos_MW6CUW_2/S7 sg13_hv_pmos_MW6CUW_2/S7 avss sg13_hv_pmos_MW6CUW_2/S7
+ avss out sg13_hv_pmos_MW6CUW_2/S7 sg13_hv_pmos_MW6CUW_2/S7 avss sg13_hv_pmos_MW6CUW_2/S7
+ avss out sg13_hv_pmos_MW6CUW_2/S7 sg13_hv_pmos_MW6CUW_2/S7 avss sg13_hv_pmos_MW6CUW_2/S7
+ avss out sg13_hv_pmos_MW6CUW_2/S7 sg13_hv_pmos_MW6CUW_2/S7 avss sg13_hv_pmos_MW6CUW_2/S7
+ avss out sg13_hv_pmos_MW6CUW_2/S7 avss avss avss avss sg13_hv_nmos_6DERAL
Xsg13_hv_pmos_W338R3_0 avdd sg13_hv_pmos_MW6CUW_2/D8 sg13_hv_pmos_MW6CUW_0/D8 avdd
+ sg13_hv_pmos_MW6CUW_0/D8 sg13_hv_pmos_MW6CUW_0/D8 sg13_hv_pmos_MW6CUW_0/D8 avdd
+ sg13_hv_pmos_MW6CUW_0/D8 sg13_hv_pmos_MW6CUW_2/D8 avdd sg13_hv_pmos_MW6CUW_0/D8
+ avdd sg13_hv_pmos_MW6CUW_2/D8 sg13_hv_pmos_MW6CUW_0/D8 avdd sg13_hv_pmos_MW6CUW_0/D8
+ sg13_hv_pmos_MW6CUW_0/D8 sg13_hv_pmos_MW6CUW_0/D8 avdd sg13_hv_pmos_MW6CUW_0/D8
+ sg13_hv_pmos_MW6CUW_2/D8 avdd sg13_hv_pmos_MW6CUW_0/D8 avdd sg13_hv_pmos_MW6CUW_2/D8
+ sg13_hv_pmos_MW6CUW_0/D8 avdd sg13_hv_pmos_MW6CUW_0/D8 sg13_hv_pmos_MW6CUW_0/D8
+ sg13_hv_pmos_MW6CUW_0/D8 avdd sg13_hv_pmos_MW6CUW_0/D8 sg13_hv_pmos_MW6CUW_2/D8
+ avdd sg13_hv_pmos_MW6CUW_0/D8 avdd sg13_hv_pmos_MW6CUW_2/D8 sg13_hv_pmos_MW6CUW_0/D8
+ avdd sg13_hv_pmos_MW6CUW_0/D8 sg13_hv_pmos_MW6CUW_0/D8 sg13_hv_pmos_MW6CUW_0/D8
+ avdd sg13_hv_pmos_MW6CUW_0/D8 sg13_hv_pmos_MW6CUW_2/D8 avdd sg13_hv_pmos_MW6CUW_0/D8
+ avdd sg13_hv_pmos_MW6CUW_2/D8 sg13_hv_pmos_MW6CUW_0/D8 avdd sg13_hv_pmos_MW6CUW_0/D8
+ sg13_hv_pmos_MW6CUW_0/D8 sg13_hv_pmos_MW6CUW_0/D8 avdd sg13_hv_pmos_MW6CUW_0/D8
+ sg13_hv_pmos_MW6CUW_2/D8 avdd sg13_hv_pmos_MW6CUW_0/D8 avdd sg13_hv_pmos_W338R3
Xsg13_hv_pmos_W338R3_1 avdd sg13_hv_pmos_MW6CUW_2/D8 sg13_hv_pmos_MW6CUW_0/D8 avdd
+ sg13_hv_pmos_MW6CUW_0/D8 sg13_hv_pmos_MW6CUW_0/D8 sg13_hv_pmos_MW6CUW_0/D8 avdd
+ sg13_hv_pmos_MW6CUW_0/D8 sg13_hv_pmos_MW6CUW_2/D8 avdd sg13_hv_pmos_MW6CUW_0/D8
+ avdd sg13_hv_pmos_MW6CUW_2/D8 sg13_hv_pmos_MW6CUW_0/D8 avdd sg13_hv_pmos_MW6CUW_0/D8
+ sg13_hv_pmos_MW6CUW_0/D8 sg13_hv_pmos_MW6CUW_0/D8 avdd sg13_hv_pmos_MW6CUW_0/D8
+ sg13_hv_pmos_MW6CUW_2/D8 avdd sg13_hv_pmos_MW6CUW_0/D8 avdd sg13_hv_pmos_MW6CUW_2/D8
+ sg13_hv_pmos_MW6CUW_0/D8 avdd sg13_hv_pmos_MW6CUW_0/D8 sg13_hv_pmos_MW6CUW_0/D8
+ sg13_hv_pmos_MW6CUW_0/D8 avdd sg13_hv_pmos_MW6CUW_0/D8 sg13_hv_pmos_MW6CUW_2/D8
+ avdd sg13_hv_pmos_MW6CUW_0/D8 avdd sg13_hv_pmos_MW6CUW_2/D8 sg13_hv_pmos_MW6CUW_0/D8
+ avdd sg13_hv_pmos_MW6CUW_0/D8 sg13_hv_pmos_MW6CUW_0/D8 sg13_hv_pmos_MW6CUW_0/D8
+ avdd sg13_hv_pmos_MW6CUW_0/D8 sg13_hv_pmos_MW6CUW_2/D8 avdd sg13_hv_pmos_MW6CUW_0/D8
+ avdd sg13_hv_pmos_MW6CUW_2/D8 sg13_hv_pmos_MW6CUW_0/D8 avdd sg13_hv_pmos_MW6CUW_0/D8
+ sg13_hv_pmos_MW6CUW_0/D8 sg13_hv_pmos_MW6CUW_0/D8 avdd sg13_hv_pmos_MW6CUW_0/D8
+ sg13_hv_pmos_MW6CUW_2/D8 avdd sg13_hv_pmos_MW6CUW_0/D8 avdd sg13_hv_pmos_W338R3
Xsg13_hv_pmos_MW6CUW_0 sg13_hv_pmos_MW6CUW_0/D8 ena_b ibias ena_b sg13_hv_pmos_MW6CUW_0/D8
+ ena_b ibias ena_b sg13_hv_pmos_MW6CUW_0/D8 ena_b ibias ena_b sg13_hv_pmos_MW6CUW_0/D8
+ ena_b ibias ena_b sg13_hv_pmos_MW6CUW_0/D8 ena_b ibias ena_b sg13_hv_pmos_MW6CUW_0/D8
+ ena_b ibias ena_b sg13_hv_pmos_MW6CUW_0/D8 ena_b ibias ena_b sg13_hv_pmos_MW6CUW_0/D8
+ ena_b ibias ena_b sg13_hv_pmos_MW6CUW_0/D8 ena_b ibias ena_b sg13_hv_pmos_MW6CUW_0/D8
+ ena_b ibias ena_b avdd sg13_hv_pmos_MW6CUW_0/D8 sg13_hv_pmos_MW6CUW
.ends

.subckt sg13_hv_pmos_7A8CUW D0 S0 G0 D1 S1 G1 D2 S2 G2 D3 S3 G3 D4 S4 G4 D5 S5 G5
+ D6 S6 G6 D7 S7 G7 D8 S8 G8 D9 S9 G9 D10 S10 G10 D11 S11 G11 w_n1771_n224#
X0 S6 G6 D6 w_n1771_n224# sg13_hv_pmos ad=0.34p pd=2.68u as=0.34p ps=2.68u w=1u l=0.5u
X1 S8 G8 D8 w_n1771_n224# sg13_hv_pmos ad=0.34p pd=2.68u as=0.34p ps=2.68u w=1u l=0.5u
X2 D1 G1 S1 w_n1771_n224# sg13_hv_pmos ad=0.34p pd=2.68u as=0.34p ps=2.68u w=1u l=0.5u
X3 S0 G0 D0 w_n1771_n224# sg13_hv_pmos ad=0.34p pd=2.68u as=0.34p ps=2.68u w=1u l=0.5u
X4 D5 G5 S5 w_n1771_n224# sg13_hv_pmos ad=0.34p pd=2.68u as=0.34p ps=2.68u w=1u l=0.5u
X5 D9 G9 S9 w_n1771_n224# sg13_hv_pmos ad=0.34p pd=2.68u as=0.34p ps=2.68u w=1u l=0.5u
X6 S4 G4 D4 w_n1771_n224# sg13_hv_pmos ad=0.34p pd=2.68u as=0.34p ps=2.68u w=1u l=0.5u
X7 D3 G3 S3 w_n1771_n224# sg13_hv_pmos ad=0.34p pd=2.68u as=0.34p ps=2.68u w=1u l=0.5u
X8 S10 G10 D10 w_n1771_n224# sg13_hv_pmos ad=0.34p pd=2.68u as=0.34p ps=2.68u w=1u l=0.5u
X9 D11 G11 S11 w_n1771_n224# sg13_hv_pmos ad=0.34p pd=2.68u as=0.34p ps=2.68u w=1u l=0.5u
X10 S2 G2 D2 w_n1771_n224# sg13_hv_pmos ad=0.34p pd=2.68u as=0.34p ps=2.68u w=1u l=0.5u
X11 D7 G7 S7 w_n1771_n224# sg13_hv_pmos ad=0.34p pd=2.68u as=0.34p ps=2.68u w=1u l=0.5u
.ends

.subckt sg13_hv_nmos_XVVFQX D0_0 S0_0 G0_0 D0_1 S0_1 G0_1 D1_0 S1_0 G1_0 D1_1 S1_1
+ G1_1 D2_0 S2_0 G2_0 D2_1 S2_1 G2_1 D3_0 S3_0 G3_0 D3_1 S3_1 G3_1 D4_0 S4_0 G4_0
+ D4_1 S4_1 G4_1 D5_0 S5_0 G5_0 D5_1 S5_1 G5_1 D6_0 S6_0 G6_0 D6_1 S6_1 G6_1 D7_0
+ S7_0 G7_0 D7_1 S7_1 G7_1 D8_0 S8_0 G8_0 D8_1 S8_1 G8_1 D9_0 S9_0 G9_0 D9_1 S9_1
+ G9_1 sub
X0 D7_1 G7_1 S7_1 sub sg13_hv_nmos ad=0.34p pd=2.68u as=0.34p ps=2.68u w=1u l=1u
X1 S2_0 G2_0 D2_0 sub sg13_hv_nmos ad=0.34p pd=2.68u as=0.34p ps=2.68u w=1u l=1u
X2 D1_0 G1_0 S1_0 sub sg13_hv_nmos ad=0.34p pd=2.68u as=0.34p ps=2.68u w=1u l=1u
X3 S6_0 G6_0 D6_0 sub sg13_hv_nmos ad=0.34p pd=2.68u as=0.34p ps=2.68u w=1u l=1u
X4 D1_1 G1_1 S1_1 sub sg13_hv_nmos ad=0.34p pd=2.68u as=0.34p ps=2.68u w=1u l=1u
X5 D9_1 G9_1 S9_1 sub sg13_hv_nmos ad=0.34p pd=2.68u as=0.34p ps=2.68u w=1u l=1u
X6 S0_0 G0_0 D0_0 sub sg13_hv_nmos ad=0.34p pd=2.68u as=0.34p ps=2.68u w=1u l=1u
X7 D7_0 G7_0 S7_0 sub sg13_hv_nmos ad=0.34p pd=2.68u as=0.34p ps=2.68u w=1u l=1u
X8 S6_1 G6_1 D6_1 sub sg13_hv_nmos ad=0.34p pd=2.68u as=0.34p ps=2.68u w=1u l=1u
X9 D3_1 G3_1 S3_1 sub sg13_hv_nmos ad=0.34p pd=2.68u as=0.34p ps=2.68u w=1u l=1u
X10 S8_0 G8_0 D8_0 sub sg13_hv_nmos ad=0.34p pd=2.68u as=0.34p ps=2.68u w=1u l=1u
X11 S2_1 G2_1 D2_1 sub sg13_hv_nmos ad=0.34p pd=2.68u as=0.34p ps=2.68u w=1u l=1u
X12 D9_0 G9_0 S9_0 sub sg13_hv_nmos ad=0.34p pd=2.68u as=0.34p ps=2.68u w=1u l=1u
X13 S8_1 G8_1 D8_1 sub sg13_hv_nmos ad=0.34p pd=2.68u as=0.34p ps=2.68u w=1u l=1u
X14 D5_0 G5_0 S5_0 sub sg13_hv_nmos ad=0.34p pd=2.68u as=0.34p ps=2.68u w=1u l=1u
X15 S4_1 G4_1 D4_1 sub sg13_hv_nmos ad=0.34p pd=2.68u as=0.34p ps=2.68u w=1u l=1u
X16 S4_0 G4_0 D4_0 sub sg13_hv_nmos ad=0.34p pd=2.68u as=0.34p ps=2.68u w=1u l=1u
X17 D3_0 G3_0 S3_0 sub sg13_hv_nmos ad=0.34p pd=2.68u as=0.34p ps=2.68u w=1u l=1u
X18 S0_1 G0_1 D0_1 sub sg13_hv_nmos ad=0.34p pd=2.68u as=0.34p ps=2.68u w=1u l=1u
X19 D5_1 G5_1 S5_1 sub sg13_hv_nmos ad=0.34p pd=2.68u as=0.34p ps=2.68u w=1u l=1u
.ends

.subckt sg13_hv_nmos_666RAL D0 G0 S1 G1 D2 G2 S3 G3 D4 G4 S5 G5 D6 G6 S7 G7 D8 G8
+ S9 G9 D10 G10 S11 G11 D12 G12 S13 G13 D14 G14 S15 G15 D16 G16 S17 G17 D18 G18 S19
+ G19 a_1722_n100# sub
X0 D4 G3 S3 sub sg13_hv_nmos ad=0.19p pd=1.38u as=0.19p ps=1.38u w=1u l=0.5u
X1 S19 G18 D18 sub sg13_hv_nmos ad=0.19p pd=1.38u as=0.19p ps=1.38u w=1u l=0.5u
X2 S5 G4 D4 sub sg13_hv_nmos ad=0.19p pd=1.38u as=0.19p ps=1.38u w=1u l=0.5u
X3 S11 G10 D10 sub sg13_hv_nmos ad=0.19p pd=1.38u as=0.19p ps=1.38u w=1u l=0.5u
X4 D14 G13 S13 sub sg13_hv_nmos ad=0.19p pd=1.38u as=0.19p ps=1.38u w=1u l=0.5u
X5 a_1722_n100# G19 S19 sub sg13_hv_nmos ad=0.34p pd=2.68u as=0.19p ps=1.38u w=1u l=0.5u
X6 S3 G2 D2 sub sg13_hv_nmos ad=0.19p pd=1.38u as=0.19p ps=1.38u w=1u l=0.5u
X7 D10 G9 S9 sub sg13_hv_nmos ad=0.19p pd=1.38u as=0.19p ps=1.38u w=1u l=0.5u
X8 S15 G14 D14 sub sg13_hv_nmos ad=0.19p pd=1.38u as=0.19p ps=1.38u w=1u l=0.5u
X9 D2 G1 S1 sub sg13_hv_nmos ad=0.19p pd=1.38u as=0.19p ps=1.38u w=1u l=0.5u
X10 D8 G7 S7 sub sg13_hv_nmos ad=0.19p pd=1.38u as=0.19p ps=1.38u w=1u l=0.5u
X11 S9 G8 D8 sub sg13_hv_nmos ad=0.19p pd=1.38u as=0.19p ps=1.38u w=1u l=0.5u
X12 D16 G15 S15 sub sg13_hv_nmos ad=0.19p pd=1.38u as=0.19p ps=1.38u w=1u l=0.5u
X13 S17 G16 D16 sub sg13_hv_nmos ad=0.19p pd=1.38u as=0.19p ps=1.38u w=1u l=0.5u
X14 S1 G0 D0 sub sg13_hv_nmos ad=0.19p pd=1.38u as=0.34p ps=2.68u w=1u l=0.5u
X15 S7 G6 D6 sub sg13_hv_nmos ad=0.19p pd=1.38u as=0.19p ps=1.38u w=1u l=0.5u
X16 D18 G17 S17 sub sg13_hv_nmos ad=0.19p pd=1.38u as=0.19p ps=1.38u w=1u l=0.5u
X17 S13 G12 D12 sub sg13_hv_nmos ad=0.19p pd=1.38u as=0.19p ps=1.38u w=1u l=0.5u
X18 D6 G5 S5 sub sg13_hv_nmos ad=0.19p pd=1.38u as=0.19p ps=1.38u w=1u l=0.5u
X19 D12 G11 S11 sub sg13_hv_nmos ad=0.19p pd=1.38u as=0.19p ps=1.38u w=1u l=0.5u
.ends

.subckt n_amp_large out inn inp avss ena ibias avdd
Xsg13_hv_pmos_7A8CUW_0 avdd avdd avdd XM6/S7 avdd XM6/S7 avdd out XM6/S7 XM6/S7 avdd
+ XM6/S7 avdd out XM6/S7 XM6/S7 avdd XM6/S7 avdd out XM6/S7 XM6/S7 avdd XM6/S7 avdd
+ out XM6/S7 XM6/S7 avdd XM6/S7 avdd out XM6/S7 avdd avdd avdd avdd sg13_hv_pmos_7A8CUW
Xsg13_hv_nmos_XVVFQX_0 avss XM1/S8_0 XM1/S8_0 avss XM6/D8 XM1/S8_0 XM6/D8 avss XM1/S8_0
+ XM1/S8_0 avss XM1/S8_0 avss XM1/S8_0 XM1/S8_0 avss XM6/D8 XM1/S8_0 XM6/D8 avss XM1/S8_0
+ XM1/S8_0 avss XM1/S8_0 avss XM1/S8_0 XM1/S8_0 avss XM6/D8 XM1/S8_0 XM6/D8 avss XM1/S8_0
+ XM1/S8_0 avss XM1/S8_0 avss XM1/S8_0 XM1/S8_0 avss XM6/D8 XM1/S8_0 XM6/D8 avss XM1/S8_0
+ XM1/S8_0 avss XM1/S8_0 avss XM1/S8_0 XM1/S8_0 avss XM6/D8 XM1/S8_0 XM6/D8 avss XM1/S8_0
+ XM1/S8_0 avss XM1/S8_0 avss sg13_hv_nmos_XVVFQX
XXM1 avss XM1/S8_0 XM1/S8_0 avss XM6/D8 XM1/S8_0 XM6/D8 avss XM1/S8_0 XM1/S8_0 avss
+ XM1/S8_0 avss XM1/S8_0 XM1/S8_0 avss XM6/D8 XM1/S8_0 XM6/D8 avss XM1/S8_0 XM1/S8_0
+ avss XM1/S8_0 avss XM1/S8_0 XM1/S8_0 avss XM6/D8 XM1/S8_0 XM6/D8 avss XM1/S8_0 XM1/S8_0
+ avss XM1/S8_0 avss XM1/S8_0 XM1/S8_0 avss XM6/D8 XM1/S8_0 XM6/D8 avss XM1/S8_0 XM1/S8_0
+ avss XM1/S8_0 avss XM1/S8_0 XM1/S8_0 avss XM6/D8 XM1/S8_0 XM6/D8 avss XM1/S8_0 XM1/S8_0
+ avss XM1/S8_0 avss sg13_hv_nmos_XVVFQX
XXM2 avdd avdd avdd out avdd XM6/S7 avdd XM6/S7 XM6/S7 out avdd XM6/S7 avdd XM6/S7
+ XM6/S7 out avdd XM6/S7 avdd XM6/S7 XM6/S7 out avdd XM6/S7 avdd XM6/S7 XM6/S7 out
+ avdd XM6/S7 avdd XM6/S7 XM6/S7 avdd avdd avdd avdd sg13_hv_pmos_7A8CUW
XXM5 XM6/D8 inp XM6/S7 inp XM6/D8 inn out inn XM6/D8 inp XM6/S7 inp XM6/D8 inn out
+ inn XM6/D8 inp XM6/S7 inp XM6/D8 inn out inn XM6/D8 inp XM6/S7 inp XM6/D8 inn out
+ inn XM6/D8 inp XM6/S7 inp XM6/D8 inn out inn XM6/D8 avss sg13_hv_nmos_666RAL
XXM6 XM6/D8 inn out inn XM6/D8 inp XM6/S7 inp XM6/D8 inn out inn XM6/D8 inp XM6/S7
+ inp XM6/D8 inn out inn XM6/D8 inp XM6/S7 inp XM6/D8 inn out inn XM6/D8 inp XM6/S7
+ inp XM6/D8 inn out inn XM6/D8 inp XM6/S7 inp XM6/D8 avss sg13_hv_nmos_666RAL
Xsg13_hv_nmos_666RAL_0 XM1/S8_0 ena ibias ena XM1/S8_0 ena ibias ena XM1/S8_0 ena
+ ibias ena XM1/S8_0 ena ibias ena XM1/S8_0 ena ibias ena XM1/S8_0 ena ibias ena XM1/S8_0
+ ena ibias ena XM1/S8_0 ena ibias ena XM1/S8_0 ena ibias ena XM1/S8_0 ena ibias ena
+ XM1/S8_0 avss sg13_hv_nmos_666RAL
.ends

.subckt sg13cmos5l_ocd_ip__voltgen dvdd vbg ibias1u_1 vout2 ibias1u_2 vout1 ena1 ena2
+ ibias1u_3 high s[2] vdd s[0] vss s[1] dvss ena
Xsg13cmos5l_inv_2_0 sg13cmos5l_inv_2_0/Y sg13cmos5l_inv_2_0/A dvdd dvss sg13cmos5l_inv_2
Xhv_inv_1_0 vdd x6/ena vss x6/ena_b hv_inv_1
Xsg13cmos5l_inv_2_1 sg13cmos5l_inv_2_1/Y sg13cmos5l_inv_2_1/A dvdd dvss sg13cmos5l_inv_2
Xhv_inv_1_1 vdd hv_inv_1_1/X vss v0 hv_inv_1
Xsg13cmos5l_inv_2_2 sg13cmos5l_inv_2_2/Y sg13cmos5l_inv_2_2/A dvdd dvss sg13cmos5l_inv_2
Xhv_inv_1_2 vdd hv_inv_1_2/X vss v2 hv_inv_1
Xhv_inv_1_3 vdd hv_inv_1_3/X vss v1 hv_inv_1
Xsg13cmos5l_inv_2_3 sg13cmos5l_inv_2_3/Y sg13cmos5l_inv_2_3/A dvdd dvss sg13cmos5l_inv_2
Xsg13cmos5l_inv_2_4 sg13cmos5l_inv_2_4/Y sg13cmos5l_inv_2_4/A dvdd dvss sg13cmos5l_inv_2
Xhv_inv_1_4 vdd hv_inv_1_4/X vss v4 hv_inv_1
Xse_folded_cascode_p_0 vout2 ibias1u_3 level_shift_2/out vout2 x50/inp vdd vss se_folded_cascode_p
Xx6 x6/ena_b x6/in vref3 x6/ena vss vdd xgate
Xhv_inv_1_5 vdd hv_inv_1_5/X vss v3 hv_inv_1
Xsg13cmos5l_inv_2_5 level_shift_3/in_p ena1 dvdd dvss sg13cmos5l_inv_2
XXR1 vss vss vss vss vref0 vref1 vref0 vref1 vref2 vref3 vref2 vref3 vref4 vref5 vref4
+ vref5 vref6 vref7 vref6 vss vss rhigh_NFPZ4T
Xsg13cmos5l_inv_2_6 level_shift_2/in_p ena2 dvdd dvss sg13cmos5l_inv_2
Xhv_inv_1_6 vdd hv_inv_1_6/X vss v6 hv_inv_1
Xhv_inv_1_7 vdd hv_inv_1_7/X vss v5 hv_inv_1
Xsg13cmos5l_inv_2_7 sg13cmos5l_inv_2_7/Y ena dvdd dvss sg13cmos5l_inv_2
Xsg13cmos5l_inv_2_8 s0b s[0] dvdd dvss sg13cmos5l_inv_2
Xhv_inv_1_8 vdd hv_inv_1_8/X vss v7 hv_inv_1
Xsg13cmos5l_inv_2_9 s0 s0b dvdd dvss sg13cmos5l_inv_2
Xxgate_0 x6/ena x6/in vref2 x6/ena_b vss vdd xgate
Xxgate_1 hv_inv_1_1/X vref0 x50/inp v0 vss vdd xgate
XXM1 vdd vref7 vdd XM1/G sg13_hv_pmos_QH8WBX
Xxgate_2 hv_inv_1_3/X vref1 x50/inp v1 vss vdd xgate
Xsg13cmos5l_antennanp_0 s[2] dvdd dvss sg13cmos5l_antennanp
Xsg13cmos5l_antennanp_1 s[1] dvdd dvss sg13cmos5l_antennanp
Xxgate_3 hv_inv_1_2/X vref2 x50/inp v2 vss vdd xgate
Xxgate_4 hv_inv_1_5/X vref3 x50/inp v3 vss vdd xgate
Xsg13cmos5l_antennanp_2 s[0] dvdd dvss sg13cmos5l_antennanp
Xsg13cmos5l_nand3_1_0 sg13cmos5l_inv_2_1/A s2 s1 s0b dvdd dvss sg13cmos5l_nand3_1
Xsg13cmos5l_antennanp_3 ena dvdd dvss sg13cmos5l_antennanp
Xxgate_5 hv_inv_1_7/X vref5 x50/inp v5 vss vdd xgate
Xxgate_6 hv_inv_1_4/X vref4 x50/inp v4 vss vdd xgate
Xsg13cmos5l_antennanp_4 ena2 dvdd dvss sg13cmos5l_antennanp
Xsg13cmos5l_nand3_1_1 sg13cmos5l_inv_2_0/A s2b s1 s0b dvdd dvss sg13cmos5l_nand3_1
Xsg13cmos5l_nand3_1_2 sg13cmos5l_inv_2_4/A s2 s1b s0b dvdd dvss sg13cmos5l_nand3_1
Xsg13cmos5l_antennanp_5 ena1 dvdd dvss sg13cmos5l_antennanp
XC1 vdd XM1/G capacitor_78Y85C
Xxgate_7 hv_inv_1_6/X vref6 x50/inp v6 vss vdd xgate
Xxgate_8 hv_inv_1_8/X vref7 x50/inp v7 vss vdd xgate
Xsg13cmos5l_nand3_1_3 sg13cmos5l_inv_2_2/A s2b s1b s0b dvdd dvss sg13cmos5l_nand3_1
Xsg13cmos5l_antennanp_7 high dvdd dvss sg13cmos5l_antennanp
Xsg13cmos5l_nand3_1_4 sg13cmos5l_inv_2_3/A s2b s1b s0 dvdd dvss sg13cmos5l_nand3_1
Xx50 vss vout1 vout1 x50/inp vdd x50/ena_b ibias1u_2 p_amp_large
Xsg13cmos5l_nand3_1_5 sg13cmos5l_inv_2_14/A s2 s1b s0 dvdd dvss sg13cmos5l_nand3_1
Xlevel_shift_0[0] x14/A x14/Y vdd v7 vss level_shift
Xlevel_shift_0[1] sg13cmos5l_inv_2_4/A sg13cmos5l_inv_2_4/Y vdd v4 vss level_shift
Xlevel_shift_0[2] sg13cmos5l_inv_2_0/A sg13cmos5l_inv_2_0/Y vdd v2 vss level_shift
Xlevel_shift_0[3] sg13cmos5l_inv_2_2/A sg13cmos5l_inv_2_2/Y vdd v0 vss level_shift
Xlevel_shift_0[4] sg13cmos5l_inv_2_7/Y ena vdd x48/ena vss level_shift
Xlevel_shift_1[0] sg13cmos5l_inv_2_1/A sg13cmos5l_inv_2_1/Y vdd v6 vss level_shift
Xlevel_shift_1[1] sg13cmos5l_inv_2_14/A sg13cmos5l_inv_2_14/Y vdd v5 vss level_shift
Xlevel_shift_1[2] x35/Y x34/Y vdd v3 vss level_shift
Xlevel_shift_1[3] sg13cmos5l_inv_2_3/A sg13cmos5l_inv_2_3/Y vdd v1 vss level_shift
Xlevel_shift_1[4] sg13cmos5l_inv_2_15/Y high vdd x6/ena_b vss level_shift
Xlevel_shift_2 ena2 level_shift_2/in_p vdd level_shift_2/out vss level_shift
Xsg13cmos5l_decap_4_0 dvdd dvss sg13cmos5l_decap_4
Xlevel_shift_3 ena1 level_shift_3/in_p vdd x50/ena_b vss level_shift
Xx34 x34/Y x35/Y dvdd dvss sg13cmos5l_inv_2
Xx13 x14/A s2 s1 s0 dvdd dvss sg13cmos5l_nand3_1
Xx35 x35/Y s2b s1 s0 dvdd dvss sg13cmos5l_nand3_1
Xx14 x14/Y x14/A dvdd dvss sg13cmos5l_inv_2
Xx48 XM1/G vbg x6/in vss x48/ena ibias1u_1 vdd n_amp_large
Xsg13cmos5l_inv_2_10 s1 s1b dvdd dvss sg13cmos5l_inv_2
Xsg13cmos5l_inv_2_11 s2 s2b dvdd dvss sg13cmos5l_inv_2
Xsg13cmos5l_inv_2_12 s2b s[2] dvdd dvss sg13cmos5l_inv_2
Xsg13cmos5l_inv_2_13 s1b s[1] dvdd dvss sg13cmos5l_inv_2
Xsg13cmos5l_inv_2_14 sg13cmos5l_inv_2_14/Y sg13cmos5l_inv_2_14/A dvdd dvss sg13cmos5l_inv_2
Xsg13cmos5l_inv_2_15 sg13cmos5l_inv_2_15/Y high dvdd dvss sg13cmos5l_inv_2
.ends

.subckt sg13_hv_nmos_XAVYYR D0 G0 S1 G1 D2 G2 S3 G3 sub a_314_n200#
X0 S3 G2 D2 sub sg13_hv_nmos ad=0.38p pd=2.38u as=0.38p ps=2.38u w=2u l=0.5u
X1 D2 G1 S1 sub sg13_hv_nmos ad=0.38p pd=2.38u as=0.38p ps=2.38u w=2u l=0.5u
X2 S1 G0 D0 sub sg13_hv_nmos ad=0.38p pd=2.38u as=0.68p ps=4.68u w=2u l=0.5u
X3 a_314_n200# G3 S3 sub sg13_hv_nmos ad=0.68p pd=4.68u as=0.38p ps=2.38u w=2u l=0.5u
.ends

.subckt sg13_hv_nmos_3JX36Y D0 G0 S1 G1 D2 G2 S3 G3 D4 G4 S5 G5 D6 G6 S7 G7 D8 G8
+ S9 G9 D10 G10 S11 G11 D12 G12 S13 G13 D14 G14 S15 G15 D16 G16 S17 G17 D18 G18 S19
+ G19 D20 G20 S21 G21 D22 G22 S23 G23 D24 G24 S25 G25 D26 G26 S27 G27 D28 G28 S29
+ G29 D30 G30 S31 G31 D32 G32 S33 G33 D34 G34 S35 G35 D36 G36 S37 G37 D38 G38 S39
+ G39 D40 G40 S41 G41 D42 G42 S43 G43 D44 G44 S45 G45 D46 G46 S47 G47 D48 G48 S49
+ G49 D50 G50 S51 G51 D52 G52 S53 G53 D54 G54 S55 G55 D56 G56 S57 G57 D58 G58 S59
+ G59 D60 G60 S61 G61 D62 G62 S63 G63 D64 G64 S65 G65 D66 G66 S67 G67 D68 G68 S69
+ G69 D70 G70 S71 G71 D72 G72 S73 G73 D74 G74 S75 G75 D76 G76 S77 G77 D78 G78 S79
+ G79 D80 G80 S81 G81 D82 G82 S83 G83 D84 G84 S85 G85 D86 G86 S87 G87 a_7706_n500#
+ sub
X0 S27 G26 D26 sub sg13_hv_nmos ad=0.95p pd=5.38u as=0.95p ps=5.38u w=5u l=0.5u
X1 D46 G45 S45 sub sg13_hv_nmos ad=0.95p pd=5.38u as=0.95p ps=5.38u w=5u l=0.5u
X2 D8 G7 S7 sub sg13_hv_nmos ad=0.95p pd=5.38u as=0.95p ps=5.38u w=5u l=0.5u
X3 S15 G14 D14 sub sg13_hv_nmos ad=0.95p pd=5.38u as=0.95p ps=5.38u w=5u l=0.5u
X4 D42 G41 S41 sub sg13_hv_nmos ad=0.95p pd=5.38u as=0.95p ps=5.38u w=5u l=0.5u
X5 D56 G55 S55 sub sg13_hv_nmos ad=0.95p pd=5.38u as=0.95p ps=5.38u w=5u l=0.5u
X6 D74 G73 S73 sub sg13_hv_nmos ad=0.95p pd=5.38u as=0.95p ps=5.38u w=5u l=0.5u
X7 S81 G80 D80 sub sg13_hv_nmos ad=0.95p pd=5.38u as=0.95p ps=5.38u w=5u l=0.5u
X8 D6 G5 S5 sub sg13_hv_nmos ad=0.95p pd=5.38u as=0.95p ps=5.38u w=5u l=0.5u
X9 S83 G82 D82 sub sg13_hv_nmos ad=0.95p pd=5.38u as=0.95p ps=5.38u w=5u l=0.5u
X10 S19 G18 D18 sub sg13_hv_nmos ad=0.95p pd=5.38u as=0.95p ps=5.38u w=5u l=0.5u
X11 S21 G20 D20 sub sg13_hv_nmos ad=0.95p pd=5.38u as=0.95p ps=5.38u w=5u l=0.5u
X12 D26 G25 S25 sub sg13_hv_nmos ad=0.95p pd=5.38u as=0.95p ps=5.38u w=5u l=0.5u
X13 S63 G62 D62 sub sg13_hv_nmos ad=0.95p pd=5.38u as=0.95p ps=5.38u w=5u l=0.5u
X14 D68 G67 S67 sub sg13_hv_nmos ad=0.95p pd=5.38u as=0.95p ps=5.38u w=5u l=0.5u
X15 D70 G69 S69 sub sg13_hv_nmos ad=0.95p pd=5.38u as=0.95p ps=5.38u w=5u l=0.5u
X16 D12 G11 S11 sub sg13_hv_nmos ad=0.95p pd=5.38u as=0.95p ps=5.38u w=5u l=0.5u
X17 S41 G40 D40 sub sg13_hv_nmos ad=0.95p pd=5.38u as=0.95p ps=5.38u w=5u l=0.5u
X18 D82 G81 S81 sub sg13_hv_nmos ad=0.95p pd=5.38u as=0.95p ps=5.38u w=5u l=0.5u
X19 D84 G83 S83 sub sg13_hv_nmos ad=0.95p pd=5.38u as=0.95p ps=5.38u w=5u l=0.5u
X20 D32 G31 S31 sub sg13_hv_nmos ad=0.95p pd=5.38u as=0.95p ps=5.38u w=5u l=0.5u
X21 S39 G38 D38 sub sg13_hv_nmos ad=0.95p pd=5.38u as=0.95p ps=5.38u w=5u l=0.5u
X22 D48 G47 S47 sub sg13_hv_nmos ad=0.95p pd=5.38u as=0.95p ps=5.38u w=5u l=0.5u
X23 D62 G61 S61 sub sg13_hv_nmos ad=0.95p pd=5.38u as=0.95p ps=5.38u w=5u l=0.5u
X24 S13 G12 D12 sub sg13_hv_nmos ad=0.95p pd=5.38u as=0.95p ps=5.38u w=5u l=0.5u
X25 D18 G17 S17 sub sg13_hv_nmos ad=0.95p pd=5.38u as=0.95p ps=5.38u w=5u l=0.5u
X26 D20 G19 S19 sub sg13_hv_nmos ad=0.95p pd=5.38u as=0.95p ps=5.38u w=5u l=0.5u
X27 D50 G49 S49 sub sg13_hv_nmos ad=0.95p pd=5.38u as=0.95p ps=5.38u w=5u l=0.5u
X28 S69 G68 D68 sub sg13_hv_nmos ad=0.95p pd=5.38u as=0.95p ps=5.38u w=5u l=0.5u
X29 S71 G70 D70 sub sg13_hv_nmos ad=0.95p pd=5.38u as=0.95p ps=5.38u w=5u l=0.5u
X30 D76 G75 S75 sub sg13_hv_nmos ad=0.95p pd=5.38u as=0.95p ps=5.38u w=5u l=0.5u
X31 S11 G10 D10 sub sg13_hv_nmos ad=0.95p pd=5.38u as=0.95p ps=5.38u w=5u l=0.5u
X32 D40 G39 S39 sub sg13_hv_nmos ad=0.95p pd=5.38u as=0.95p ps=5.38u w=5u l=0.5u
X33 D78 G77 S77 sub sg13_hv_nmos ad=0.95p pd=5.38u as=0.95p ps=5.38u w=5u l=0.5u
X34 S33 G32 D32 sub sg13_hv_nmos ad=0.95p pd=5.38u as=0.95p ps=5.38u w=5u l=0.5u
X35 S47 G46 D46 sub sg13_hv_nmos ad=0.95p pd=5.38u as=0.95p ps=5.38u w=5u l=0.5u
X36 D58 G57 S57 sub sg13_hv_nmos ad=0.95p pd=5.38u as=0.95p ps=5.38u w=5u l=0.5u
X37 D24 G23 S23 sub sg13_hv_nmos ad=0.95p pd=5.38u as=0.95p ps=5.38u w=5u l=0.5u
X38 S31 G30 D30 sub sg13_hv_nmos ad=0.95p pd=5.38u as=0.95p ps=5.38u w=5u l=0.5u
X39 S49 G48 D48 sub sg13_hv_nmos ad=0.95p pd=5.38u as=0.95p ps=5.38u w=5u l=0.5u
X40 S65 G64 D64 sub sg13_hv_nmos ad=0.95p pd=5.38u as=0.95p ps=5.38u w=5u l=0.5u
X41 S17 G16 D16 sub sg13_hv_nmos ad=0.95p pd=5.38u as=0.95p ps=5.38u w=5u l=0.5u
X42 S77 G76 D76 sub sg13_hv_nmos ad=0.95p pd=5.38u as=0.95p ps=5.38u w=5u l=0.5u
X43 S37 G36 D36 sub sg13_hv_nmos ad=0.95p pd=5.38u as=0.95p ps=5.38u w=5u l=0.5u
X44 S57 G56 D56 sub sg13_hv_nmos ad=0.95p pd=5.38u as=0.95p ps=5.38u w=5u l=0.5u
X45 S5 G4 D4 sub sg13_hv_nmos ad=0.95p pd=5.38u as=0.95p ps=5.38u w=5u l=0.5u
X46 S23 G22 D22 sub sg13_hv_nmos ad=0.95p pd=5.38u as=0.95p ps=5.38u w=5u l=0.5u
X47 S25 G24 D24 sub sg13_hv_nmos ad=0.95p pd=5.38u as=0.95p ps=5.38u w=5u l=0.5u
X48 D30 G29 S29 sub sg13_hv_nmos ad=0.95p pd=5.38u as=0.95p ps=5.38u w=5u l=0.5u
X49 S45 G44 D44 sub sg13_hv_nmos ad=0.95p pd=5.38u as=0.95p ps=5.38u w=5u l=0.5u
X50 S59 G58 D58 sub sg13_hv_nmos ad=0.95p pd=5.38u as=0.95p ps=5.38u w=5u l=0.5u
X51 D64 G63 S63 sub sg13_hv_nmos ad=0.95p pd=5.38u as=0.95p ps=5.38u w=5u l=0.5u
X52 D66 G65 S65 sub sg13_hv_nmos ad=0.95p pd=5.38u as=0.95p ps=5.38u w=5u l=0.5u
X53 S73 G72 D72 sub sg13_hv_nmos ad=0.95p pd=5.38u as=0.95p ps=5.38u w=5u l=0.5u
X54 D38 G37 S37 sub sg13_hv_nmos ad=0.95p pd=5.38u as=0.95p ps=5.38u w=5u l=0.5u
X55 S51 G50 D50 sub sg13_hv_nmos ad=0.95p pd=5.38u as=0.95p ps=5.38u w=5u l=0.5u
X56 S53 G52 D52 sub sg13_hv_nmos ad=0.95p pd=5.38u as=0.95p ps=5.38u w=5u l=0.5u
X57 D4 G3 S3 sub sg13_hv_nmos ad=0.95p pd=5.38u as=0.95p ps=5.38u w=5u l=0.5u
X58 S29 G28 D28 sub sg13_hv_nmos ad=0.95p pd=5.38u as=0.95p ps=5.38u w=5u l=0.5u
X59 D36 G35 S35 sub sg13_hv_nmos ad=0.95p pd=5.38u as=0.95p ps=5.38u w=5u l=0.5u
X60 D60 G59 S59 sub sg13_hv_nmos ad=0.95p pd=5.38u as=0.95p ps=5.38u w=5u l=0.5u
X61 S85 G84 D84 sub sg13_hv_nmos ad=0.95p pd=5.38u as=0.95p ps=5.38u w=5u l=0.5u
X62 D2 G1 S1 sub sg13_hv_nmos ad=0.95p pd=5.38u as=0.95p ps=5.38u w=5u l=0.5u
X63 S67 G66 D66 sub sg13_hv_nmos ad=0.95p pd=5.38u as=0.95p ps=5.38u w=5u l=0.5u
X64 D72 G71 S71 sub sg13_hv_nmos ad=0.95p pd=5.38u as=0.95p ps=5.38u w=5u l=0.5u
X65 D22 G21 S21 sub sg13_hv_nmos ad=0.95p pd=5.38u as=0.95p ps=5.38u w=5u l=0.5u
X66 D52 G51 S51 sub sg13_hv_nmos ad=0.95p pd=5.38u as=0.95p ps=5.38u w=5u l=0.5u
X67 S3 G2 D2 sub sg13_hv_nmos ad=0.95p pd=5.38u as=0.95p ps=5.38u w=5u l=0.5u
X68 D10 G9 S9 sub sg13_hv_nmos ad=0.95p pd=5.38u as=0.95p ps=5.38u w=5u l=0.5u
X69 D28 G27 S27 sub sg13_hv_nmos ad=0.95p pd=5.38u as=0.95p ps=5.38u w=5u l=0.5u
X70 S35 G34 D34 sub sg13_hv_nmos ad=0.95p pd=5.38u as=0.95p ps=5.38u w=5u l=0.5u
X71 D44 G43 S43 sub sg13_hv_nmos ad=0.95p pd=5.38u as=0.95p ps=5.38u w=5u l=0.5u
X72 D54 G53 S53 sub sg13_hv_nmos ad=0.95p pd=5.38u as=0.95p ps=5.38u w=5u l=0.5u
X73 S61 G60 D60 sub sg13_hv_nmos ad=0.95p pd=5.38u as=0.95p ps=5.38u w=5u l=0.5u
X74 S79 G78 D78 sub sg13_hv_nmos ad=0.95p pd=5.38u as=0.95p ps=5.38u w=5u l=0.5u
X75 D86 G85 S85 sub sg13_hv_nmos ad=0.95p pd=5.38u as=0.95p ps=5.38u w=5u l=0.5u
X76 S1 G0 D0 sub sg13_hv_nmos ad=0.95p pd=5.38u as=1.7p ps=10.68u w=5u l=0.5u
X77 a_7706_n500# G87 S87 sub sg13_hv_nmos ad=1.7p pd=10.68u as=0.95p ps=5.38u w=5u l=0.5u
X78 S9 G8 D8 sub sg13_hv_nmos ad=0.95p pd=5.38u as=0.95p ps=5.38u w=5u l=0.5u
X79 D14 G13 S13 sub sg13_hv_nmos ad=0.95p pd=5.38u as=0.95p ps=5.38u w=5u l=0.5u
X80 D16 G15 S15 sub sg13_hv_nmos ad=0.95p pd=5.38u as=0.95p ps=5.38u w=5u l=0.5u
X81 D34 G33 S33 sub sg13_hv_nmos ad=0.95p pd=5.38u as=0.95p ps=5.38u w=5u l=0.5u
X82 S43 G42 D42 sub sg13_hv_nmos ad=0.95p pd=5.38u as=0.95p ps=5.38u w=5u l=0.5u
X83 S55 G54 D54 sub sg13_hv_nmos ad=0.95p pd=5.38u as=0.95p ps=5.38u w=5u l=0.5u
X84 S75 G74 D74 sub sg13_hv_nmos ad=0.95p pd=5.38u as=0.95p ps=5.38u w=5u l=0.5u
X85 D80 G79 S79 sub sg13_hv_nmos ad=0.95p pd=5.38u as=0.95p ps=5.38u w=5u l=0.5u
X86 S7 G6 D6 sub sg13_hv_nmos ad=0.95p pd=5.38u as=0.95p ps=5.38u w=5u l=0.5u
X87 S87 G86 D86 sub sg13_hv_nmos ad=0.95p pd=5.38u as=0.95p ps=5.38u w=5u l=0.5u
.ends

.subckt sg13_hv_pmos_YZSTZS D0 G0 S1 G1 D2 G2 S3 G3 a_314_n400# w_n506_n524#
X0 D2 G1 S1 w_n506_n524# sg13_hv_pmos ad=0.76p pd=4.38u as=0.76p ps=4.38u w=4u l=0.5u
X1 S1 G0 D0 w_n506_n524# sg13_hv_pmos ad=0.76p pd=4.38u as=1.36p ps=8.68u w=4u l=0.5u
X2 a_314_n400# G3 S3 w_n506_n524# sg13_hv_pmos ad=1.36p pd=8.68u as=0.76p ps=4.38u w=4u l=0.5u
X3 S3 G2 D2 w_n506_n524# sg13_hv_pmos ad=0.76p pd=4.38u as=0.76p ps=4.38u w=4u l=0.5u
.ends

.subckt sg13_hv_pmos_RQMCRC D0 G0 S1 G1 D2 G2 S3 G3 D4 G4 S5 G5 D6 G6 S7 G7 D8 G8
+ S9 G9 D10 G10 S11 G11 D12 G12 S13 G13 D14 G14 S15 G15 D16 G16 S17 G17 D18 G18 S19
+ G19 D20 G20 S21 G21 D22 G22 S23 G23 D24 G24 S25 G25 D26 G26 S27 G27 D28 G28 S29
+ G29 D30 G30 S31 G31 D32 G32 S33 G33 D34 G34 S35 G35 D36 G36 S37 G37 D38 G38 S39
+ G39 D40 G40 S41 G41 D42 G42 S43 G43 D44 G44 S45 G45 D46 G46 S47 G47 D48 G48 S49
+ G49 D50 G50 S51 G51 D52 G52 S53 G53 D54 G54 S55 G55 D56 G56 S57 G57 D58 G58 S59
+ G59 D60 G60 S61 G61 D62 G62 S63 G63 D64 G64 S65 G65 D66 G66 S67 G67 D68 G68 S69
+ G69 D70 G70 S71 G71 D72 G72 S73 G73 D74 G74 S75 G75 D76 G76 S77 G77 D78 G78 S79
+ G79 D80 G80 S81 G81 D82 G82 S83 G83 D84 G84 S85 G85 D86 G86 S87 G87 w_n7898_n1124#
+ a_7706_n1000#
X0 D30 G29 S29 w_n7898_n1124# sg13_hv_pmos ad=1.9p pd=10.38u as=1.9p ps=10.38u w=10u l=0.5u
X1 S37 G36 D36 w_n7898_n1124# sg13_hv_pmos ad=1.9p pd=10.38u as=1.9p ps=10.38u w=10u l=0.5u
X2 S45 G44 D44 w_n7898_n1124# sg13_hv_pmos ad=1.9p pd=10.38u as=1.9p ps=10.38u w=10u l=0.5u
X3 S57 G56 D56 w_n7898_n1124# sg13_hv_pmos ad=1.9p pd=10.38u as=1.9p ps=10.38u w=10u l=0.5u
X4 S59 G58 D58 w_n7898_n1124# sg13_hv_pmos ad=1.9p pd=10.38u as=1.9p ps=10.38u w=10u l=0.5u
X5 D64 G63 S63 w_n7898_n1124# sg13_hv_pmos ad=1.9p pd=10.38u as=1.9p ps=10.38u w=10u l=0.5u
X6 S5 G4 D4 w_n7898_n1124# sg13_hv_pmos ad=1.9p pd=10.38u as=1.9p ps=10.38u w=10u l=0.5u
X7 S23 G22 D22 w_n7898_n1124# sg13_hv_pmos ad=1.9p pd=10.38u as=1.9p ps=10.38u w=10u l=0.5u
X8 S25 G24 D24 w_n7898_n1124# sg13_hv_pmos ad=1.9p pd=10.38u as=1.9p ps=10.38u w=10u l=0.5u
X9 D66 G65 S65 w_n7898_n1124# sg13_hv_pmos ad=1.9p pd=10.38u as=1.9p ps=10.38u w=10u l=0.5u
X10 S73 G72 D72 w_n7898_n1124# sg13_hv_pmos ad=1.9p pd=10.38u as=1.9p ps=10.38u w=10u l=0.5u
X11 D36 G35 S35 w_n7898_n1124# sg13_hv_pmos ad=1.9p pd=10.38u as=1.9p ps=10.38u w=10u l=0.5u
X12 D38 G37 S37 w_n7898_n1124# sg13_hv_pmos ad=1.9p pd=10.38u as=1.9p ps=10.38u w=10u l=0.5u
X13 S51 G50 D50 w_n7898_n1124# sg13_hv_pmos ad=1.9p pd=10.38u as=1.9p ps=10.38u w=10u l=0.5u
X14 S53 G52 D52 w_n7898_n1124# sg13_hv_pmos ad=1.9p pd=10.38u as=1.9p ps=10.38u w=10u l=0.5u
X15 D60 G59 S59 w_n7898_n1124# sg13_hv_pmos ad=1.9p pd=10.38u as=1.9p ps=10.38u w=10u l=0.5u
X16 D2 G1 S1 w_n7898_n1124# sg13_hv_pmos ad=1.9p pd=10.38u as=1.9p ps=10.38u w=10u l=0.5u
X17 D4 G3 S3 w_n7898_n1124# sg13_hv_pmos ad=1.9p pd=10.38u as=1.9p ps=10.38u w=10u l=0.5u
X18 S29 G28 D28 w_n7898_n1124# sg13_hv_pmos ad=1.9p pd=10.38u as=1.9p ps=10.38u w=10u l=0.5u
X19 S67 G66 D66 w_n7898_n1124# sg13_hv_pmos ad=1.9p pd=10.38u as=1.9p ps=10.38u w=10u l=0.5u
X20 D72 G71 S71 w_n7898_n1124# sg13_hv_pmos ad=1.9p pd=10.38u as=1.9p ps=10.38u w=10u l=0.5u
X21 S85 G84 D84 w_n7898_n1124# sg13_hv_pmos ad=1.9p pd=10.38u as=1.9p ps=10.38u w=10u l=0.5u
X22 D22 G21 S21 w_n7898_n1124# sg13_hv_pmos ad=1.9p pd=10.38u as=1.9p ps=10.38u w=10u l=0.5u
X23 S35 G34 D34 w_n7898_n1124# sg13_hv_pmos ad=1.9p pd=10.38u as=1.9p ps=10.38u w=10u l=0.5u
X24 D44 G43 S43 w_n7898_n1124# sg13_hv_pmos ad=1.9p pd=10.38u as=1.9p ps=10.38u w=10u l=0.5u
X25 D52 G51 S51 w_n7898_n1124# sg13_hv_pmos ad=1.9p pd=10.38u as=1.9p ps=10.38u w=10u l=0.5u
X26 D54 G53 S53 w_n7898_n1124# sg13_hv_pmos ad=1.9p pd=10.38u as=1.9p ps=10.38u w=10u l=0.5u
X27 S79 G78 D78 w_n7898_n1124# sg13_hv_pmos ad=1.9p pd=10.38u as=1.9p ps=10.38u w=10u l=0.5u
X28 S1 G0 D0 w_n7898_n1124# sg13_hv_pmos ad=1.9p pd=10.38u as=3.4p ps=20.68u w=10u l=0.5u
X29 S3 G2 D2 w_n7898_n1124# sg13_hv_pmos ad=1.9p pd=10.38u as=1.9p ps=10.38u w=10u l=0.5u
X30 D10 G9 S9 w_n7898_n1124# sg13_hv_pmos ad=1.9p pd=10.38u as=1.9p ps=10.38u w=10u l=0.5u
X31 D28 G27 S27 w_n7898_n1124# sg13_hv_pmos ad=1.9p pd=10.38u as=1.9p ps=10.38u w=10u l=0.5u
X32 S61 G60 D60 w_n7898_n1124# sg13_hv_pmos ad=1.9p pd=10.38u as=1.9p ps=10.38u w=10u l=0.5u
X33 D86 G85 S85 w_n7898_n1124# sg13_hv_pmos ad=1.9p pd=10.38u as=1.9p ps=10.38u w=10u l=0.5u
X34 a_7706_n1000# G87 S87 w_n7898_n1124# sg13_hv_pmos ad=3.4p pd=20.68u as=1.9p ps=10.38u w=10u l=0.5u
X35 D16 G15 S15 w_n7898_n1124# sg13_hv_pmos ad=1.9p pd=10.38u as=1.9p ps=10.38u w=10u l=0.5u
X36 S55 G54 D54 w_n7898_n1124# sg13_hv_pmos ad=1.9p pd=10.38u as=1.9p ps=10.38u w=10u l=0.5u
X37 S75 G74 D74 w_n7898_n1124# sg13_hv_pmos ad=1.9p pd=10.38u as=1.9p ps=10.38u w=10u l=0.5u
X38 S7 G6 D6 w_n7898_n1124# sg13_hv_pmos ad=1.9p pd=10.38u as=1.9p ps=10.38u w=10u l=0.5u
X39 S9 G8 D8 w_n7898_n1124# sg13_hv_pmos ad=1.9p pd=10.38u as=1.9p ps=10.38u w=10u l=0.5u
X40 D14 G13 S13 w_n7898_n1124# sg13_hv_pmos ad=1.9p pd=10.38u as=1.9p ps=10.38u w=10u l=0.5u
X41 D34 G33 S33 w_n7898_n1124# sg13_hv_pmos ad=1.9p pd=10.38u as=1.9p ps=10.38u w=10u l=0.5u
X42 S43 G42 D42 w_n7898_n1124# sg13_hv_pmos ad=1.9p pd=10.38u as=1.9p ps=10.38u w=10u l=0.5u
X43 D80 G79 S79 w_n7898_n1124# sg13_hv_pmos ad=1.9p pd=10.38u as=1.9p ps=10.38u w=10u l=0.5u
X44 S87 G86 D86 w_n7898_n1124# sg13_hv_pmos ad=1.9p pd=10.38u as=1.9p ps=10.38u w=10u l=0.5u
X45 D46 G45 S45 w_n7898_n1124# sg13_hv_pmos ad=1.9p pd=10.38u as=1.9p ps=10.38u w=10u l=0.5u
X46 S27 G26 D26 w_n7898_n1124# sg13_hv_pmos ad=1.9p pd=10.38u as=1.9p ps=10.38u w=10u l=0.5u
X47 D74 G73 S73 w_n7898_n1124# sg13_hv_pmos ad=1.9p pd=10.38u as=1.9p ps=10.38u w=10u l=0.5u
X48 D6 G5 S5 w_n7898_n1124# sg13_hv_pmos ad=1.9p pd=10.38u as=1.9p ps=10.38u w=10u l=0.5u
X49 D8 G7 S7 w_n7898_n1124# sg13_hv_pmos ad=1.9p pd=10.38u as=1.9p ps=10.38u w=10u l=0.5u
X50 S15 G14 D14 w_n7898_n1124# sg13_hv_pmos ad=1.9p pd=10.38u as=1.9p ps=10.38u w=10u l=0.5u
X51 D42 G41 S41 w_n7898_n1124# sg13_hv_pmos ad=1.9p pd=10.38u as=1.9p ps=10.38u w=10u l=0.5u
X52 D56 G55 S55 w_n7898_n1124# sg13_hv_pmos ad=1.9p pd=10.38u as=1.9p ps=10.38u w=10u l=0.5u
X53 S81 G80 D80 w_n7898_n1124# sg13_hv_pmos ad=1.9p pd=10.38u as=1.9p ps=10.38u w=10u l=0.5u
X54 S83 G82 D82 w_n7898_n1124# sg13_hv_pmos ad=1.9p pd=10.38u as=1.9p ps=10.38u w=10u l=0.5u
X55 S21 G20 D20 w_n7898_n1124# sg13_hv_pmos ad=1.9p pd=10.38u as=1.9p ps=10.38u w=10u l=0.5u
X56 D26 G25 S25 w_n7898_n1124# sg13_hv_pmos ad=1.9p pd=10.38u as=1.9p ps=10.38u w=10u l=0.5u
X57 S63 G62 D62 w_n7898_n1124# sg13_hv_pmos ad=1.9p pd=10.38u as=1.9p ps=10.38u w=10u l=0.5u
X58 D68 G67 S67 w_n7898_n1124# sg13_hv_pmos ad=1.9p pd=10.38u as=1.9p ps=10.38u w=10u l=0.5u
X59 D70 G69 S69 w_n7898_n1124# sg13_hv_pmos ad=1.9p pd=10.38u as=1.9p ps=10.38u w=10u l=0.5u
X60 D12 G11 S11 w_n7898_n1124# sg13_hv_pmos ad=1.9p pd=10.38u as=1.9p ps=10.38u w=10u l=0.5u
X61 S19 G18 D18 w_n7898_n1124# sg13_hv_pmos ad=1.9p pd=10.38u as=1.9p ps=10.38u w=10u l=0.5u
X62 S41 G40 D40 w_n7898_n1124# sg13_hv_pmos ad=1.9p pd=10.38u as=1.9p ps=10.38u w=10u l=0.5u
X63 D82 G81 S81 w_n7898_n1124# sg13_hv_pmos ad=1.9p pd=10.38u as=1.9p ps=10.38u w=10u l=0.5u
X64 D84 G83 S83 w_n7898_n1124# sg13_hv_pmos ad=1.9p pd=10.38u as=1.9p ps=10.38u w=10u l=0.5u
X65 S39 G38 D38 w_n7898_n1124# sg13_hv_pmos ad=1.9p pd=10.38u as=1.9p ps=10.38u w=10u l=0.5u
X66 D32 G31 S31 w_n7898_n1124# sg13_hv_pmos ad=1.9p pd=10.38u as=1.9p ps=10.38u w=10u l=0.5u
X67 D48 G47 S47 w_n7898_n1124# sg13_hv_pmos ad=1.9p pd=10.38u as=1.9p ps=10.38u w=10u l=0.5u
X68 D50 G49 S49 w_n7898_n1124# sg13_hv_pmos ad=1.9p pd=10.38u as=1.9p ps=10.38u w=10u l=0.5u
X69 D62 G61 S61 w_n7898_n1124# sg13_hv_pmos ad=1.9p pd=10.38u as=1.9p ps=10.38u w=10u l=0.5u
X70 S69 G68 D68 w_n7898_n1124# sg13_hv_pmos ad=1.9p pd=10.38u as=1.9p ps=10.38u w=10u l=0.5u
X71 S11 G10 D10 w_n7898_n1124# sg13_hv_pmos ad=1.9p pd=10.38u as=1.9p ps=10.38u w=10u l=0.5u
X72 S13 G12 D12 w_n7898_n1124# sg13_hv_pmos ad=1.9p pd=10.38u as=1.9p ps=10.38u w=10u l=0.5u
X73 D18 G17 S17 w_n7898_n1124# sg13_hv_pmos ad=1.9p pd=10.38u as=1.9p ps=10.38u w=10u l=0.5u
X74 D20 G19 S19 w_n7898_n1124# sg13_hv_pmos ad=1.9p pd=10.38u as=1.9p ps=10.38u w=10u l=0.5u
X75 D40 G39 S39 w_n7898_n1124# sg13_hv_pmos ad=1.9p pd=10.38u as=1.9p ps=10.38u w=10u l=0.5u
X76 S71 G70 D70 w_n7898_n1124# sg13_hv_pmos ad=1.9p pd=10.38u as=1.9p ps=10.38u w=10u l=0.5u
X77 D76 G75 S75 w_n7898_n1124# sg13_hv_pmos ad=1.9p pd=10.38u as=1.9p ps=10.38u w=10u l=0.5u
X78 D78 G77 S77 w_n7898_n1124# sg13_hv_pmos ad=1.9p pd=10.38u as=1.9p ps=10.38u w=10u l=0.5u
X79 S31 G30 D30 w_n7898_n1124# sg13_hv_pmos ad=1.9p pd=10.38u as=1.9p ps=10.38u w=10u l=0.5u
X80 S33 G32 D32 w_n7898_n1124# sg13_hv_pmos ad=1.9p pd=10.38u as=1.9p ps=10.38u w=10u l=0.5u
X81 S47 G46 D46 w_n7898_n1124# sg13_hv_pmos ad=1.9p pd=10.38u as=1.9p ps=10.38u w=10u l=0.5u
X82 S49 G48 D48 w_n7898_n1124# sg13_hv_pmos ad=1.9p pd=10.38u as=1.9p ps=10.38u w=10u l=0.5u
X83 D58 G57 S57 w_n7898_n1124# sg13_hv_pmos ad=1.9p pd=10.38u as=1.9p ps=10.38u w=10u l=0.5u
X84 S65 G64 D64 w_n7898_n1124# sg13_hv_pmos ad=1.9p pd=10.38u as=1.9p ps=10.38u w=10u l=0.5u
X85 S17 G16 D16 w_n7898_n1124# sg13_hv_pmos ad=1.9p pd=10.38u as=1.9p ps=10.38u w=10u l=0.5u
X86 D24 G23 S23 w_n7898_n1124# sg13_hv_pmos ad=1.9p pd=10.38u as=1.9p ps=10.38u w=10u l=0.5u
X87 S77 G76 D76 w_n7898_n1124# sg13_hv_pmos ad=1.9p pd=10.38u as=1.9p ps=10.38u w=10u l=0.5u
.ends

.subckt gate_drive in_p in_n out vss vdd
Xsg13_hv_nmos_XAVYYR_0 vss in_p sg13_hv_pmos_YZSTZS_0/S1 in_p vss in_n sg13_hv_pmos_YZSTZS_0/S3
+ in_n vss vss sg13_hv_nmos_XAVYYR
Xsg13_hv_nmos_3JX36Y_0 vss sg13_hv_pmos_YZSTZS_0/S3 sg13_hv_pmos_RQMCRC_0/S1 sg13_hv_pmos_YZSTZS_0/S3
+ vss sg13_hv_pmos_RQMCRC_0/S1 sg13_hv_pmos_RQMCRC_0/S7 sg13_hv_pmos_RQMCRC_0/S1 vss
+ sg13_hv_pmos_RQMCRC_0/S1 sg13_hv_pmos_RQMCRC_0/S7 sg13_hv_pmos_RQMCRC_0/S1 vss sg13_hv_pmos_RQMCRC_0/S1
+ sg13_hv_pmos_RQMCRC_0/S7 sg13_hv_pmos_RQMCRC_0/S1 vss sg13_hv_pmos_RQMCRC_0/S7 sg13_hv_pmos_RQMCRC_0/S9
+ sg13_hv_pmos_RQMCRC_0/S7 vss sg13_hv_pmos_RQMCRC_0/S7 sg13_hv_pmos_RQMCRC_0/S9 sg13_hv_pmos_RQMCRC_0/S7
+ vss sg13_hv_pmos_RQMCRC_0/S7 sg13_hv_pmos_RQMCRC_0/S9 sg13_hv_pmos_RQMCRC_0/S7 vss
+ sg13_hv_pmos_RQMCRC_0/S7 sg13_hv_pmos_RQMCRC_0/S9 sg13_hv_pmos_RQMCRC_0/S7 vss sg13_hv_pmos_RQMCRC_0/S7
+ sg13_hv_pmos_RQMCRC_0/S9 sg13_hv_pmos_RQMCRC_0/S7 vss sg13_hv_pmos_RQMCRC_0/S7 sg13_hv_pmos_RQMCRC_0/S9
+ sg13_hv_pmos_RQMCRC_0/S7 vss sg13_hv_pmos_RQMCRC_0/S7 sg13_hv_pmos_RQMCRC_0/S9 sg13_hv_pmos_RQMCRC_0/S7
+ vss sg13_hv_pmos_RQMCRC_0/S7 sg13_hv_pmos_RQMCRC_0/S9 sg13_hv_pmos_RQMCRC_0/S7 vss
+ sg13_hv_pmos_RQMCRC_0/S7 sg13_hv_pmos_RQMCRC_0/S9 sg13_hv_pmos_RQMCRC_0/S7 vss sg13_hv_pmos_RQMCRC_0/S7
+ sg13_hv_pmos_RQMCRC_0/S9 sg13_hv_pmos_RQMCRC_0/S7 vss sg13_hv_pmos_RQMCRC_0/S9 out
+ sg13_hv_pmos_RQMCRC_0/S9 vss sg13_hv_pmos_RQMCRC_0/S9 out sg13_hv_pmos_RQMCRC_0/S9
+ vss sg13_hv_pmos_RQMCRC_0/S9 out sg13_hv_pmos_RQMCRC_0/S9 vss sg13_hv_pmos_RQMCRC_0/S9
+ out sg13_hv_pmos_RQMCRC_0/S9 vss sg13_hv_pmos_RQMCRC_0/S9 out sg13_hv_pmos_RQMCRC_0/S9
+ vss sg13_hv_pmos_RQMCRC_0/S9 out sg13_hv_pmos_RQMCRC_0/S9 vss sg13_hv_pmos_RQMCRC_0/S9
+ out sg13_hv_pmos_RQMCRC_0/S9 vss sg13_hv_pmos_RQMCRC_0/S9 out sg13_hv_pmos_RQMCRC_0/S9
+ vss sg13_hv_pmos_RQMCRC_0/S9 out sg13_hv_pmos_RQMCRC_0/S9 vss sg13_hv_pmos_RQMCRC_0/S9
+ out sg13_hv_pmos_RQMCRC_0/S9 vss sg13_hv_pmos_RQMCRC_0/S9 out sg13_hv_pmos_RQMCRC_0/S9
+ vss sg13_hv_pmos_RQMCRC_0/S9 out sg13_hv_pmos_RQMCRC_0/S9 vss sg13_hv_pmos_RQMCRC_0/S9
+ out sg13_hv_pmos_RQMCRC_0/S9 vss sg13_hv_pmos_RQMCRC_0/S9 out sg13_hv_pmos_RQMCRC_0/S9
+ vss sg13_hv_pmos_RQMCRC_0/S9 out sg13_hv_pmos_RQMCRC_0/S9 vss sg13_hv_pmos_RQMCRC_0/S9
+ out sg13_hv_pmos_RQMCRC_0/S9 vss sg13_hv_pmos_RQMCRC_0/S9 out sg13_hv_pmos_RQMCRC_0/S9
+ vss sg13_hv_pmos_RQMCRC_0/S9 out sg13_hv_pmos_RQMCRC_0/S9 vss sg13_hv_pmos_RQMCRC_0/S9
+ out sg13_hv_pmos_RQMCRC_0/S9 vss sg13_hv_pmos_RQMCRC_0/S9 out sg13_hv_pmos_RQMCRC_0/S9
+ vss sg13_hv_pmos_RQMCRC_0/S9 out sg13_hv_pmos_RQMCRC_0/S9 vss sg13_hv_pmos_RQMCRC_0/S9
+ out sg13_hv_pmos_RQMCRC_0/S9 vss sg13_hv_pmos_RQMCRC_0/S9 out sg13_hv_pmos_RQMCRC_0/S9
+ vss sg13_hv_pmos_RQMCRC_0/S9 out sg13_hv_pmos_RQMCRC_0/S9 vss sg13_hv_pmos_RQMCRC_0/S9
+ out sg13_hv_pmos_RQMCRC_0/S9 vss sg13_hv_pmos_RQMCRC_0/S9 out sg13_hv_pmos_RQMCRC_0/S9
+ vss sg13_hv_pmos_RQMCRC_0/S9 out sg13_hv_pmos_RQMCRC_0/S9 vss sg13_hv_pmos_RQMCRC_0/S9
+ out sg13_hv_pmos_RQMCRC_0/S9 vss sg13_hv_pmos_RQMCRC_0/S9 out sg13_hv_pmos_RQMCRC_0/S9
+ vss sg13_hv_pmos_RQMCRC_0/S9 out sg13_hv_pmos_RQMCRC_0/S9 vss vss sg13_hv_nmos_3JX36Y
Xsg13_hv_pmos_YZSTZS_0 vdd sg13_hv_pmos_YZSTZS_0/S3 sg13_hv_pmos_YZSTZS_0/S1 sg13_hv_pmos_YZSTZS_0/S3
+ vdd sg13_hv_pmos_YZSTZS_0/S1 sg13_hv_pmos_YZSTZS_0/S3 sg13_hv_pmos_YZSTZS_0/S1 vdd
+ vdd sg13_hv_pmos_YZSTZS
Xsg13_hv_pmos_RQMCRC_0 vdd sg13_hv_pmos_YZSTZS_0/S3 sg13_hv_pmos_RQMCRC_0/S1 sg13_hv_pmos_YZSTZS_0/S3
+ vdd sg13_hv_pmos_RQMCRC_0/S1 sg13_hv_pmos_RQMCRC_0/S7 sg13_hv_pmos_RQMCRC_0/S1 vdd
+ sg13_hv_pmos_RQMCRC_0/S1 sg13_hv_pmos_RQMCRC_0/S7 sg13_hv_pmos_RQMCRC_0/S1 vdd sg13_hv_pmos_RQMCRC_0/S1
+ sg13_hv_pmos_RQMCRC_0/S7 sg13_hv_pmos_RQMCRC_0/S1 vdd sg13_hv_pmos_RQMCRC_0/S7 sg13_hv_pmos_RQMCRC_0/S9
+ sg13_hv_pmos_RQMCRC_0/S7 vdd sg13_hv_pmos_RQMCRC_0/S7 sg13_hv_pmos_RQMCRC_0/S9 sg13_hv_pmos_RQMCRC_0/S7
+ vdd sg13_hv_pmos_RQMCRC_0/S7 sg13_hv_pmos_RQMCRC_0/S9 sg13_hv_pmos_RQMCRC_0/S7 vdd
+ sg13_hv_pmos_RQMCRC_0/S7 sg13_hv_pmos_RQMCRC_0/S9 sg13_hv_pmos_RQMCRC_0/S7 vdd sg13_hv_pmos_RQMCRC_0/S7
+ sg13_hv_pmos_RQMCRC_0/S9 sg13_hv_pmos_RQMCRC_0/S7 vdd sg13_hv_pmos_RQMCRC_0/S7 sg13_hv_pmos_RQMCRC_0/S9
+ sg13_hv_pmos_RQMCRC_0/S7 vdd sg13_hv_pmos_RQMCRC_0/S7 sg13_hv_pmos_RQMCRC_0/S9 sg13_hv_pmos_RQMCRC_0/S7
+ vdd sg13_hv_pmos_RQMCRC_0/S7 sg13_hv_pmos_RQMCRC_0/S9 sg13_hv_pmos_RQMCRC_0/S7 vdd
+ sg13_hv_pmos_RQMCRC_0/S7 sg13_hv_pmos_RQMCRC_0/S9 sg13_hv_pmos_RQMCRC_0/S7 vdd sg13_hv_pmos_RQMCRC_0/S7
+ sg13_hv_pmos_RQMCRC_0/S9 sg13_hv_pmos_RQMCRC_0/S7 vdd sg13_hv_pmos_RQMCRC_0/S9 out
+ sg13_hv_pmos_RQMCRC_0/S9 vdd sg13_hv_pmos_RQMCRC_0/S9 out sg13_hv_pmos_RQMCRC_0/S9
+ vdd sg13_hv_pmos_RQMCRC_0/S9 out sg13_hv_pmos_RQMCRC_0/S9 vdd sg13_hv_pmos_RQMCRC_0/S9
+ out sg13_hv_pmos_RQMCRC_0/S9 vdd sg13_hv_pmos_RQMCRC_0/S9 out sg13_hv_pmos_RQMCRC_0/S9
+ vdd sg13_hv_pmos_RQMCRC_0/S9 out sg13_hv_pmos_RQMCRC_0/S9 vdd sg13_hv_pmos_RQMCRC_0/S9
+ out sg13_hv_pmos_RQMCRC_0/S9 vdd sg13_hv_pmos_RQMCRC_0/S9 out sg13_hv_pmos_RQMCRC_0/S9
+ vdd sg13_hv_pmos_RQMCRC_0/S9 out sg13_hv_pmos_RQMCRC_0/S9 vdd sg13_hv_pmos_RQMCRC_0/S9
+ out sg13_hv_pmos_RQMCRC_0/S9 vdd sg13_hv_pmos_RQMCRC_0/S9 out sg13_hv_pmos_RQMCRC_0/S9
+ vdd sg13_hv_pmos_RQMCRC_0/S9 out sg13_hv_pmos_RQMCRC_0/S9 vdd sg13_hv_pmos_RQMCRC_0/S9
+ out sg13_hv_pmos_RQMCRC_0/S9 vdd sg13_hv_pmos_RQMCRC_0/S9 out sg13_hv_pmos_RQMCRC_0/S9
+ vdd sg13_hv_pmos_RQMCRC_0/S9 out sg13_hv_pmos_RQMCRC_0/S9 vdd sg13_hv_pmos_RQMCRC_0/S9
+ out sg13_hv_pmos_RQMCRC_0/S9 vdd sg13_hv_pmos_RQMCRC_0/S9 out sg13_hv_pmos_RQMCRC_0/S9
+ vdd sg13_hv_pmos_RQMCRC_0/S9 out sg13_hv_pmos_RQMCRC_0/S9 vdd sg13_hv_pmos_RQMCRC_0/S9
+ out sg13_hv_pmos_RQMCRC_0/S9 vdd sg13_hv_pmos_RQMCRC_0/S9 out sg13_hv_pmos_RQMCRC_0/S9
+ vdd sg13_hv_pmos_RQMCRC_0/S9 out sg13_hv_pmos_RQMCRC_0/S9 vdd sg13_hv_pmos_RQMCRC_0/S9
+ out sg13_hv_pmos_RQMCRC_0/S9 vdd sg13_hv_pmos_RQMCRC_0/S9 out sg13_hv_pmos_RQMCRC_0/S9
+ vdd sg13_hv_pmos_RQMCRC_0/S9 out sg13_hv_pmos_RQMCRC_0/S9 vdd sg13_hv_pmos_RQMCRC_0/S9
+ out sg13_hv_pmos_RQMCRC_0/S9 vdd sg13_hv_pmos_RQMCRC_0/S9 out sg13_hv_pmos_RQMCRC_0/S9
+ vdd sg13_hv_pmos_RQMCRC_0/S9 out sg13_hv_pmos_RQMCRC_0/S9 vdd sg13_hv_pmos_RQMCRC_0/S9
+ out sg13_hv_pmos_RQMCRC_0/S9 vdd sg13_hv_pmos_RQMCRC_0/S9 out sg13_hv_pmos_RQMCRC_0/S9
+ vdd sg13_hv_pmos_RQMCRC_0/S9 out sg13_hv_pmos_RQMCRC_0/S9 vdd vdd sg13_hv_pmos_RQMCRC
.ends

.subckt pmos_waffle_20 B A SUB GATE
X0 A GATE B A sg13_hv_pmos ad=5.5584p pd=15.52u as=3.052p ps=10.12u w=4.36u l=0.4u
X1 A GATE B A sg13_hv_pmos ad=5.5584p pd=15.52u as=3.052p ps=10.12u w=4.36u l=0.4u
X2 B GATE A A sg13_hv_pmos ad=5.4312p pd=15.6u as=5.5584p ps=15.52u w=4.36u l=0.4u
X3 A GATE B A sg13_hv_pmos ad=5.5584p pd=15.52u as=5.4312p ps=15.6u w=4.36u l=0.4u
X4 A GATE B A sg13_hv_pmos ad=5.5584p pd=15.52u as=5.4312p ps=15.6u w=4.36u l=0.4u
X5 B GATE A A sg13_hv_pmos ad=5.4312p pd=15.6u as=5.5584p ps=15.52u w=4.36u l=0.4u
X6 A GATE B A sg13_hv_pmos ad=5.5584p pd=15.52u as=5.4312p ps=15.6u w=4.36u l=0.4u
X7 A GATE B A sg13_hv_pmos ad=5.5584p pd=15.52u as=5.4312p ps=15.6u w=4.36u l=0.4u
X8 B GATE A A sg13_hv_pmos ad=5.4312p pd=15.6u as=5.5584p ps=15.52u w=4.36u l=0.4u
X9 B GATE A A sg13_hv_pmos ad=5.4312p pd=15.6u as=5.5584p ps=15.52u w=4.36u l=0.4u
X10 A GATE B A sg13_hv_pmos ad=5.5584p pd=15.52u as=3.052p ps=10.12u w=4.36u l=0.4u
X11 A GATE B A sg13_hv_pmos ad=5.5584p pd=15.52u as=3.052p ps=10.12u w=4.36u l=0.4u
X12 B GATE A A sg13_hv_pmos ad=5.4312p pd=15.6u as=5.5584p ps=15.52u w=4.36u l=0.4u
X13 A GATE B A sg13_hv_pmos ad=3.1392p pd=10.16u as=5.4312p ps=15.6u w=4.36u l=0.4u
X14 A GATE B A sg13_hv_pmos ad=5.5584p pd=15.52u as=5.4312p ps=15.6u w=4.36u l=0.4u
X15 A GATE B A sg13_hv_pmos ad=5.5584p pd=15.52u as=5.4312p ps=15.6u w=4.36u l=0.4u
X16 B GATE A A sg13_hv_pmos ad=5.4312p pd=15.6u as=5.5584p ps=15.52u w=4.36u l=0.4u
X17 B GATE A A sg13_hv_pmos ad=5.4312p pd=15.6u as=3.1392p ps=10.16u w=4.36u l=0.4u
X18 B GATE A A sg13_hv_pmos ad=5.4312p pd=15.6u as=5.5584p ps=15.52u w=4.36u l=0.4u
X19 A GATE B A sg13_hv_pmos ad=5.5584p pd=15.52u as=5.4312p ps=15.6u w=4.36u l=0.4u
X20 A GATE B A sg13_hv_pmos ad=5.5584p pd=15.52u as=5.4312p ps=15.6u w=4.36u l=0.4u
X21 B GATE A A sg13_hv_pmos ad=5.4312p pd=15.6u as=5.5584p ps=15.52u w=4.36u l=0.4u
X22 B GATE A A sg13_hv_pmos ad=5.4312p pd=15.6u as=5.5584p ps=15.52u w=4.36u l=0.4u
X23 A GATE B A sg13_hv_pmos ad=5.5584p pd=15.52u as=3.052p ps=10.12u w=4.36u l=0.4u
X24 A GATE B A sg13_hv_pmos ad=5.5584p pd=15.52u as=5.4312p ps=15.6u w=4.36u l=0.4u
X25 A GATE B A sg13_hv_pmos ad=5.5584p pd=15.52u as=5.4312p ps=15.6u w=4.36u l=0.4u
X26 A GATE B A sg13_hv_pmos ad=5.5584p pd=15.52u as=5.4312p ps=15.6u w=4.36u l=0.4u
X27 B GATE A A sg13_hv_pmos ad=3.052p pd=10.12u as=5.5584p ps=15.52u w=4.36u l=0.4u
X28 B GATE A A sg13_hv_pmos ad=5.4312p pd=15.6u as=5.5584p ps=15.52u w=4.36u l=0.4u
X29 B GATE A A sg13_hv_pmos ad=5.4312p pd=15.6u as=5.5584p ps=15.52u w=4.36u l=0.4u
X30 A GATE B A sg13_hv_pmos ad=5.5584p pd=15.52u as=5.4312p ps=15.6u w=4.36u l=0.4u
X31 A GATE B A sg13_hv_pmos ad=5.5584p pd=15.52u as=5.4312p ps=15.6u w=4.36u l=0.4u
X32 B GATE A A sg13_hv_pmos ad=5.4312p pd=15.6u as=5.5584p ps=15.52u w=4.36u l=0.4u
X33 B GATE A A sg13_hv_pmos ad=5.4312p pd=15.6u as=5.5584p ps=15.52u w=4.36u l=0.4u
X34 B GATE A A sg13_hv_pmos ad=5.4312p pd=15.6u as=5.5584p ps=15.52u w=4.36u l=0.4u
X35 A GATE B A sg13_hv_pmos ad=5.5584p pd=15.52u as=5.4312p ps=15.6u w=4.36u l=0.4u
X36 A GATE B A sg13_hv_pmos ad=5.5584p pd=15.52u as=5.4312p ps=15.6u w=4.36u l=0.4u
X37 B GATE A A sg13_hv_pmos ad=5.4312p pd=15.6u as=5.5584p ps=15.52u w=4.36u l=0.4u
X38 A GATE B A sg13_hv_pmos ad=5.5584p pd=15.52u as=5.4312p ps=15.6u w=4.36u l=0.4u
X39 A GATE B A sg13_hv_pmos ad=3.1392p pd=10.16u as=5.4312p ps=15.6u w=4.36u l=0.4u
X40 B GATE A A sg13_hv_pmos ad=5.4312p pd=15.6u as=5.5584p ps=15.52u w=4.36u l=0.4u
X41 B GATE A A sg13_hv_pmos ad=5.4312p pd=15.6u as=5.5584p ps=15.52u w=4.36u l=0.4u
X42 A GATE B A sg13_hv_pmos ad=3.1392p pd=10.16u as=5.4312p ps=15.6u w=4.36u l=0.4u
X43 B GATE A A sg13_hv_pmos ad=3.052p pd=10.12u as=5.5584p ps=15.52u w=4.36u l=0.4u
X44 A GATE B A sg13_hv_pmos ad=5.5584p pd=15.52u as=5.4312p ps=15.6u w=4.36u l=0.4u
X45 A GATE B A sg13_hv_pmos ad=5.5584p pd=15.52u as=5.4312p ps=15.6u w=4.36u l=0.4u
X46 B GATE A A sg13_hv_pmos ad=5.4312p pd=15.6u as=5.5584p ps=15.52u w=4.36u l=0.4u
X47 A GATE B A sg13_hv_pmos ad=5.5584p pd=15.52u as=5.4312p ps=15.6u w=4.36u l=0.4u
X48 B GATE A A sg13_hv_pmos ad=5.4312p pd=15.6u as=5.5584p ps=15.52u w=4.36u l=0.4u
X49 A GATE B A sg13_hv_pmos ad=5.5584p pd=15.52u as=5.4312p ps=15.6u w=4.36u l=0.4u
X50 B GATE A A sg13_hv_pmos ad=3.052p pd=10.12u as=5.5584p ps=15.52u w=4.36u l=0.4u
X51 B GATE A A sg13_hv_pmos ad=5.4312p pd=15.6u as=5.5584p ps=15.52u w=4.36u l=0.4u
X52 A GATE B A sg13_hv_pmos ad=5.5584p pd=15.52u as=5.4312p ps=15.6u w=4.36u l=0.4u
X53 A GATE B A sg13_hv_pmos ad=5.5584p pd=15.52u as=5.4312p ps=15.6u w=4.36u l=0.4u
X54 A GATE B A sg13_hv_pmos ad=3.1392p pd=10.16u as=5.4312p ps=15.6u w=4.36u l=0.4u
X55 B GATE A A sg13_hv_pmos ad=5.4312p pd=15.6u as=5.5584p ps=15.52u w=4.36u l=0.4u
X56 A GATE B A sg13_hv_pmos ad=5.5584p pd=15.52u as=5.4312p ps=15.6u w=4.36u l=0.4u
X57 A GATE B A sg13_hv_pmos ad=5.5584p pd=15.52u as=5.4312p ps=15.6u w=4.36u l=0.4u
X58 B GATE A A sg13_hv_pmos ad=5.4312p pd=15.6u as=5.5584p ps=15.52u w=4.36u l=0.4u
X59 B GATE A A sg13_hv_pmos ad=5.4312p pd=15.6u as=5.5584p ps=15.52u w=4.36u l=0.4u
X60 A GATE B A sg13_hv_pmos ad=5.5584p pd=15.52u as=5.4312p ps=15.6u w=4.36u l=0.4u
X61 A GATE B A sg13_hv_pmos ad=5.5584p pd=15.52u as=3.052p ps=10.12u w=4.36u l=0.4u
X62 B GATE A A sg13_hv_pmos ad=3.052p pd=10.12u as=5.5584p ps=15.52u w=4.36u l=0.4u
X63 A GATE B A sg13_hv_pmos ad=5.5584p pd=15.52u as=5.4312p ps=15.6u w=4.36u l=0.4u
X64 A GATE B A sg13_hv_pmos ad=3.1392p pd=10.16u as=5.4312p ps=15.6u w=4.36u l=0.4u
X65 B GATE A A sg13_hv_pmos ad=5.4312p pd=15.6u as=5.5584p ps=15.52u w=4.36u l=0.4u
X66 A GATE B A sg13_hv_pmos ad=5.5584p pd=15.52u as=5.4312p ps=15.6u w=4.36u l=0.4u
X67 B GATE A A sg13_hv_pmos ad=3.052p pd=10.12u as=5.5584p ps=15.52u w=4.36u l=0.4u
X68 A GATE B A sg13_hv_pmos ad=5.5584p pd=15.52u as=5.4312p ps=15.6u w=4.36u l=0.4u
X69 B GATE A A sg13_hv_pmos ad=5.4312p pd=15.6u as=5.5584p ps=15.52u w=4.36u l=0.4u
X70 A GATE B A sg13_hv_pmos ad=5.5584p pd=15.52u as=5.4312p ps=15.6u w=4.36u l=0.4u
X71 A GATE B A sg13_hv_pmos ad=5.5584p pd=15.52u as=5.4312p ps=15.6u w=4.36u l=0.4u
X72 B GATE A A sg13_hv_pmos ad=5.4312p pd=15.6u as=5.5584p ps=15.52u w=4.36u l=0.4u
X73 A GATE B A sg13_hv_pmos ad=5.5584p pd=15.52u as=5.4312p ps=15.6u w=4.36u l=0.4u
X74 B GATE A A sg13_hv_pmos ad=5.4312p pd=15.6u as=5.5584p ps=15.52u w=4.36u l=0.4u
X75 A GATE B A sg13_hv_pmos ad=5.5584p pd=15.52u as=5.4312p ps=15.6u w=4.36u l=0.4u
X76 B GATE A A sg13_hv_pmos ad=5.4312p pd=15.6u as=5.5584p ps=15.52u w=4.36u l=0.4u
X77 A GATE B A sg13_hv_pmos ad=5.5584p pd=15.52u as=5.4312p ps=15.6u w=4.36u l=0.4u
X78 B GATE A A sg13_hv_pmos ad=5.4312p pd=15.6u as=5.5584p ps=15.52u w=4.36u l=0.4u
X79 B GATE A A sg13_hv_pmos ad=3.052p pd=10.12u as=5.5584p ps=15.52u w=4.36u l=0.4u
X80 B GATE A A sg13_hv_pmos ad=5.4312p pd=15.6u as=5.5584p ps=15.52u w=4.36u l=0.4u
X81 A GATE B A sg13_hv_pmos ad=5.5584p pd=15.52u as=5.4312p ps=15.6u w=4.36u l=0.4u
X82 B GATE A A sg13_hv_pmos ad=5.4312p pd=15.6u as=5.5584p ps=15.52u w=4.36u l=0.4u
X83 A GATE B A sg13_hv_pmos ad=5.5584p pd=15.52u as=5.4312p ps=15.6u w=4.36u l=0.4u
X84 A GATE B A sg13_hv_pmos ad=3.1392p pd=10.16u as=5.4312p ps=15.6u w=4.36u l=0.4u
X85 B GATE A A sg13_hv_pmos ad=5.4312p pd=15.6u as=3.1392p ps=10.16u w=4.36u l=0.4u
X86 A GATE B A sg13_hv_pmos ad=5.5584p pd=15.52u as=5.4312p ps=15.6u w=4.36u l=0.4u
X87 B GATE A A sg13_hv_pmos ad=5.4312p pd=15.6u as=5.5584p ps=15.52u w=4.36u l=0.4u
X88 A GATE B A sg13_hv_pmos ad=5.5584p pd=15.52u as=5.4312p ps=15.6u w=4.36u l=0.4u
X89 B GATE A A sg13_hv_pmos ad=5.4312p pd=15.6u as=5.5584p ps=15.52u w=4.36u l=0.4u
X90 B GATE A A sg13_hv_pmos ad=5.4312p pd=15.6u as=5.5584p ps=15.52u w=4.36u l=0.4u
X91 A GATE B A sg13_hv_pmos ad=5.5584p pd=15.52u as=5.4312p ps=15.6u w=4.36u l=0.4u
X92 B GATE A A sg13_hv_pmos ad=5.4312p pd=15.6u as=5.5584p ps=15.52u w=4.36u l=0.4u
X93 A GATE B A sg13_hv_pmos ad=5.5584p pd=15.52u as=5.4312p ps=15.6u w=4.36u l=0.4u
X94 B GATE A A sg13_hv_pmos ad=5.4312p pd=15.6u as=5.5584p ps=15.52u w=4.36u l=0.4u
X95 A GATE B A sg13_hv_pmos ad=5.5584p pd=15.52u as=5.4312p ps=15.6u w=4.36u l=0.4u
X96 A GATE B A sg13_hv_pmos ad=3.1392p pd=10.16u as=5.4312p ps=15.6u w=4.36u l=0.4u
X97 A GATE B A sg13_hv_pmos ad=5.5584p pd=15.52u as=5.4312p ps=15.6u w=4.36u l=0.4u
X98 B GATE A A sg13_hv_pmos ad=5.4312p pd=15.6u as=5.5584p ps=15.52u w=4.36u l=0.4u
X99 B GATE A A sg13_hv_pmos ad=3.052p pd=10.12u as=5.5584p ps=15.52u w=4.36u l=0.4u
X100 A GATE B A sg13_hv_pmos ad=5.5584p pd=15.52u as=5.4312p ps=15.6u w=4.36u l=0.4u
X101 B GATE A A sg13_hv_pmos ad=5.4312p pd=15.6u as=5.5584p ps=15.52u w=4.36u l=0.4u
X102 A GATE B A sg13_hv_pmos ad=5.5584p pd=15.52u as=5.4312p ps=15.6u w=4.36u l=0.4u
X103 B GATE A A sg13_hv_pmos ad=5.4312p pd=15.6u as=5.5584p ps=15.52u w=4.36u l=0.4u
X104 A GATE B A sg13_hv_pmos ad=5.5584p pd=15.52u as=5.4312p ps=15.6u w=4.36u l=0.4u
X105 A GATE B A sg13_hv_pmos ad=5.5584p pd=15.52u as=5.4312p ps=15.6u w=4.36u l=0.4u
X106 A GATE B A sg13_hv_pmos ad=5.5584p pd=15.52u as=5.4312p ps=15.6u w=4.36u l=0.4u
X107 B GATE A A sg13_hv_pmos ad=5.4312p pd=15.6u as=5.5584p ps=15.52u w=4.36u l=0.4u
X108 A GATE B A sg13_hv_pmos ad=5.5584p pd=15.52u as=5.4312p ps=15.6u w=4.36u l=0.4u
X109 B GATE A A sg13_hv_pmos ad=5.4312p pd=15.6u as=5.5584p ps=15.52u w=4.36u l=0.4u
X110 B GATE A A sg13_hv_pmos ad=5.4312p pd=15.6u as=5.5584p ps=15.52u w=4.36u l=0.4u
X111 A GATE B A sg13_hv_pmos ad=5.5584p pd=15.52u as=3.052p ps=10.12u w=4.36u l=0.4u
X112 A GATE B A sg13_hv_pmos ad=3.1392p pd=10.16u as=5.4312p ps=15.6u w=4.36u l=0.4u
X113 B GATE A A sg13_hv_pmos ad=5.4312p pd=15.6u as=5.5584p ps=15.52u w=4.36u l=0.4u
X114 B GATE A A sg13_hv_pmos ad=3.052p pd=10.12u as=5.5584p ps=15.52u w=4.36u l=0.4u
X115 A GATE B A sg13_hv_pmos ad=5.5584p pd=15.52u as=5.4312p ps=15.6u w=4.36u l=0.4u
X116 B GATE A A sg13_hv_pmos ad=5.4312p pd=15.6u as=5.5584p ps=15.52u w=4.36u l=0.4u
X117 A GATE B A sg13_hv_pmos ad=5.5584p pd=15.52u as=5.4312p ps=15.6u w=4.36u l=0.4u
X118 A GATE B A sg13_hv_pmos ad=5.5584p pd=15.52u as=5.4312p ps=15.6u w=4.36u l=0.4u
X119 A GATE B A sg13_hv_pmos ad=3.1392p pd=10.16u as=5.4312p ps=15.6u w=4.36u l=0.4u
X120 A GATE B A sg13_hv_pmos ad=5.5584p pd=15.52u as=5.4312p ps=15.6u w=4.36u l=0.4u
X121 B GATE A A sg13_hv_pmos ad=5.4312p pd=15.6u as=5.5584p ps=15.52u w=4.36u l=0.4u
X122 B GATE A A sg13_hv_pmos ad=5.4312p pd=15.6u as=5.5584p ps=15.52u w=4.36u l=0.4u
X123 B GATE A A sg13_hv_pmos ad=5.4312p pd=15.6u as=5.5584p ps=15.52u w=4.36u l=0.4u
X124 B GATE A A sg13_hv_pmos ad=5.4312p pd=15.6u as=5.5584p ps=15.52u w=4.36u l=0.4u
X125 B GATE A A sg13_hv_pmos ad=5.4312p pd=15.6u as=5.5584p ps=15.52u w=4.36u l=0.4u
X126 A GATE B A sg13_hv_pmos ad=5.5584p pd=15.52u as=5.4312p ps=15.6u w=4.36u l=0.4u
X127 A GATE B A sg13_hv_pmos ad=5.5584p pd=15.52u as=5.4312p ps=15.6u w=4.36u l=0.4u
X128 A GATE B A sg13_hv_pmos ad=5.5584p pd=15.52u as=5.4312p ps=15.6u w=4.36u l=0.4u
X129 A GATE B A sg13_hv_pmos ad=5.5584p pd=15.52u as=5.4312p ps=15.6u w=4.36u l=0.4u
X130 A GATE B A sg13_hv_pmos ad=3.1392p pd=10.16u as=5.4312p ps=15.6u w=4.36u l=0.4u
X131 B GATE A A sg13_hv_pmos ad=5.4312p pd=15.6u as=5.5584p ps=15.52u w=4.36u l=0.4u
X132 A GATE B A sg13_hv_pmos ad=5.5584p pd=15.52u as=5.4312p ps=15.6u w=4.36u l=0.4u
X133 B GATE A A sg13_hv_pmos ad=5.4312p pd=15.6u as=5.5584p ps=15.52u w=4.36u l=0.4u
X134 B GATE A A sg13_hv_pmos ad=5.4312p pd=15.6u as=5.5584p ps=15.52u w=4.36u l=0.4u
X135 B GATE A A sg13_hv_pmos ad=5.4312p pd=15.6u as=5.5584p ps=15.52u w=4.36u l=0.4u
X136 B GATE A A sg13_hv_pmos ad=3.052p pd=10.12u as=5.5584p ps=15.52u w=4.36u l=0.4u
X137 A GATE B A sg13_hv_pmos ad=5.5584p pd=15.52u as=5.4312p ps=15.6u w=4.36u l=0.4u
X138 B GATE A A sg13_hv_pmos ad=5.4312p pd=15.6u as=5.5584p ps=15.52u w=4.36u l=0.4u
X139 A GATE B A sg13_hv_pmos ad=5.5584p pd=15.52u as=5.4312p ps=15.6u w=4.36u l=0.4u
X140 A GATE B A sg13_hv_pmos ad=5.5584p pd=15.52u as=5.4312p ps=15.6u w=4.36u l=0.4u
X141 B GATE A A sg13_hv_pmos ad=5.4312p pd=15.6u as=3.1392p ps=10.16u w=4.36u l=0.4u
X142 A GATE B A sg13_hv_pmos ad=5.5584p pd=15.52u as=5.4312p ps=15.6u w=4.36u l=0.4u
X143 A GATE B A sg13_hv_pmos ad=5.5584p pd=15.52u as=5.4312p ps=15.6u w=4.36u l=0.4u
X144 B GATE A A sg13_hv_pmos ad=5.4312p pd=15.6u as=5.5584p ps=15.52u w=4.36u l=0.4u
X145 B GATE A A sg13_hv_pmos ad=5.4312p pd=15.6u as=3.1392p ps=10.16u w=4.36u l=0.4u
X146 A GATE B A sg13_hv_pmos ad=5.5584p pd=15.52u as=5.4312p ps=15.6u w=4.36u l=0.4u
X147 B GATE A A sg13_hv_pmos ad=5.4312p pd=15.6u as=5.5584p ps=15.52u w=4.36u l=0.4u
X148 B GATE A A sg13_hv_pmos ad=5.4312p pd=15.6u as=5.5584p ps=15.52u w=4.36u l=0.4u
X149 B GATE A A sg13_hv_pmos ad=5.4312p pd=15.6u as=5.5584p ps=15.52u w=4.36u l=0.4u
X150 B GATE A A sg13_hv_pmos ad=5.4312p pd=15.6u as=5.5584p ps=15.52u w=4.36u l=0.4u
X151 A GATE B A sg13_hv_pmos ad=5.5584p pd=15.52u as=5.4312p ps=15.6u w=4.36u l=0.4u
X152 B GATE A A sg13_hv_pmos ad=3.052p pd=10.12u as=5.5584p ps=15.52u w=4.36u l=0.4u
X153 A GATE B A sg13_hv_pmos ad=5.5584p pd=15.52u as=5.4312p ps=15.6u w=4.36u l=0.4u
X154 A GATE B A sg13_hv_pmos ad=5.5584p pd=15.52u as=5.4312p ps=15.6u w=4.36u l=0.4u
X155 A GATE B A sg13_hv_pmos ad=5.5584p pd=15.52u as=5.4312p ps=15.6u w=4.36u l=0.4u
X156 B GATE A A sg13_hv_pmos ad=5.4312p pd=15.6u as=5.5584p ps=15.52u w=4.36u l=0.4u
X157 A GATE B A sg13_hv_pmos ad=3.1392p pd=10.16u as=5.4312p ps=15.6u w=4.36u l=0.4u
X158 A GATE B A sg13_hv_pmos ad=5.5584p pd=15.52u as=5.4312p ps=15.6u w=4.36u l=0.4u
X159 B GATE A A sg13_hv_pmos ad=5.4312p pd=15.6u as=5.5584p ps=15.52u w=4.36u l=0.4u
X160 B GATE A A sg13_hv_pmos ad=5.4312p pd=15.6u as=5.5584p ps=15.52u w=4.36u l=0.4u
X161 B GATE A A sg13_hv_pmos ad=5.4312p pd=15.6u as=5.5584p ps=15.52u w=4.36u l=0.4u
X162 B GATE A A sg13_hv_pmos ad=5.4312p pd=15.6u as=5.5584p ps=15.52u w=4.36u l=0.4u
X163 B GATE A A sg13_hv_pmos ad=5.4312p pd=15.6u as=5.5584p ps=15.52u w=4.36u l=0.4u
X164 A GATE B A sg13_hv_pmos ad=5.5584p pd=15.52u as=5.4312p ps=15.6u w=4.36u l=0.4u
X165 A GATE B A sg13_hv_pmos ad=5.5584p pd=15.52u as=5.4312p ps=15.6u w=4.36u l=0.4u
X166 A GATE B A sg13_hv_pmos ad=5.5584p pd=15.52u as=5.4312p ps=15.6u w=4.36u l=0.4u
X167 A GATE B A sg13_hv_pmos ad=5.5584p pd=15.52u as=5.4312p ps=15.6u w=4.36u l=0.4u
X168 B GATE A A sg13_hv_pmos ad=5.4312p pd=15.6u as=3.1392p ps=10.16u w=4.36u l=0.4u
X169 B GATE A A sg13_hv_pmos ad=5.4312p pd=15.6u as=3.1392p ps=10.16u w=4.36u l=0.4u
X170 A GATE B A sg13_hv_pmos ad=5.5584p pd=15.52u as=5.4312p ps=15.6u w=4.36u l=0.4u
X171 B GATE A A sg13_hv_pmos ad=5.4312p pd=15.6u as=5.5584p ps=15.52u w=4.36u l=0.4u
X172 B GATE A A sg13_hv_pmos ad=5.4312p pd=15.6u as=5.5584p ps=15.52u w=4.36u l=0.4u
X173 A GATE B A sg13_hv_pmos ad=3.1392p pd=10.16u as=5.4312p ps=15.6u w=4.36u l=0.4u
X174 B GATE A A sg13_hv_pmos ad=5.4312p pd=15.6u as=5.5584p ps=15.52u w=4.36u l=0.4u
X175 A GATE B A sg13_hv_pmos ad=5.5584p pd=15.52u as=5.4312p ps=15.6u w=4.36u l=0.4u
X176 A GATE B A sg13_hv_pmos ad=5.5584p pd=15.52u as=3.052p ps=10.12u w=4.36u l=0.4u
X177 B GATE A A sg13_hv_pmos ad=5.4312p pd=15.6u as=5.5584p ps=15.52u w=4.36u l=0.4u
X178 A GATE B A sg13_hv_pmos ad=5.5584p pd=15.52u as=5.4312p ps=15.6u w=4.36u l=0.4u
X179 B GATE A A sg13_hv_pmos ad=5.4312p pd=15.6u as=5.5584p ps=15.52u w=4.36u l=0.4u
X180 B GATE A A sg13_hv_pmos ad=3.052p pd=10.12u as=5.5584p ps=15.52u w=4.36u l=0.4u
X181 A GATE B A sg13_hv_pmos ad=5.5584p pd=15.52u as=5.4312p ps=15.6u w=4.36u l=0.4u
X182 B GATE A A sg13_hv_pmos ad=5.4312p pd=15.6u as=5.5584p ps=15.52u w=4.36u l=0.4u
X183 A GATE B A sg13_hv_pmos ad=5.5584p pd=15.52u as=5.4312p ps=15.6u w=4.36u l=0.4u
X184 A GATE B A sg13_hv_pmos ad=5.5584p pd=15.52u as=5.4312p ps=15.6u w=4.36u l=0.4u
X185 A GATE B A sg13_hv_pmos ad=5.5584p pd=15.52u as=5.4312p ps=15.6u w=4.36u l=0.4u
X186 B GATE A A sg13_hv_pmos ad=5.4312p pd=15.6u as=5.5584p ps=15.52u w=4.36u l=0.4u
X187 A GATE B A sg13_hv_pmos ad=5.5584p pd=15.52u as=5.4312p ps=15.6u w=4.36u l=0.4u
X188 B GATE A A sg13_hv_pmos ad=5.4312p pd=15.6u as=5.5584p ps=15.52u w=4.36u l=0.4u
X189 B GATE A A sg13_hv_pmos ad=5.4312p pd=15.6u as=5.5584p ps=15.52u w=4.36u l=0.4u
X190 B GATE A A sg13_hv_pmos ad=5.4312p pd=15.6u as=5.5584p ps=15.52u w=4.36u l=0.4u
X191 A GATE B A sg13_hv_pmos ad=5.5584p pd=15.52u as=5.4312p ps=15.6u w=4.36u l=0.4u
X192 B GATE A A sg13_hv_pmos ad=5.4312p pd=15.6u as=5.5584p ps=15.52u w=4.36u l=0.4u
X193 B GATE A A sg13_hv_pmos ad=5.4312p pd=15.6u as=5.5584p ps=15.52u w=4.36u l=0.4u
X194 A GATE B A sg13_hv_pmos ad=5.5584p pd=15.52u as=5.4312p ps=15.6u w=4.36u l=0.4u
X195 A GATE B A sg13_hv_pmos ad=5.5584p pd=15.52u as=5.4312p ps=15.6u w=4.36u l=0.4u
X196 A GATE B A sg13_hv_pmos ad=5.5584p pd=15.52u as=5.4312p ps=15.6u w=4.36u l=0.4u
X197 B GATE A A sg13_hv_pmos ad=5.4312p pd=15.6u as=3.1392p ps=10.16u w=4.36u l=0.4u
X198 A GATE B A sg13_hv_pmos ad=5.5584p pd=15.52u as=5.4312p ps=15.6u w=4.36u l=0.4u
X199 B GATE A A sg13_hv_pmos ad=5.4312p pd=15.6u as=5.5584p ps=15.52u w=4.36u l=0.4u
X200 A GATE B A sg13_hv_pmos ad=5.5584p pd=15.52u as=5.4312p ps=15.6u w=4.36u l=0.4u
X201 B GATE A A sg13_hv_pmos ad=5.4312p pd=15.6u as=5.5584p ps=15.52u w=4.36u l=0.4u
X202 B GATE A A sg13_hv_pmos ad=5.4312p pd=15.6u as=5.5584p ps=15.52u w=4.36u l=0.4u
X203 B GATE A A sg13_hv_pmos ad=5.4312p pd=15.6u as=5.5584p ps=15.52u w=4.36u l=0.4u
X204 A GATE B A sg13_hv_pmos ad=5.5584p pd=15.52u as=5.4312p ps=15.6u w=4.36u l=0.4u
X205 B GATE A A sg13_hv_pmos ad=5.4312p pd=15.6u as=5.5584p ps=15.52u w=4.36u l=0.4u
X206 B GATE A A sg13_hv_pmos ad=5.4312p pd=15.6u as=5.5584p ps=15.52u w=4.36u l=0.4u
X207 A GATE B A sg13_hv_pmos ad=5.5584p pd=15.52u as=5.4312p ps=15.6u w=4.36u l=0.4u
X208 A GATE B A sg13_hv_pmos ad=5.5584p pd=15.52u as=5.4312p ps=15.6u w=4.36u l=0.4u
X209 A GATE B A sg13_hv_pmos ad=5.5584p pd=15.52u as=5.4312p ps=15.6u w=4.36u l=0.4u
X210 B GATE A A sg13_hv_pmos ad=5.4312p pd=15.6u as=3.1392p ps=10.16u w=4.36u l=0.4u
X211 A GATE B A sg13_hv_pmos ad=5.5584p pd=15.52u as=5.4312p ps=15.6u w=4.36u l=0.4u
X212 B GATE A A sg13_hv_pmos ad=5.4312p pd=15.6u as=5.5584p ps=15.52u w=4.36u l=0.4u
X213 A GATE B A sg13_hv_pmos ad=5.5584p pd=15.52u as=5.4312p ps=15.6u w=4.36u l=0.4u
X214 A GATE B A sg13_hv_pmos ad=5.5584p pd=15.52u as=5.4312p ps=15.6u w=4.36u l=0.4u
X215 B GATE A A sg13_hv_pmos ad=5.4312p pd=15.6u as=5.5584p ps=15.52u w=4.36u l=0.4u
X216 B GATE A A sg13_hv_pmos ad=5.4312p pd=15.6u as=5.5584p ps=15.52u w=4.36u l=0.4u
X217 B GATE A A sg13_hv_pmos ad=5.4312p pd=15.6u as=5.5584p ps=15.52u w=4.36u l=0.4u
X218 B GATE A A sg13_hv_pmos ad=5.4312p pd=15.6u as=5.5584p ps=15.52u w=4.36u l=0.4u
X219 B GATE A A sg13_hv_pmos ad=5.4312p pd=15.6u as=5.5584p ps=15.52u w=4.36u l=0.4u
X220 A GATE B A sg13_hv_pmos ad=5.5584p pd=15.52u as=5.4312p ps=15.6u w=4.36u l=0.4u
X221 B GATE A A sg13_hv_pmos ad=5.4312p pd=15.6u as=5.5584p ps=15.52u w=4.36u l=0.4u
X222 A GATE B A sg13_hv_pmos ad=5.5584p pd=15.52u as=5.4312p ps=15.6u w=4.36u l=0.4u
X223 A GATE B A sg13_hv_pmos ad=5.5584p pd=15.52u as=5.4312p ps=15.6u w=4.36u l=0.4u
X224 A GATE B A sg13_hv_pmos ad=5.5584p pd=15.52u as=5.4312p ps=15.6u w=4.36u l=0.4u
X225 A GATE B A sg13_hv_pmos ad=5.5584p pd=15.52u as=5.4312p ps=15.6u w=4.36u l=0.4u
X226 A GATE B A sg13_hv_pmos ad=5.5584p pd=15.52u as=5.4312p ps=15.6u w=4.36u l=0.4u
X227 B GATE A A sg13_hv_pmos ad=5.4312p pd=15.6u as=5.5584p ps=15.52u w=4.36u l=0.4u
X228 B GATE A A sg13_hv_pmos ad=5.4312p pd=15.6u as=5.5584p ps=15.52u w=4.36u l=0.4u
X229 B GATE A A sg13_hv_pmos ad=5.4312p pd=15.6u as=5.5584p ps=15.52u w=4.36u l=0.4u
X230 B GATE A A sg13_hv_pmos ad=5.4312p pd=15.6u as=5.5584p ps=15.52u w=4.36u l=0.4u
X231 B GATE A A sg13_hv_pmos ad=5.4312p pd=15.6u as=5.5584p ps=15.52u w=4.36u l=0.4u
X232 A GATE B A sg13_hv_pmos ad=5.5584p pd=15.52u as=5.4312p ps=15.6u w=4.36u l=0.4u
X233 B GATE A A sg13_hv_pmos ad=5.4312p pd=15.6u as=5.5584p ps=15.52u w=4.36u l=0.4u
X234 A GATE B A sg13_hv_pmos ad=5.5584p pd=15.52u as=5.4312p ps=15.6u w=4.36u l=0.4u
X235 A GATE B A sg13_hv_pmos ad=5.5584p pd=15.52u as=5.4312p ps=15.6u w=4.36u l=0.4u
X236 A GATE B A sg13_hv_pmos ad=5.5584p pd=15.52u as=5.4312p ps=15.6u w=4.36u l=0.4u
X237 B GATE A A sg13_hv_pmos ad=5.4312p pd=15.6u as=5.5584p ps=15.52u w=4.36u l=0.4u
X238 A GATE B A sg13_hv_pmos ad=5.5584p pd=15.52u as=5.4312p ps=15.6u w=4.36u l=0.4u
X239 B GATE A A sg13_hv_pmos ad=5.4312p pd=15.6u as=5.5584p ps=15.52u w=4.36u l=0.4u
X240 B GATE A A sg13_hv_pmos ad=5.4312p pd=15.6u as=5.5584p ps=15.52u w=4.36u l=0.4u
X241 A GATE B A sg13_hv_pmos ad=5.5584p pd=15.52u as=5.4312p ps=15.6u w=4.36u l=0.4u
X242 B GATE A A sg13_hv_pmos ad=5.4312p pd=15.6u as=5.5584p ps=15.52u w=4.36u l=0.4u
X243 A GATE B A sg13_hv_pmos ad=5.5584p pd=15.52u as=3.052p ps=10.12u w=4.36u l=0.4u
X244 B GATE A A sg13_hv_pmos ad=5.4312p pd=15.6u as=5.5584p ps=15.52u w=4.36u l=0.4u
X245 A GATE B A sg13_hv_pmos ad=5.5584p pd=15.52u as=5.4312p ps=15.6u w=4.36u l=0.4u
X246 B GATE A A sg13_hv_pmos ad=5.4312p pd=15.6u as=5.5584p ps=15.52u w=4.36u l=0.4u
X247 A GATE B A sg13_hv_pmos ad=5.5584p pd=15.52u as=5.4312p ps=15.6u w=4.36u l=0.4u
X248 B GATE A A sg13_hv_pmos ad=5.4312p pd=15.6u as=5.5584p ps=15.52u w=4.36u l=0.4u
X249 A GATE B A sg13_hv_pmos ad=5.5584p pd=15.52u as=5.4312p ps=15.6u w=4.36u l=0.4u
X250 A GATE B A sg13_hv_pmos ad=5.5584p pd=15.52u as=5.4312p ps=15.6u w=4.36u l=0.4u
X251 A GATE B A sg13_hv_pmos ad=5.5584p pd=15.52u as=5.4312p ps=15.6u w=4.36u l=0.4u
X252 A GATE B A sg13_hv_pmos ad=5.5584p pd=15.52u as=5.4312p ps=15.6u w=4.36u l=0.4u
X253 B GATE A A sg13_hv_pmos ad=5.4312p pd=15.6u as=5.5584p ps=15.52u w=4.36u l=0.4u
X254 A GATE B A sg13_hv_pmos ad=5.5584p pd=15.52u as=5.4312p ps=15.6u w=4.36u l=0.4u
X255 B GATE A A sg13_hv_pmos ad=5.4312p pd=15.6u as=5.5584p ps=15.52u w=4.36u l=0.4u
X256 B GATE A A sg13_hv_pmos ad=5.4312p pd=15.6u as=5.5584p ps=15.52u w=4.36u l=0.4u
X257 B GATE A A sg13_hv_pmos ad=5.4312p pd=15.6u as=5.5584p ps=15.52u w=4.36u l=0.4u
X258 B GATE A A sg13_hv_pmos ad=5.4312p pd=15.6u as=5.5584p ps=15.52u w=4.36u l=0.4u
X259 B GATE A A sg13_hv_pmos ad=5.4312p pd=15.6u as=5.5584p ps=15.52u w=4.36u l=0.4u
X260 B GATE A A sg13_hv_pmos ad=5.4312p pd=15.6u as=5.5584p ps=15.52u w=4.36u l=0.4u
X261 A GATE B A sg13_hv_pmos ad=5.5584p pd=15.52u as=5.4312p ps=15.6u w=4.36u l=0.4u
X262 A GATE B A sg13_hv_pmos ad=5.5584p pd=15.52u as=5.4312p ps=15.6u w=4.36u l=0.4u
X263 A GATE B A sg13_hv_pmos ad=5.5584p pd=15.52u as=5.4312p ps=15.6u w=4.36u l=0.4u
X264 A GATE B A sg13_hv_pmos ad=5.5584p pd=15.52u as=5.4312p ps=15.6u w=4.36u l=0.4u
X265 A GATE B A sg13_hv_pmos ad=5.5584p pd=15.52u as=5.4312p ps=15.6u w=4.36u l=0.4u
X266 B GATE A A sg13_hv_pmos ad=5.4312p pd=15.6u as=5.5584p ps=15.52u w=4.36u l=0.4u
X267 A GATE B A sg13_hv_pmos ad=5.5584p pd=15.52u as=5.4312p ps=15.6u w=4.36u l=0.4u
X268 B GATE A A sg13_hv_pmos ad=5.4312p pd=15.6u as=5.5584p ps=15.52u w=4.36u l=0.4u
X269 B GATE A A sg13_hv_pmos ad=5.4312p pd=15.6u as=5.5584p ps=15.52u w=4.36u l=0.4u
X270 B GATE A A sg13_hv_pmos ad=5.4312p pd=15.6u as=5.5584p ps=15.52u w=4.36u l=0.4u
X271 A GATE B A sg13_hv_pmos ad=5.5584p pd=15.52u as=5.4312p ps=15.6u w=4.36u l=0.4u
X272 B GATE A A sg13_hv_pmos ad=5.4312p pd=15.6u as=5.5584p ps=15.52u w=4.36u l=0.4u
X273 A GATE B A sg13_hv_pmos ad=3.1392p pd=10.16u as=5.4312p ps=15.6u w=4.36u l=0.4u
X274 A GATE B A sg13_hv_pmos ad=5.5584p pd=15.52u as=5.4312p ps=15.6u w=4.36u l=0.4u
X275 A GATE B A sg13_hv_pmos ad=5.5584p pd=15.52u as=5.4312p ps=15.6u w=4.36u l=0.4u
X276 B GATE A A sg13_hv_pmos ad=5.4312p pd=15.6u as=5.5584p ps=15.52u w=4.36u l=0.4u
X277 A GATE B A sg13_hv_pmos ad=5.5584p pd=15.52u as=5.4312p ps=15.6u w=4.36u l=0.4u
X278 B GATE A A sg13_hv_pmos ad=5.4312p pd=15.6u as=3.1392p ps=10.16u w=4.36u l=0.4u
X279 A GATE B A sg13_hv_pmos ad=5.5584p pd=15.52u as=5.4312p ps=15.6u w=4.36u l=0.4u
X280 B GATE A A sg13_hv_pmos ad=5.4312p pd=15.6u as=5.5584p ps=15.52u w=4.36u l=0.4u
X281 A GATE B A sg13_hv_pmos ad=5.5584p pd=15.52u as=5.4312p ps=15.6u w=4.36u l=0.4u
X282 B GATE A A sg13_hv_pmos ad=5.4312p pd=15.6u as=5.5584p ps=15.52u w=4.36u l=0.4u
X283 A GATE B A sg13_hv_pmos ad=5.5584p pd=15.52u as=5.4312p ps=15.6u w=4.36u l=0.4u
X284 B GATE A A sg13_hv_pmos ad=5.4312p pd=15.6u as=5.5584p ps=15.52u w=4.36u l=0.4u
X285 B GATE A A sg13_hv_pmos ad=5.4312p pd=15.6u as=5.5584p ps=15.52u w=4.36u l=0.4u
X286 B GATE A A sg13_hv_pmos ad=5.4312p pd=15.6u as=5.5584p ps=15.52u w=4.36u l=0.4u
X287 B GATE A A sg13_hv_pmos ad=5.4312p pd=15.6u as=5.5584p ps=15.52u w=4.36u l=0.4u
X288 B GATE A A sg13_hv_pmos ad=5.4312p pd=15.6u as=5.5584p ps=15.52u w=4.36u l=0.4u
X289 B GATE A A sg13_hv_pmos ad=5.4312p pd=15.6u as=5.5584p ps=15.52u w=4.36u l=0.4u
X290 A GATE B A sg13_hv_pmos ad=5.5584p pd=15.52u as=5.4312p ps=15.6u w=4.36u l=0.4u
X291 B GATE A A sg13_hv_pmos ad=5.4312p pd=15.6u as=5.5584p ps=15.52u w=4.36u l=0.4u
X292 A GATE B A sg13_hv_pmos ad=5.5584p pd=15.52u as=5.4312p ps=15.6u w=4.36u l=0.4u
X293 A GATE B A sg13_hv_pmos ad=5.5584p pd=15.52u as=5.4312p ps=15.6u w=4.36u l=0.4u
X294 B GATE A A sg13_hv_pmos ad=5.4312p pd=15.6u as=5.5584p ps=15.52u w=4.36u l=0.4u
X295 A GATE B A sg13_hv_pmos ad=5.5584p pd=15.52u as=5.4312p ps=15.6u w=4.36u l=0.4u
X296 B GATE A A sg13_hv_pmos ad=5.4312p pd=15.6u as=5.5584p ps=15.52u w=4.36u l=0.4u
X297 A GATE B A sg13_hv_pmos ad=5.5584p pd=15.52u as=5.4312p ps=15.6u w=4.36u l=0.4u
X298 B GATE A A sg13_hv_pmos ad=5.4312p pd=15.6u as=5.5584p ps=15.52u w=4.36u l=0.4u
X299 A GATE B A sg13_hv_pmos ad=5.5584p pd=15.52u as=5.4312p ps=15.6u w=4.36u l=0.4u
X300 B GATE A A sg13_hv_pmos ad=5.4312p pd=15.6u as=5.5584p ps=15.52u w=4.36u l=0.4u
X301 B GATE A A sg13_hv_pmos ad=5.4312p pd=15.6u as=5.5584p ps=15.52u w=4.36u l=0.4u
X302 B GATE A A sg13_hv_pmos ad=5.4312p pd=15.6u as=5.5584p ps=15.52u w=4.36u l=0.4u
X303 A GATE B A sg13_hv_pmos ad=5.5584p pd=15.52u as=5.4312p ps=15.6u w=4.36u l=0.4u
X304 A GATE B A sg13_hv_pmos ad=5.5584p pd=15.52u as=5.4312p ps=15.6u w=4.36u l=0.4u
X305 A GATE B A sg13_hv_pmos ad=5.5584p pd=15.52u as=5.4312p ps=15.6u w=4.36u l=0.4u
X306 A GATE B A sg13_hv_pmos ad=5.5584p pd=15.52u as=5.4312p ps=15.6u w=4.36u l=0.4u
X307 B GATE A A sg13_hv_pmos ad=5.4312p pd=15.6u as=5.5584p ps=15.52u w=4.36u l=0.4u
X308 A GATE B A sg13_hv_pmos ad=5.5584p pd=15.52u as=5.4312p ps=15.6u w=4.36u l=0.4u
X309 B GATE A A sg13_hv_pmos ad=5.4312p pd=15.6u as=5.5584p ps=15.52u w=4.36u l=0.4u
X310 B GATE A A sg13_hv_pmos ad=5.4312p pd=15.6u as=5.5584p ps=15.52u w=4.36u l=0.4u
X311 B GATE A A sg13_hv_pmos ad=5.4312p pd=15.6u as=5.5584p ps=15.52u w=4.36u l=0.4u
X312 A GATE B A sg13_hv_pmos ad=5.5584p pd=15.52u as=5.4312p ps=15.6u w=4.36u l=0.4u
X313 B GATE A A sg13_hv_pmos ad=5.4312p pd=15.6u as=5.5584p ps=15.52u w=4.36u l=0.4u
X314 A GATE B A sg13_hv_pmos ad=5.5584p pd=15.52u as=3.052p ps=10.12u w=4.36u l=0.4u
X315 A GATE B A sg13_hv_pmos ad=5.5584p pd=15.52u as=5.4312p ps=15.6u w=4.36u l=0.4u
X316 B GATE A A sg13_hv_pmos ad=5.4312p pd=15.6u as=5.5584p ps=15.52u w=4.36u l=0.4u
X317 A GATE B A sg13_hv_pmos ad=5.5584p pd=15.52u as=5.4312p ps=15.6u w=4.36u l=0.4u
X318 B GATE A A sg13_hv_pmos ad=5.4312p pd=15.6u as=5.5584p ps=15.52u w=4.36u l=0.4u
X319 B GATE A A sg13_hv_pmos ad=5.4312p pd=15.6u as=5.5584p ps=15.52u w=4.36u l=0.4u
X320 B GATE A A sg13_hv_pmos ad=5.4312p pd=15.6u as=5.5584p ps=15.52u w=4.36u l=0.4u
X321 A GATE B A sg13_hv_pmos ad=5.5584p pd=15.52u as=5.4312p ps=15.6u w=4.36u l=0.4u
X322 A GATE B A sg13_hv_pmos ad=5.5584p pd=15.52u as=5.4312p ps=15.6u w=4.36u l=0.4u
X323 A GATE B A sg13_hv_pmos ad=5.5584p pd=15.52u as=5.4312p ps=15.6u w=4.36u l=0.4u
X324 B GATE A A sg13_hv_pmos ad=5.4312p pd=15.6u as=5.5584p ps=15.52u w=4.36u l=0.4u
X325 A GATE B A sg13_hv_pmos ad=5.5584p pd=15.52u as=5.4312p ps=15.6u w=4.36u l=0.4u
X326 A GATE B A sg13_hv_pmos ad=5.5584p pd=15.52u as=5.4312p ps=15.6u w=4.36u l=0.4u
X327 B GATE A A sg13_hv_pmos ad=5.4312p pd=15.6u as=5.5584p ps=15.52u w=4.36u l=0.4u
X328 A GATE B A sg13_hv_pmos ad=5.5584p pd=15.52u as=5.4312p ps=15.6u w=4.36u l=0.4u
X329 B GATE A A sg13_hv_pmos ad=5.4312p pd=15.6u as=5.5584p ps=15.52u w=4.36u l=0.4u
X330 B GATE A A sg13_hv_pmos ad=5.4312p pd=15.6u as=5.5584p ps=15.52u w=4.36u l=0.4u
X331 A GATE B A sg13_hv_pmos ad=5.5584p pd=15.52u as=5.4312p ps=15.6u w=4.36u l=0.4u
X332 B GATE A A sg13_hv_pmos ad=5.4312p pd=15.6u as=5.5584p ps=15.52u w=4.36u l=0.4u
X333 A GATE B A sg13_hv_pmos ad=5.5584p pd=15.52u as=5.4312p ps=15.6u w=4.36u l=0.4u
X334 B GATE A A sg13_hv_pmos ad=5.4312p pd=15.6u as=5.5584p ps=15.52u w=4.36u l=0.4u
X335 A GATE B A sg13_hv_pmos ad=5.5584p pd=15.52u as=5.4312p ps=15.6u w=4.36u l=0.4u
X336 A GATE B A sg13_hv_pmos ad=5.5584p pd=15.52u as=5.4312p ps=15.6u w=4.36u l=0.4u
X337 A GATE B A sg13_hv_pmos ad=5.5584p pd=15.52u as=5.4312p ps=15.6u w=4.36u l=0.4u
X338 B GATE A A sg13_hv_pmos ad=5.4312p pd=15.6u as=5.5584p ps=15.52u w=4.36u l=0.4u
X339 A GATE B A sg13_hv_pmos ad=3.1392p pd=10.16u as=5.4312p ps=15.6u w=4.36u l=0.4u
X340 B GATE A A sg13_hv_pmos ad=5.4312p pd=15.6u as=5.5584p ps=15.52u w=4.36u l=0.4u
X341 B GATE A A sg13_hv_pmos ad=5.4312p pd=15.6u as=5.5584p ps=15.52u w=4.36u l=0.4u
X342 B GATE A A sg13_hv_pmos ad=5.4312p pd=15.6u as=5.5584p ps=15.52u w=4.36u l=0.4u
X343 A GATE B A sg13_hv_pmos ad=5.5584p pd=15.52u as=5.4312p ps=15.6u w=4.36u l=0.4u
X344 A GATE B A sg13_hv_pmos ad=5.5584p pd=15.52u as=5.4312p ps=15.6u w=4.36u l=0.4u
X345 B GATE A A sg13_hv_pmos ad=5.4312p pd=15.6u as=5.5584p ps=15.52u w=4.36u l=0.4u
X346 B GATE A A sg13_hv_pmos ad=5.4312p pd=15.6u as=5.5584p ps=15.52u w=4.36u l=0.4u
X347 A GATE B A sg13_hv_pmos ad=5.5584p pd=15.52u as=5.4312p ps=15.6u w=4.36u l=0.4u
X348 B GATE A A sg13_hv_pmos ad=5.4312p pd=15.6u as=5.5584p ps=15.52u w=4.36u l=0.4u
X349 A GATE B A sg13_hv_pmos ad=5.5584p pd=15.52u as=5.4312p ps=15.6u w=4.36u l=0.4u
X350 A GATE B A sg13_hv_pmos ad=5.5584p pd=15.52u as=5.4312p ps=15.6u w=4.36u l=0.4u
X351 A GATE B A sg13_hv_pmos ad=5.5584p pd=15.52u as=5.4312p ps=15.6u w=4.36u l=0.4u
X352 B GATE A A sg13_hv_pmos ad=5.4312p pd=15.6u as=5.5584p ps=15.52u w=4.36u l=0.4u
X353 B GATE A A sg13_hv_pmos ad=5.4312p pd=15.6u as=5.5584p ps=15.52u w=4.36u l=0.4u
X354 B GATE A A sg13_hv_pmos ad=5.4312p pd=15.6u as=5.5584p ps=15.52u w=4.36u l=0.4u
X355 B GATE A A sg13_hv_pmos ad=5.4312p pd=15.6u as=5.5584p ps=15.52u w=4.36u l=0.4u
X356 A GATE B A sg13_hv_pmos ad=5.5584p pd=15.52u as=5.4312p ps=15.6u w=4.36u l=0.4u
X357 B GATE A A sg13_hv_pmos ad=5.4312p pd=15.6u as=5.5584p ps=15.52u w=4.36u l=0.4u
X358 A GATE B A sg13_hv_pmos ad=5.5584p pd=15.52u as=5.4312p ps=15.6u w=4.36u l=0.4u
X359 B GATE A A sg13_hv_pmos ad=5.4312p pd=15.6u as=5.5584p ps=15.52u w=4.36u l=0.4u
X360 A GATE B A sg13_hv_pmos ad=5.5584p pd=15.52u as=5.4312p ps=15.6u w=4.36u l=0.4u
X361 B GATE A A sg13_hv_pmos ad=5.4312p pd=15.6u as=5.5584p ps=15.52u w=4.36u l=0.4u
X362 A GATE B A sg13_hv_pmos ad=5.5584p pd=15.52u as=5.4312p ps=15.6u w=4.36u l=0.4u
X363 A GATE B A sg13_hv_pmos ad=5.5584p pd=15.52u as=5.4312p ps=15.6u w=4.36u l=0.4u
X364 B GATE A A sg13_hv_pmos ad=5.4312p pd=15.6u as=5.5584p ps=15.52u w=4.36u l=0.4u
X365 A GATE B A sg13_hv_pmos ad=5.5584p pd=15.52u as=5.4312p ps=15.6u w=4.36u l=0.4u
X366 B GATE A A sg13_hv_pmos ad=5.4312p pd=15.6u as=5.5584p ps=15.52u w=4.36u l=0.4u
X367 B GATE A A sg13_hv_pmos ad=5.4312p pd=15.6u as=5.5584p ps=15.52u w=4.36u l=0.4u
X368 A GATE B A sg13_hv_pmos ad=5.5584p pd=15.52u as=5.4312p ps=15.6u w=4.36u l=0.4u
X369 B GATE A A sg13_hv_pmos ad=5.4312p pd=15.6u as=5.5584p ps=15.52u w=4.36u l=0.4u
X370 B GATE A A sg13_hv_pmos ad=3.052p pd=10.12u as=5.5584p ps=15.52u w=4.36u l=0.4u
X371 A GATE B A sg13_hv_pmos ad=5.5584p pd=15.52u as=5.4312p ps=15.6u w=4.36u l=0.4u
X372 A GATE B A sg13_hv_pmos ad=5.5584p pd=15.52u as=5.4312p ps=15.6u w=4.36u l=0.4u
X373 B GATE A A sg13_hv_pmos ad=5.4312p pd=15.6u as=5.5584p ps=15.52u w=4.36u l=0.4u
X374 B GATE A A sg13_hv_pmos ad=5.4312p pd=15.6u as=5.5584p ps=15.52u w=4.36u l=0.4u
X375 A GATE B A sg13_hv_pmos ad=5.5584p pd=15.52u as=5.4312p ps=15.6u w=4.36u l=0.4u
X376 A GATE B A sg13_hv_pmos ad=5.5584p pd=15.52u as=3.052p ps=10.12u w=4.36u l=0.4u
X377 A GATE B A sg13_hv_pmos ad=5.5584p pd=15.52u as=5.4312p ps=15.6u w=4.36u l=0.4u
X378 A GATE B A sg13_hv_pmos ad=5.5584p pd=15.52u as=5.4312p ps=15.6u w=4.36u l=0.4u
X379 B GATE A A sg13_hv_pmos ad=5.4312p pd=15.6u as=5.5584p ps=15.52u w=4.36u l=0.4u
X380 A GATE B A sg13_hv_pmos ad=5.5584p pd=15.52u as=5.4312p ps=15.6u w=4.36u l=0.4u
X381 A GATE B A sg13_hv_pmos ad=5.5584p pd=15.52u as=5.4312p ps=15.6u w=4.36u l=0.4u
X382 B GATE A A sg13_hv_pmos ad=5.4312p pd=15.6u as=5.5584p ps=15.52u w=4.36u l=0.4u
X383 B GATE A A sg13_hv_pmos ad=5.4312p pd=15.6u as=5.5584p ps=15.52u w=4.36u l=0.4u
X384 B GATE A A sg13_hv_pmos ad=5.4312p pd=15.6u as=5.5584p ps=15.52u w=4.36u l=0.4u
X385 A GATE B A sg13_hv_pmos ad=5.5584p pd=15.52u as=5.4312p ps=15.6u w=4.36u l=0.4u
X386 B GATE A A sg13_hv_pmos ad=5.4312p pd=15.6u as=5.5584p ps=15.52u w=4.36u l=0.4u
X387 A GATE B A sg13_hv_pmos ad=5.5584p pd=15.52u as=5.4312p ps=15.6u w=4.36u l=0.4u
X388 B GATE A A sg13_hv_pmos ad=5.4312p pd=15.6u as=5.5584p ps=15.52u w=4.36u l=0.4u
X389 A GATE B A sg13_hv_pmos ad=5.5584p pd=15.52u as=5.4312p ps=15.6u w=4.36u l=0.4u
X390 B GATE A A sg13_hv_pmos ad=5.4312p pd=15.6u as=5.5584p ps=15.52u w=4.36u l=0.4u
X391 A GATE B A sg13_hv_pmos ad=5.5584p pd=15.52u as=5.4312p ps=15.6u w=4.36u l=0.4u
X392 A GATE B A sg13_hv_pmos ad=5.5584p pd=15.52u as=5.4312p ps=15.6u w=4.36u l=0.4u
X393 B GATE A A sg13_hv_pmos ad=5.4312p pd=15.6u as=5.5584p ps=15.52u w=4.36u l=0.4u
X394 B GATE A A sg13_hv_pmos ad=5.4312p pd=15.6u as=5.5584p ps=15.52u w=4.36u l=0.4u
X395 A GATE B A sg13_hv_pmos ad=5.5584p pd=15.52u as=5.4312p ps=15.6u w=4.36u l=0.4u
X396 B GATE A A sg13_hv_pmos ad=5.4312p pd=15.6u as=5.5584p ps=15.52u w=4.36u l=0.4u
X397 A GATE B A sg13_hv_pmos ad=5.5584p pd=15.52u as=5.4312p ps=15.6u w=4.36u l=0.4u
X398 A GATE B A sg13_hv_pmos ad=5.5584p pd=15.52u as=5.4312p ps=15.6u w=4.36u l=0.4u
X399 B GATE A A sg13_hv_pmos ad=5.4312p pd=15.6u as=5.5584p ps=15.52u w=4.36u l=0.4u
X400 B GATE A A sg13_hv_pmos ad=5.4312p pd=15.6u as=5.5584p ps=15.52u w=4.36u l=0.4u
X401 B GATE A A sg13_hv_pmos ad=5.4312p pd=15.6u as=3.1392p ps=10.16u w=4.36u l=0.4u
X402 A GATE B A sg13_hv_pmos ad=5.5584p pd=15.52u as=3.052p ps=10.12u w=4.36u l=0.4u
X403 A GATE B A sg13_hv_pmos ad=5.5584p pd=15.52u as=5.4312p ps=15.6u w=4.36u l=0.4u
X404 A GATE B A sg13_hv_pmos ad=5.5584p pd=15.52u as=3.052p ps=10.12u w=4.36u l=0.4u
X405 A GATE B A sg13_hv_pmos ad=3.1392p pd=10.16u as=5.4312p ps=15.6u w=4.36u l=0.4u
X406 A GATE B A sg13_hv_pmos ad=5.5584p pd=15.52u as=5.4312p ps=15.6u w=4.36u l=0.4u
X407 B GATE A A sg13_hv_pmos ad=5.4312p pd=15.6u as=5.5584p ps=15.52u w=4.36u l=0.4u
X408 A GATE B A sg13_hv_pmos ad=5.5584p pd=15.52u as=5.4312p ps=15.6u w=4.36u l=0.4u
X409 B GATE A A sg13_hv_pmos ad=5.4312p pd=15.6u as=5.5584p ps=15.52u w=4.36u l=0.4u
X410 A GATE B A sg13_hv_pmos ad=5.5584p pd=15.52u as=5.4312p ps=15.6u w=4.36u l=0.4u
X411 B GATE A A sg13_hv_pmos ad=5.4312p pd=15.6u as=5.5584p ps=15.52u w=4.36u l=0.4u
X412 B GATE A A sg13_hv_pmos ad=5.4312p pd=15.6u as=5.5584p ps=15.52u w=4.36u l=0.4u
X413 B GATE A A sg13_hv_pmos ad=5.4312p pd=15.6u as=5.5584p ps=15.52u w=4.36u l=0.4u
X414 B GATE A A sg13_hv_pmos ad=5.4312p pd=15.6u as=5.5584p ps=15.52u w=4.36u l=0.4u
X415 A GATE B A sg13_hv_pmos ad=5.5584p pd=15.52u as=5.4312p ps=15.6u w=4.36u l=0.4u
X416 A GATE B A sg13_hv_pmos ad=5.5584p pd=15.52u as=5.4312p ps=15.6u w=4.36u l=0.4u
X417 B GATE A A sg13_hv_pmos ad=5.4312p pd=15.6u as=5.5584p ps=15.52u w=4.36u l=0.4u
X418 A GATE B A sg13_hv_pmos ad=5.5584p pd=15.52u as=5.4312p ps=15.6u w=4.36u l=0.4u
X419 A GATE B A sg13_hv_pmos ad=5.5584p pd=15.52u as=5.4312p ps=15.6u w=4.36u l=0.4u
X420 B GATE A A sg13_hv_pmos ad=5.4312p pd=15.6u as=5.5584p ps=15.52u w=4.36u l=0.4u
X421 A GATE B A sg13_hv_pmos ad=5.5584p pd=15.52u as=5.4312p ps=15.6u w=4.36u l=0.4u
X422 B GATE A A sg13_hv_pmos ad=5.4312p pd=15.6u as=5.5584p ps=15.52u w=4.36u l=0.4u
X423 A GATE B A sg13_hv_pmos ad=5.5584p pd=15.52u as=5.4312p ps=15.6u w=4.36u l=0.4u
X424 B GATE A A sg13_hv_pmos ad=5.4312p pd=15.6u as=5.5584p ps=15.52u w=4.36u l=0.4u
X425 B GATE A A sg13_hv_pmos ad=5.4312p pd=15.6u as=5.5584p ps=15.52u w=4.36u l=0.4u
X426 B GATE A A sg13_hv_pmos ad=5.4312p pd=15.6u as=5.5584p ps=15.52u w=4.36u l=0.4u
X427 A GATE B A sg13_hv_pmos ad=5.5584p pd=15.52u as=5.4312p ps=15.6u w=4.36u l=0.4u
X428 A GATE B A sg13_hv_pmos ad=5.5584p pd=15.52u as=3.052p ps=10.12u w=4.36u l=0.4u
X429 A GATE B A sg13_hv_pmos ad=5.5584p pd=15.52u as=5.4312p ps=15.6u w=4.36u l=0.4u
X430 B GATE A A sg13_hv_pmos ad=5.4312p pd=15.6u as=5.5584p ps=15.52u w=4.36u l=0.4u
X431 A GATE B A sg13_hv_pmos ad=5.5584p pd=15.52u as=5.4312p ps=15.6u w=4.36u l=0.4u
X432 A GATE B A sg13_hv_pmos ad=5.5584p pd=15.52u as=5.4312p ps=15.6u w=4.36u l=0.4u
X433 B GATE A A sg13_hv_pmos ad=5.4312p pd=15.6u as=5.5584p ps=15.52u w=4.36u l=0.4u
X434 B GATE A A sg13_hv_pmos ad=3.052p pd=10.12u as=5.5584p ps=15.52u w=4.36u l=0.4u
X435 B GATE A A sg13_hv_pmos ad=5.4312p pd=15.6u as=5.5584p ps=15.52u w=4.36u l=0.4u
X436 A GATE B A sg13_hv_pmos ad=5.5584p pd=15.52u as=5.4312p ps=15.6u w=4.36u l=0.4u
X437 B GATE A A sg13_hv_pmos ad=5.4312p pd=15.6u as=5.5584p ps=15.52u w=4.36u l=0.4u
X438 A GATE B A sg13_hv_pmos ad=5.5584p pd=15.52u as=5.4312p ps=15.6u w=4.36u l=0.4u
X439 B GATE A A sg13_hv_pmos ad=5.4312p pd=15.6u as=5.5584p ps=15.52u w=4.36u l=0.4u
X440 B GATE A A sg13_hv_pmos ad=5.4312p pd=15.6u as=5.5584p ps=15.52u w=4.36u l=0.4u
X441 A GATE B A sg13_hv_pmos ad=5.5584p pd=15.52u as=5.4312p ps=15.6u w=4.36u l=0.4u
X442 A GATE B A sg13_hv_pmos ad=5.5584p pd=15.52u as=5.4312p ps=15.6u w=4.36u l=0.4u
X443 A GATE B A sg13_hv_pmos ad=5.5584p pd=15.52u as=5.4312p ps=15.6u w=4.36u l=0.4u
X444 A GATE B A sg13_hv_pmos ad=5.5584p pd=15.52u as=5.4312p ps=15.6u w=4.36u l=0.4u
X445 A GATE B A sg13_hv_pmos ad=5.5584p pd=15.52u as=5.4312p ps=15.6u w=4.36u l=0.4u
X446 B GATE A A sg13_hv_pmos ad=5.4312p pd=15.6u as=5.5584p ps=15.52u w=4.36u l=0.4u
X447 B GATE A A sg13_hv_pmos ad=5.4312p pd=15.6u as=5.5584p ps=15.52u w=4.36u l=0.4u
X448 B GATE A A sg13_hv_pmos ad=5.4312p pd=15.6u as=5.5584p ps=15.52u w=4.36u l=0.4u
X449 A GATE B A sg13_hv_pmos ad=5.5584p pd=15.52u as=5.4312p ps=15.6u w=4.36u l=0.4u
X450 B GATE A A sg13_hv_pmos ad=5.4312p pd=15.6u as=5.5584p ps=15.52u w=4.36u l=0.4u
X451 A GATE B A sg13_hv_pmos ad=5.5584p pd=15.52u as=5.4312p ps=15.6u w=4.36u l=0.4u
X452 B GATE A A sg13_hv_pmos ad=5.4312p pd=15.6u as=5.5584p ps=15.52u w=4.36u l=0.4u
X453 A GATE B A sg13_hv_pmos ad=5.5584p pd=15.52u as=5.4312p ps=15.6u w=4.36u l=0.4u
X454 A GATE B A sg13_hv_pmos ad=5.5584p pd=15.52u as=5.4312p ps=15.6u w=4.36u l=0.4u
X455 A GATE B A sg13_hv_pmos ad=5.5584p pd=15.52u as=5.4312p ps=15.6u w=4.36u l=0.4u
X456 B GATE A A sg13_hv_pmos ad=5.4312p pd=15.6u as=5.5584p ps=15.52u w=4.36u l=0.4u
X457 B GATE A A sg13_hv_pmos ad=5.4312p pd=15.6u as=5.5584p ps=15.52u w=4.36u l=0.4u
X458 A GATE B A sg13_hv_pmos ad=5.5584p pd=15.52u as=5.4312p ps=15.6u w=4.36u l=0.4u
X459 B GATE A A sg13_hv_pmos ad=5.4312p pd=15.6u as=5.5584p ps=15.52u w=4.36u l=0.4u
X460 B GATE A A sg13_hv_pmos ad=5.4312p pd=15.6u as=5.5584p ps=15.52u w=4.36u l=0.4u
X461 B GATE A A sg13_hv_pmos ad=5.4312p pd=15.6u as=5.5584p ps=15.52u w=4.36u l=0.4u
X462 A GATE B A sg13_hv_pmos ad=5.5584p pd=15.52u as=5.4312p ps=15.6u w=4.36u l=0.4u
X463 B GATE A A sg13_hv_pmos ad=5.4312p pd=15.6u as=5.5584p ps=15.52u w=4.36u l=0.4u
X464 A GATE B A sg13_hv_pmos ad=3.1392p pd=10.16u as=5.4312p ps=15.6u w=4.36u l=0.4u
X465 A GATE B A sg13_hv_pmos ad=5.5584p pd=15.52u as=5.4312p ps=15.6u w=4.36u l=0.4u
X466 A GATE B A sg13_hv_pmos ad=5.5584p pd=15.52u as=5.4312p ps=15.6u w=4.36u l=0.4u
X467 A GATE B A sg13_hv_pmos ad=5.5584p pd=15.52u as=5.4312p ps=15.6u w=4.36u l=0.4u
X468 A GATE B A sg13_hv_pmos ad=5.5584p pd=15.52u as=5.4312p ps=15.6u w=4.36u l=0.4u
X469 B GATE A A sg13_hv_pmos ad=5.4312p pd=15.6u as=5.5584p ps=15.52u w=4.36u l=0.4u
X470 B GATE A A sg13_hv_pmos ad=5.4312p pd=15.6u as=5.5584p ps=15.52u w=4.36u l=0.4u
X471 B GATE A A sg13_hv_pmos ad=5.4312p pd=15.6u as=5.5584p ps=15.52u w=4.36u l=0.4u
X472 B GATE A A sg13_hv_pmos ad=5.4312p pd=15.6u as=5.5584p ps=15.52u w=4.36u l=0.4u
X473 B GATE A A sg13_hv_pmos ad=5.4312p pd=15.6u as=5.5584p ps=15.52u w=4.36u l=0.4u
X474 A GATE B A sg13_hv_pmos ad=5.5584p pd=15.52u as=5.4312p ps=15.6u w=4.36u l=0.4u
X475 A GATE B A sg13_hv_pmos ad=5.5584p pd=15.52u as=5.4312p ps=15.6u w=4.36u l=0.4u
X476 B GATE A A sg13_hv_pmos ad=5.4312p pd=15.6u as=5.5584p ps=15.52u w=4.36u l=0.4u
X477 A GATE B A sg13_hv_pmos ad=5.5584p pd=15.52u as=5.4312p ps=15.6u w=4.36u l=0.4u
X478 B GATE A A sg13_hv_pmos ad=5.4312p pd=15.6u as=5.5584p ps=15.52u w=4.36u l=0.4u
X479 A GATE B A sg13_hv_pmos ad=5.5584p pd=15.52u as=5.4312p ps=15.6u w=4.36u l=0.4u
X480 A GATE B A sg13_hv_pmos ad=5.5584p pd=15.52u as=5.4312p ps=15.6u w=4.36u l=0.4u
X481 A GATE B A sg13_hv_pmos ad=5.5584p pd=15.52u as=5.4312p ps=15.6u w=4.36u l=0.4u
X482 B GATE A A sg13_hv_pmos ad=5.4312p pd=15.6u as=5.5584p ps=15.52u w=4.36u l=0.4u
X483 A GATE B A sg13_hv_pmos ad=5.5584p pd=15.52u as=5.4312p ps=15.6u w=4.36u l=0.4u
X484 B GATE A A sg13_hv_pmos ad=5.4312p pd=15.6u as=5.5584p ps=15.52u w=4.36u l=0.4u
X485 B GATE A A sg13_hv_pmos ad=5.4312p pd=15.6u as=5.5584p ps=15.52u w=4.36u l=0.4u
X486 A GATE B A sg13_hv_pmos ad=5.5584p pd=15.52u as=5.4312p ps=15.6u w=4.36u l=0.4u
X487 B GATE A A sg13_hv_pmos ad=5.4312p pd=15.6u as=5.5584p ps=15.52u w=4.36u l=0.4u
X488 A GATE B A sg13_hv_pmos ad=5.5584p pd=15.52u as=5.4312p ps=15.6u w=4.36u l=0.4u
X489 A GATE B A sg13_hv_pmos ad=5.5584p pd=15.52u as=5.4312p ps=15.6u w=4.36u l=0.4u
X490 A GATE B A sg13_hv_pmos ad=5.5584p pd=15.52u as=5.4312p ps=15.6u w=4.36u l=0.4u
X491 A GATE B A sg13_hv_pmos ad=5.5584p pd=15.52u as=5.4312p ps=15.6u w=4.36u l=0.4u
X492 B GATE A A sg13_hv_pmos ad=5.4312p pd=15.6u as=5.5584p ps=15.52u w=4.36u l=0.4u
X493 B GATE A A sg13_hv_pmos ad=3.052p pd=10.12u as=5.5584p ps=15.52u w=4.36u l=0.4u
X494 A GATE B A sg13_hv_pmos ad=5.5584p pd=15.52u as=5.4312p ps=15.6u w=4.36u l=0.4u
X495 B GATE A A sg13_hv_pmos ad=5.4312p pd=15.6u as=5.5584p ps=15.52u w=4.36u l=0.4u
X496 A GATE B A sg13_hv_pmos ad=5.5584p pd=15.52u as=5.4312p ps=15.6u w=4.36u l=0.4u
X497 B GATE A A sg13_hv_pmos ad=5.4312p pd=15.6u as=5.5584p ps=15.52u w=4.36u l=0.4u
X498 B GATE A A sg13_hv_pmos ad=5.4312p pd=15.6u as=5.5584p ps=15.52u w=4.36u l=0.4u
X499 A GATE B A sg13_hv_pmos ad=5.5584p pd=15.52u as=5.4312p ps=15.6u w=4.36u l=0.4u
X500 B GATE A A sg13_hv_pmos ad=5.4312p pd=15.6u as=5.5584p ps=15.52u w=4.36u l=0.4u
X501 A GATE B A sg13_hv_pmos ad=5.5584p pd=15.52u as=5.4312p ps=15.6u w=4.36u l=0.4u
X502 A GATE B A sg13_hv_pmos ad=5.5584p pd=15.52u as=5.4312p ps=15.6u w=4.36u l=0.4u
X503 B GATE A A sg13_hv_pmos ad=5.4312p pd=15.6u as=5.5584p ps=15.52u w=4.36u l=0.4u
X504 A GATE B A sg13_hv_pmos ad=5.5584p pd=15.52u as=5.4312p ps=15.6u w=4.36u l=0.4u
X505 A GATE B A sg13_hv_pmos ad=5.5584p pd=15.52u as=5.4312p ps=15.6u w=4.36u l=0.4u
X506 A GATE B A sg13_hv_pmos ad=5.5584p pd=15.52u as=5.4312p ps=15.6u w=4.36u l=0.4u
X507 B GATE A A sg13_hv_pmos ad=5.4312p pd=15.6u as=5.5584p ps=15.52u w=4.36u l=0.4u
X508 B GATE A A sg13_hv_pmos ad=5.4312p pd=15.6u as=5.5584p ps=15.52u w=4.36u l=0.4u
X509 B GATE A A sg13_hv_pmos ad=5.4312p pd=15.6u as=5.5584p ps=15.52u w=4.36u l=0.4u
X510 B GATE A A sg13_hv_pmos ad=5.4312p pd=15.6u as=5.5584p ps=15.52u w=4.36u l=0.4u
X511 A GATE B A sg13_hv_pmos ad=5.5584p pd=15.52u as=5.4312p ps=15.6u w=4.36u l=0.4u
X512 B GATE A A sg13_hv_pmos ad=5.4312p pd=15.6u as=5.5584p ps=15.52u w=4.36u l=0.4u
X513 A GATE B A sg13_hv_pmos ad=5.5584p pd=15.52u as=5.4312p ps=15.6u w=4.36u l=0.4u
X514 B GATE A A sg13_hv_pmos ad=5.4312p pd=15.6u as=5.5584p ps=15.52u w=4.36u l=0.4u
X515 A GATE B A sg13_hv_pmos ad=5.5584p pd=15.52u as=5.4312p ps=15.6u w=4.36u l=0.4u
X516 B GATE A A sg13_hv_pmos ad=5.4312p pd=15.6u as=5.5584p ps=15.52u w=4.36u l=0.4u
X517 A GATE B A sg13_hv_pmos ad=5.5584p pd=15.52u as=5.4312p ps=15.6u w=4.36u l=0.4u
X518 B GATE A A sg13_hv_pmos ad=5.4312p pd=15.6u as=5.5584p ps=15.52u w=4.36u l=0.4u
X519 A GATE B A sg13_hv_pmos ad=5.5584p pd=15.52u as=5.4312p ps=15.6u w=4.36u l=0.4u
X520 B GATE A A sg13_hv_pmos ad=5.4312p pd=15.6u as=5.5584p ps=15.52u w=4.36u l=0.4u
X521 B GATE A A sg13_hv_pmos ad=5.4312p pd=15.6u as=5.5584p ps=15.52u w=4.36u l=0.4u
X522 B GATE A A sg13_hv_pmos ad=5.4312p pd=15.6u as=5.5584p ps=15.52u w=4.36u l=0.4u
X523 A GATE B A sg13_hv_pmos ad=5.5584p pd=15.52u as=5.4312p ps=15.6u w=4.36u l=0.4u
X524 A GATE B A sg13_hv_pmos ad=3.1392p pd=10.16u as=5.4312p ps=15.6u w=4.36u l=0.4u
X525 B GATE A A sg13_hv_pmos ad=5.4312p pd=15.6u as=5.5584p ps=15.52u w=4.36u l=0.4u
X526 A GATE B A sg13_hv_pmos ad=5.5584p pd=15.52u as=5.4312p ps=15.6u w=4.36u l=0.4u
X527 B GATE A A sg13_hv_pmos ad=5.4312p pd=15.6u as=5.5584p ps=15.52u w=4.36u l=0.4u
X528 A GATE B A sg13_hv_pmos ad=5.5584p pd=15.52u as=5.4312p ps=15.6u w=4.36u l=0.4u
X529 A GATE B A sg13_hv_pmos ad=5.5584p pd=15.52u as=5.4312p ps=15.6u w=4.36u l=0.4u
X530 A GATE B A sg13_hv_pmos ad=5.5584p pd=15.52u as=5.4312p ps=15.6u w=4.36u l=0.4u
X531 A GATE B A sg13_hv_pmos ad=5.5584p pd=15.52u as=5.4312p ps=15.6u w=4.36u l=0.4u
X532 B GATE A A sg13_hv_pmos ad=5.4312p pd=15.6u as=5.5584p ps=15.52u w=4.36u l=0.4u
X533 A GATE B A sg13_hv_pmos ad=5.5584p pd=15.52u as=5.4312p ps=15.6u w=4.36u l=0.4u
X534 B GATE A A sg13_hv_pmos ad=5.4312p pd=15.6u as=5.5584p ps=15.52u w=4.36u l=0.4u
X535 A GATE B A sg13_hv_pmos ad=5.5584p pd=15.52u as=5.4312p ps=15.6u w=4.36u l=0.4u
X536 A GATE B A sg13_hv_pmos ad=5.5584p pd=15.52u as=5.4312p ps=15.6u w=4.36u l=0.4u
X537 B GATE A A sg13_hv_pmos ad=5.4312p pd=15.6u as=5.5584p ps=15.52u w=4.36u l=0.4u
X538 A GATE B A sg13_hv_pmos ad=5.5584p pd=15.52u as=5.4312p ps=15.6u w=4.36u l=0.4u
X539 B GATE A A sg13_hv_pmos ad=5.4312p pd=15.6u as=5.5584p ps=15.52u w=4.36u l=0.4u
X540 A GATE B A sg13_hv_pmos ad=5.5584p pd=15.52u as=5.4312p ps=15.6u w=4.36u l=0.4u
X541 B GATE A A sg13_hv_pmos ad=5.4312p pd=15.6u as=5.5584p ps=15.52u w=4.36u l=0.4u
X542 A GATE B A sg13_hv_pmos ad=5.5584p pd=15.52u as=5.4312p ps=15.6u w=4.36u l=0.4u
X543 A GATE B A sg13_hv_pmos ad=5.5584p pd=15.52u as=5.4312p ps=15.6u w=4.36u l=0.4u
X544 B GATE A A sg13_hv_pmos ad=5.4312p pd=15.6u as=5.5584p ps=15.52u w=4.36u l=0.4u
X545 A GATE B A sg13_hv_pmos ad=5.5584p pd=15.52u as=5.4312p ps=15.6u w=4.36u l=0.4u
X546 B GATE A A sg13_hv_pmos ad=5.4312p pd=15.6u as=5.5584p ps=15.52u w=4.36u l=0.4u
X547 B GATE A A sg13_hv_pmos ad=5.4312p pd=15.6u as=5.5584p ps=15.52u w=4.36u l=0.4u
X548 A GATE B A sg13_hv_pmos ad=5.5584p pd=15.52u as=5.4312p ps=15.6u w=4.36u l=0.4u
X549 B GATE A A sg13_hv_pmos ad=5.4312p pd=15.6u as=5.5584p ps=15.52u w=4.36u l=0.4u
X550 B GATE A A sg13_hv_pmos ad=5.4312p pd=15.6u as=5.5584p ps=15.52u w=4.36u l=0.4u
X551 A GATE B A sg13_hv_pmos ad=5.5584p pd=15.52u as=5.4312p ps=15.6u w=4.36u l=0.4u
X552 A GATE B A sg13_hv_pmos ad=5.5584p pd=15.52u as=5.4312p ps=15.6u w=4.36u l=0.4u
X553 A GATE B A sg13_hv_pmos ad=5.5584p pd=15.52u as=5.4312p ps=15.6u w=4.36u l=0.4u
X554 A GATE B A sg13_hv_pmos ad=5.5584p pd=15.52u as=5.4312p ps=15.6u w=4.36u l=0.4u
X555 A GATE B A sg13_hv_pmos ad=5.5584p pd=15.52u as=5.4312p ps=15.6u w=4.36u l=0.4u
X556 B GATE A A sg13_hv_pmos ad=5.4312p pd=15.6u as=5.5584p ps=15.52u w=4.36u l=0.4u
X557 B GATE A A sg13_hv_pmos ad=3.052p pd=10.12u as=5.5584p ps=15.52u w=4.36u l=0.4u
X558 A GATE B A sg13_hv_pmos ad=5.5584p pd=15.52u as=5.4312p ps=15.6u w=4.36u l=0.4u
X559 B GATE A A sg13_hv_pmos ad=5.4312p pd=15.6u as=5.5584p ps=15.52u w=4.36u l=0.4u
X560 A GATE B A sg13_hv_pmos ad=5.5584p pd=15.52u as=5.4312p ps=15.6u w=4.36u l=0.4u
X561 B GATE A A sg13_hv_pmos ad=5.4312p pd=15.6u as=5.5584p ps=15.52u w=4.36u l=0.4u
X562 B GATE A A sg13_hv_pmos ad=5.4312p pd=15.6u as=5.5584p ps=15.52u w=4.36u l=0.4u
X563 A GATE B A sg13_hv_pmos ad=5.5584p pd=15.52u as=5.4312p ps=15.6u w=4.36u l=0.4u
X564 B GATE A A sg13_hv_pmos ad=5.4312p pd=15.6u as=5.5584p ps=15.52u w=4.36u l=0.4u
X565 A GATE B A sg13_hv_pmos ad=5.5584p pd=15.52u as=5.4312p ps=15.6u w=4.36u l=0.4u
X566 B GATE A A sg13_hv_pmos ad=5.4312p pd=15.6u as=5.5584p ps=15.52u w=4.36u l=0.4u
X567 B GATE A A sg13_hv_pmos ad=5.4312p pd=15.6u as=5.5584p ps=15.52u w=4.36u l=0.4u
X568 A GATE B A sg13_hv_pmos ad=5.5584p pd=15.52u as=5.4312p ps=15.6u w=4.36u l=0.4u
X569 B GATE A A sg13_hv_pmos ad=5.4312p pd=15.6u as=5.5584p ps=15.52u w=4.36u l=0.4u
X570 A GATE B A sg13_hv_pmos ad=5.5584p pd=15.52u as=5.4312p ps=15.6u w=4.36u l=0.4u
X571 B GATE A A sg13_hv_pmos ad=5.4312p pd=15.6u as=5.5584p ps=15.52u w=4.36u l=0.4u
X572 A GATE B A sg13_hv_pmos ad=5.5584p pd=15.52u as=5.4312p ps=15.6u w=4.36u l=0.4u
X573 B GATE A A sg13_hv_pmos ad=5.4312p pd=15.6u as=5.5584p ps=15.52u w=4.36u l=0.4u
X574 B GATE A A sg13_hv_pmos ad=5.4312p pd=15.6u as=5.5584p ps=15.52u w=4.36u l=0.4u
X575 B GATE A A sg13_hv_pmos ad=5.4312p pd=15.6u as=5.5584p ps=15.52u w=4.36u l=0.4u
X576 A GATE B A sg13_hv_pmos ad=5.5584p pd=15.52u as=5.4312p ps=15.6u w=4.36u l=0.4u
X577 B GATE A A sg13_hv_pmos ad=5.4312p pd=15.6u as=5.5584p ps=15.52u w=4.36u l=0.4u
X578 A GATE B A sg13_hv_pmos ad=5.5584p pd=15.52u as=5.4312p ps=15.6u w=4.36u l=0.4u
X579 B GATE A A sg13_hv_pmos ad=5.4312p pd=15.6u as=5.5584p ps=15.52u w=4.36u l=0.4u
X580 A GATE B A sg13_hv_pmos ad=5.5584p pd=15.52u as=5.4312p ps=15.6u w=4.36u l=0.4u
X581 B GATE A A sg13_hv_pmos ad=5.4312p pd=15.6u as=5.5584p ps=15.52u w=4.36u l=0.4u
X582 A GATE B A sg13_hv_pmos ad=5.5584p pd=15.52u as=5.4312p ps=15.6u w=4.36u l=0.4u
X583 A GATE B A sg13_hv_pmos ad=5.5584p pd=15.52u as=5.4312p ps=15.6u w=4.36u l=0.4u
X584 B GATE A A sg13_hv_pmos ad=5.4312p pd=15.6u as=5.5584p ps=15.52u w=4.36u l=0.4u
X585 B GATE A A sg13_hv_pmos ad=5.4312p pd=15.6u as=3.1392p ps=10.16u w=4.36u l=0.4u
X586 A GATE B A sg13_hv_pmos ad=5.5584p pd=15.52u as=5.4312p ps=15.6u w=4.36u l=0.4u
X587 B GATE A A sg13_hv_pmos ad=5.4312p pd=15.6u as=5.5584p ps=15.52u w=4.36u l=0.4u
X588 B GATE A A sg13_hv_pmos ad=5.4312p pd=15.6u as=5.5584p ps=15.52u w=4.36u l=0.4u
X589 A GATE B A sg13_hv_pmos ad=3.1392p pd=10.16u as=5.4312p ps=15.6u w=4.36u l=0.4u
X590 B GATE A A sg13_hv_pmos ad=5.4312p pd=15.6u as=5.5584p ps=15.52u w=4.36u l=0.4u
X591 A GATE B A sg13_hv_pmos ad=5.5584p pd=15.52u as=5.4312p ps=15.6u w=4.36u l=0.4u
X592 A GATE B A sg13_hv_pmos ad=5.5584p pd=15.52u as=5.4312p ps=15.6u w=4.36u l=0.4u
X593 B GATE A A sg13_hv_pmos ad=5.4312p pd=15.6u as=5.5584p ps=15.52u w=4.36u l=0.4u
X594 A GATE B A sg13_hv_pmos ad=5.5584p pd=15.52u as=5.4312p ps=15.6u w=4.36u l=0.4u
X595 B GATE A A sg13_hv_pmos ad=5.4312p pd=15.6u as=5.5584p ps=15.52u w=4.36u l=0.4u
X596 A GATE B A sg13_hv_pmos ad=5.5584p pd=15.52u as=5.4312p ps=15.6u w=4.36u l=0.4u
X597 A GATE B A sg13_hv_pmos ad=5.5584p pd=15.52u as=5.4312p ps=15.6u w=4.36u l=0.4u
X598 B GATE A A sg13_hv_pmos ad=5.4312p pd=15.6u as=5.5584p ps=15.52u w=4.36u l=0.4u
X599 A GATE B A sg13_hv_pmos ad=5.5584p pd=15.52u as=5.4312p ps=15.6u w=4.36u l=0.4u
X600 B GATE A A sg13_hv_pmos ad=5.4312p pd=15.6u as=5.5584p ps=15.52u w=4.36u l=0.4u
X601 A GATE B A sg13_hv_pmos ad=5.5584p pd=15.52u as=5.4312p ps=15.6u w=4.36u l=0.4u
X602 B GATE A A sg13_hv_pmos ad=5.4312p pd=15.6u as=5.5584p ps=15.52u w=4.36u l=0.4u
X603 A GATE B A sg13_hv_pmos ad=5.5584p pd=15.52u as=5.4312p ps=15.6u w=4.36u l=0.4u
X604 A GATE B A sg13_hv_pmos ad=5.5584p pd=15.52u as=5.4312p ps=15.6u w=4.36u l=0.4u
X605 A GATE B A sg13_hv_pmos ad=5.5584p pd=15.52u as=5.4312p ps=15.6u w=4.36u l=0.4u
X606 B GATE A A sg13_hv_pmos ad=5.4312p pd=15.6u as=3.1392p ps=10.16u w=4.36u l=0.4u
X607 B GATE A A sg13_hv_pmos ad=5.4312p pd=15.6u as=5.5584p ps=15.52u w=4.36u l=0.4u
X608 A GATE B A sg13_hv_pmos ad=5.5584p pd=15.52u as=5.4312p ps=15.6u w=4.36u l=0.4u
X609 B GATE A A sg13_hv_pmos ad=5.4312p pd=15.6u as=5.5584p ps=15.52u w=4.36u l=0.4u
X610 B GATE A A sg13_hv_pmos ad=5.4312p pd=15.6u as=3.1392p ps=10.16u w=4.36u l=0.4u
X611 B GATE A A sg13_hv_pmos ad=5.4312p pd=15.6u as=3.1392p ps=10.16u w=4.36u l=0.4u
X612 A GATE B A sg13_hv_pmos ad=5.5584p pd=15.52u as=5.4312p ps=15.6u w=4.36u l=0.4u
X613 B GATE A A sg13_hv_pmos ad=5.4312p pd=15.6u as=5.5584p ps=15.52u w=4.36u l=0.4u
X614 A GATE B A sg13_hv_pmos ad=5.5584p pd=15.52u as=5.4312p ps=15.6u w=4.36u l=0.4u
X615 B GATE A A sg13_hv_pmos ad=5.4312p pd=15.6u as=5.5584p ps=15.52u w=4.36u l=0.4u
X616 B GATE A A sg13_hv_pmos ad=5.4312p pd=15.6u as=5.5584p ps=15.52u w=4.36u l=0.4u
X617 A GATE B A sg13_hv_pmos ad=5.5584p pd=15.52u as=5.4312p ps=15.6u w=4.36u l=0.4u
X618 B GATE A A sg13_hv_pmos ad=5.4312p pd=15.6u as=5.5584p ps=15.52u w=4.36u l=0.4u
X619 A GATE B A sg13_hv_pmos ad=5.5584p pd=15.52u as=5.4312p ps=15.6u w=4.36u l=0.4u
X620 A GATE B A sg13_hv_pmos ad=5.5584p pd=15.52u as=5.4312p ps=15.6u w=4.36u l=0.4u
X621 A GATE B A sg13_hv_pmos ad=5.5584p pd=15.52u as=5.4312p ps=15.6u w=4.36u l=0.4u
X622 B GATE A A sg13_hv_pmos ad=5.4312p pd=15.6u as=5.5584p ps=15.52u w=4.36u l=0.4u
X623 B GATE A A sg13_hv_pmos ad=5.4312p pd=15.6u as=5.5584p ps=15.52u w=4.36u l=0.4u
X624 A GATE B A sg13_hv_pmos ad=5.5584p pd=15.52u as=5.4312p ps=15.6u w=4.36u l=0.4u
X625 B GATE A A sg13_hv_pmos ad=5.4312p pd=15.6u as=5.5584p ps=15.52u w=4.36u l=0.4u
X626 B GATE A A sg13_hv_pmos ad=5.4312p pd=15.6u as=5.5584p ps=15.52u w=4.36u l=0.4u
X627 A GATE B A sg13_hv_pmos ad=5.5584p pd=15.52u as=5.4312p ps=15.6u w=4.36u l=0.4u
X628 B GATE A A sg13_hv_pmos ad=5.4312p pd=15.6u as=5.5584p ps=15.52u w=4.36u l=0.4u
X629 A GATE B A sg13_hv_pmos ad=5.5584p pd=15.52u as=5.4312p ps=15.6u w=4.36u l=0.4u
X630 A GATE B A sg13_hv_pmos ad=5.5584p pd=15.52u as=5.4312p ps=15.6u w=4.36u l=0.4u
X631 B GATE A A sg13_hv_pmos ad=5.4312p pd=15.6u as=5.5584p ps=15.52u w=4.36u l=0.4u
X632 B GATE A A sg13_hv_pmos ad=5.4312p pd=15.6u as=5.5584p ps=15.52u w=4.36u l=0.4u
X633 B GATE A A sg13_hv_pmos ad=5.4312p pd=15.6u as=5.5584p ps=15.52u w=4.36u l=0.4u
X634 B GATE A A sg13_hv_pmos ad=5.4312p pd=15.6u as=3.1392p ps=10.16u w=4.36u l=0.4u
X635 A GATE B A sg13_hv_pmos ad=5.5584p pd=15.52u as=5.4312p ps=15.6u w=4.36u l=0.4u
X636 B GATE A A sg13_hv_pmos ad=5.4312p pd=15.6u as=5.5584p ps=15.52u w=4.36u l=0.4u
X637 A GATE B A sg13_hv_pmos ad=5.5584p pd=15.52u as=3.052p ps=10.12u w=4.36u l=0.4u
X638 B GATE A A sg13_hv_pmos ad=5.4312p pd=15.6u as=5.5584p ps=15.52u w=4.36u l=0.4u
X639 B GATE A A sg13_hv_pmos ad=5.4312p pd=15.6u as=5.5584p ps=15.52u w=4.36u l=0.4u
X640 A GATE B A sg13_hv_pmos ad=5.5584p pd=15.52u as=5.4312p ps=15.6u w=4.36u l=0.4u
X641 B GATE A A sg13_hv_pmos ad=5.4312p pd=15.6u as=5.5584p ps=15.52u w=4.36u l=0.4u
X642 A GATE B A sg13_hv_pmos ad=5.5584p pd=15.52u as=5.4312p ps=15.6u w=4.36u l=0.4u
X643 A GATE B A sg13_hv_pmos ad=5.5584p pd=15.52u as=5.4312p ps=15.6u w=4.36u l=0.4u
X644 A GATE B A sg13_hv_pmos ad=5.5584p pd=15.52u as=5.4312p ps=15.6u w=4.36u l=0.4u
X645 B GATE A A sg13_hv_pmos ad=5.4312p pd=15.6u as=5.5584p ps=15.52u w=4.36u l=0.4u
X646 B GATE A A sg13_hv_pmos ad=5.4312p pd=15.6u as=5.5584p ps=15.52u w=4.36u l=0.4u
X647 A GATE B A sg13_hv_pmos ad=5.5584p pd=15.52u as=5.4312p ps=15.6u w=4.36u l=0.4u
X648 B GATE A A sg13_hv_pmos ad=5.4312p pd=15.6u as=5.5584p ps=15.52u w=4.36u l=0.4u
X649 A GATE B A sg13_hv_pmos ad=5.5584p pd=15.52u as=5.4312p ps=15.6u w=4.36u l=0.4u
X650 B GATE A A sg13_hv_pmos ad=5.4312p pd=15.6u as=5.5584p ps=15.52u w=4.36u l=0.4u
X651 A GATE B A sg13_hv_pmos ad=5.5584p pd=15.52u as=5.4312p ps=15.6u w=4.36u l=0.4u
X652 A GATE B A sg13_hv_pmos ad=5.5584p pd=15.52u as=5.4312p ps=15.6u w=4.36u l=0.4u
X653 A GATE B A sg13_hv_pmos ad=5.5584p pd=15.52u as=5.4312p ps=15.6u w=4.36u l=0.4u
X654 A GATE B A sg13_hv_pmos ad=5.5584p pd=15.52u as=5.4312p ps=15.6u w=4.36u l=0.4u
X655 A GATE B A sg13_hv_pmos ad=5.5584p pd=15.52u as=5.4312p ps=15.6u w=4.36u l=0.4u
X656 B GATE A A sg13_hv_pmos ad=5.4312p pd=15.6u as=5.5584p ps=15.52u w=4.36u l=0.4u
X657 B GATE A A sg13_hv_pmos ad=5.4312p pd=15.6u as=3.1392p ps=10.16u w=4.36u l=0.4u
X658 B GATE A A sg13_hv_pmos ad=5.4312p pd=15.6u as=5.5584p ps=15.52u w=4.36u l=0.4u
X659 B GATE A A sg13_hv_pmos ad=5.4312p pd=15.6u as=5.5584p ps=15.52u w=4.36u l=0.4u
X660 A GATE B A sg13_hv_pmos ad=5.5584p pd=15.52u as=5.4312p ps=15.6u w=4.36u l=0.4u
X661 B GATE A A sg13_hv_pmos ad=5.4312p pd=15.6u as=5.5584p ps=15.52u w=4.36u l=0.4u
X662 A GATE B A sg13_hv_pmos ad=5.5584p pd=15.52u as=5.4312p ps=15.6u w=4.36u l=0.4u
X663 B GATE A A sg13_hv_pmos ad=5.4312p pd=15.6u as=3.1392p ps=10.16u w=4.36u l=0.4u
X664 A GATE B A sg13_hv_pmos ad=5.5584p pd=15.52u as=5.4312p ps=15.6u w=4.36u l=0.4u
X665 A GATE B A sg13_hv_pmos ad=5.5584p pd=15.52u as=5.4312p ps=15.6u w=4.36u l=0.4u
X666 A GATE B A sg13_hv_pmos ad=5.5584p pd=15.52u as=5.4312p ps=15.6u w=4.36u l=0.4u
X667 B GATE A A sg13_hv_pmos ad=5.4312p pd=15.6u as=5.5584p ps=15.52u w=4.36u l=0.4u
X668 A GATE B A sg13_hv_pmos ad=5.5584p pd=15.52u as=5.4312p ps=15.6u w=4.36u l=0.4u
X669 B GATE A A sg13_hv_pmos ad=5.4312p pd=15.6u as=5.5584p ps=15.52u w=4.36u l=0.4u
X670 B GATE A A sg13_hv_pmos ad=5.4312p pd=15.6u as=5.5584p ps=15.52u w=4.36u l=0.4u
X671 B GATE A A sg13_hv_pmos ad=5.4312p pd=15.6u as=5.5584p ps=15.52u w=4.36u l=0.4u
X672 A GATE B A sg13_hv_pmos ad=5.5584p pd=15.52u as=5.4312p ps=15.6u w=4.36u l=0.4u
X673 B GATE A A sg13_hv_pmos ad=5.4312p pd=15.6u as=5.5584p ps=15.52u w=4.36u l=0.4u
X674 A GATE B A sg13_hv_pmos ad=5.5584p pd=15.52u as=5.4312p ps=15.6u w=4.36u l=0.4u
X675 A GATE B A sg13_hv_pmos ad=5.5584p pd=15.52u as=5.4312p ps=15.6u w=4.36u l=0.4u
X676 B GATE A A sg13_hv_pmos ad=5.4312p pd=15.6u as=5.5584p ps=15.52u w=4.36u l=0.4u
X677 B GATE A A sg13_hv_pmos ad=5.4312p pd=15.6u as=5.5584p ps=15.52u w=4.36u l=0.4u
X678 B GATE A A sg13_hv_pmos ad=5.4312p pd=15.6u as=5.5584p ps=15.52u w=4.36u l=0.4u
X679 B GATE A A sg13_hv_pmos ad=5.4312p pd=15.6u as=5.5584p ps=15.52u w=4.36u l=0.4u
X680 B GATE A A sg13_hv_pmos ad=5.4312p pd=15.6u as=5.5584p ps=15.52u w=4.36u l=0.4u
X681 A GATE B A sg13_hv_pmos ad=5.5584p pd=15.52u as=5.4312p ps=15.6u w=4.36u l=0.4u
X682 A GATE B A sg13_hv_pmos ad=5.5584p pd=15.52u as=5.4312p ps=15.6u w=4.36u l=0.4u
X683 B GATE A A sg13_hv_pmos ad=3.052p pd=10.12u as=5.5584p ps=15.52u w=4.36u l=0.4u
X684 A GATE B A sg13_hv_pmos ad=5.5584p pd=15.52u as=5.4312p ps=15.6u w=4.36u l=0.4u
X685 B GATE A A sg13_hv_pmos ad=5.4312p pd=15.6u as=5.5584p ps=15.52u w=4.36u l=0.4u
X686 A GATE B A sg13_hv_pmos ad=5.5584p pd=15.52u as=5.4312p ps=15.6u w=4.36u l=0.4u
X687 A GATE B A sg13_hv_pmos ad=5.5584p pd=15.52u as=3.052p ps=10.12u w=4.36u l=0.4u
X688 B GATE A A sg13_hv_pmos ad=5.4312p pd=15.6u as=5.5584p ps=15.52u w=4.36u l=0.4u
X689 B GATE A A sg13_hv_pmos ad=5.4312p pd=15.6u as=5.5584p ps=15.52u w=4.36u l=0.4u
X690 B GATE A A sg13_hv_pmos ad=5.4312p pd=15.6u as=5.5584p ps=15.52u w=4.36u l=0.4u
X691 B GATE A A sg13_hv_pmos ad=5.4312p pd=15.6u as=5.5584p ps=15.52u w=4.36u l=0.4u
X692 A GATE B A sg13_hv_pmos ad=5.5584p pd=15.52u as=5.4312p ps=15.6u w=4.36u l=0.4u
X693 A GATE B A sg13_hv_pmos ad=5.5584p pd=15.52u as=5.4312p ps=15.6u w=4.36u l=0.4u
X694 A GATE B A sg13_hv_pmos ad=5.5584p pd=15.52u as=5.4312p ps=15.6u w=4.36u l=0.4u
X695 B GATE A A sg13_hv_pmos ad=5.4312p pd=15.6u as=5.5584p ps=15.52u w=4.36u l=0.4u
X696 A GATE B A sg13_hv_pmos ad=5.5584p pd=15.52u as=5.4312p ps=15.6u w=4.36u l=0.4u
X697 B GATE A A sg13_hv_pmos ad=5.4312p pd=15.6u as=5.5584p ps=15.52u w=4.36u l=0.4u
X698 B GATE A A sg13_hv_pmos ad=5.4312p pd=15.6u as=5.5584p ps=15.52u w=4.36u l=0.4u
X699 B GATE A A sg13_hv_pmos ad=5.4312p pd=15.6u as=5.5584p ps=15.52u w=4.36u l=0.4u
X700 B GATE A A sg13_hv_pmos ad=5.4312p pd=15.6u as=3.1392p ps=10.16u w=4.36u l=0.4u
X701 A GATE B A sg13_hv_pmos ad=5.5584p pd=15.52u as=5.4312p ps=15.6u w=4.36u l=0.4u
X702 A GATE B A sg13_hv_pmos ad=5.5584p pd=15.52u as=5.4312p ps=15.6u w=4.36u l=0.4u
X703 A GATE B A sg13_hv_pmos ad=5.5584p pd=15.52u as=5.4312p ps=15.6u w=4.36u l=0.4u
X704 A GATE B A sg13_hv_pmos ad=5.5584p pd=15.52u as=5.4312p ps=15.6u w=4.36u l=0.4u
X705 B GATE A A sg13_hv_pmos ad=5.4312p pd=15.6u as=5.5584p ps=15.52u w=4.36u l=0.4u
X706 A GATE B A sg13_hv_pmos ad=3.1392p pd=10.16u as=5.4312p ps=15.6u w=4.36u l=0.4u
X707 B GATE A A sg13_hv_pmos ad=5.4312p pd=15.6u as=5.5584p ps=15.52u w=4.36u l=0.4u
X708 B GATE A A sg13_hv_pmos ad=5.4312p pd=15.6u as=5.5584p ps=15.52u w=4.36u l=0.4u
X709 A GATE B A sg13_hv_pmos ad=5.5584p pd=15.52u as=5.4312p ps=15.6u w=4.36u l=0.4u
X710 A GATE B A sg13_hv_pmos ad=5.5584p pd=15.52u as=5.4312p ps=15.6u w=4.36u l=0.4u
X711 A GATE B A sg13_hv_pmos ad=5.5584p pd=15.52u as=5.4312p ps=15.6u w=4.36u l=0.4u
X712 B GATE A A sg13_hv_pmos ad=5.4312p pd=15.6u as=3.1392p ps=10.16u w=4.36u l=0.4u
X713 A GATE B A sg13_hv_pmos ad=5.5584p pd=15.52u as=5.4312p ps=15.6u w=4.36u l=0.4u
X714 B GATE A A sg13_hv_pmos ad=5.4312p pd=15.6u as=5.5584p ps=15.52u w=4.36u l=0.4u
X715 B GATE A A sg13_hv_pmos ad=5.4312p pd=15.6u as=5.5584p ps=15.52u w=4.36u l=0.4u
X716 B GATE A A sg13_hv_pmos ad=5.4312p pd=15.6u as=5.5584p ps=15.52u w=4.36u l=0.4u
X717 B GATE A A sg13_hv_pmos ad=5.4312p pd=15.6u as=5.5584p ps=15.52u w=4.36u l=0.4u
X718 A GATE B A sg13_hv_pmos ad=5.5584p pd=15.52u as=5.4312p ps=15.6u w=4.36u l=0.4u
X719 B GATE A A sg13_hv_pmos ad=5.4312p pd=15.6u as=5.5584p ps=15.52u w=4.36u l=0.4u
X720 A GATE B A sg13_hv_pmos ad=5.5584p pd=15.52u as=5.4312p ps=15.6u w=4.36u l=0.4u
X721 A GATE B A sg13_hv_pmos ad=5.5584p pd=15.52u as=5.4312p ps=15.6u w=4.36u l=0.4u
X722 B GATE A A sg13_hv_pmos ad=5.4312p pd=15.6u as=5.5584p ps=15.52u w=4.36u l=0.4u
X723 B GATE A A sg13_hv_pmos ad=5.4312p pd=15.6u as=5.5584p ps=15.52u w=4.36u l=0.4u
X724 B GATE A A sg13_hv_pmos ad=5.4312p pd=15.6u as=5.5584p ps=15.52u w=4.36u l=0.4u
X725 B GATE A A sg13_hv_pmos ad=5.4312p pd=15.6u as=5.5584p ps=15.52u w=4.36u l=0.4u
X726 A GATE B A sg13_hv_pmos ad=5.5584p pd=15.52u as=5.4312p ps=15.6u w=4.36u l=0.4u
X727 B GATE A A sg13_hv_pmos ad=3.052p pd=10.12u as=5.5584p ps=15.52u w=4.36u l=0.4u
X728 A GATE B A sg13_hv_pmos ad=5.5584p pd=15.52u as=5.4312p ps=15.6u w=4.36u l=0.4u
X729 B GATE A A sg13_hv_pmos ad=5.4312p pd=15.6u as=5.5584p ps=15.52u w=4.36u l=0.4u
X730 B GATE A A sg13_hv_pmos ad=5.4312p pd=15.6u as=5.5584p ps=15.52u w=4.36u l=0.4u
X731 A GATE B A sg13_hv_pmos ad=5.5584p pd=15.52u as=3.052p ps=10.12u w=4.36u l=0.4u
X732 B GATE A A sg13_hv_pmos ad=5.4312p pd=15.6u as=5.5584p ps=15.52u w=4.36u l=0.4u
X733 B GATE A A sg13_hv_pmos ad=5.4312p pd=15.6u as=5.5584p ps=15.52u w=4.36u l=0.4u
X734 A GATE B A sg13_hv_pmos ad=5.5584p pd=15.52u as=5.4312p ps=15.6u w=4.36u l=0.4u
X735 A GATE B A sg13_hv_pmos ad=5.5584p pd=15.52u as=5.4312p ps=15.6u w=4.36u l=0.4u
X736 A GATE B A sg13_hv_pmos ad=5.5584p pd=15.52u as=5.4312p ps=15.6u w=4.36u l=0.4u
X737 B GATE A A sg13_hv_pmos ad=5.4312p pd=15.6u as=5.5584p ps=15.52u w=4.36u l=0.4u
X738 A GATE B A sg13_hv_pmos ad=5.5584p pd=15.52u as=5.4312p ps=15.6u w=4.36u l=0.4u
X739 B GATE A A sg13_hv_pmos ad=5.4312p pd=15.6u as=5.5584p ps=15.52u w=4.36u l=0.4u
X740 A GATE B A sg13_hv_pmos ad=5.5584p pd=15.52u as=5.4312p ps=15.6u w=4.36u l=0.4u
X741 A GATE B A sg13_hv_pmos ad=5.5584p pd=15.52u as=5.4312p ps=15.6u w=4.36u l=0.4u
X742 A GATE B A sg13_hv_pmos ad=3.1392p pd=10.16u as=5.4312p ps=15.6u w=4.36u l=0.4u
X743 B GATE A A sg13_hv_pmos ad=5.4312p pd=15.6u as=5.5584p ps=15.52u w=4.36u l=0.4u
X744 A GATE B A sg13_hv_pmos ad=5.5584p pd=15.52u as=5.4312p ps=15.6u w=4.36u l=0.4u
X745 B GATE A A sg13_hv_pmos ad=5.4312p pd=15.6u as=5.5584p ps=15.52u w=4.36u l=0.4u
X746 B GATE A A sg13_hv_pmos ad=5.4312p pd=15.6u as=3.1392p ps=10.16u w=4.36u l=0.4u
X747 A GATE B A sg13_hv_pmos ad=5.5584p pd=15.52u as=5.4312p ps=15.6u w=4.36u l=0.4u
X748 B GATE A A sg13_hv_pmos ad=5.4312p pd=15.6u as=5.5584p ps=15.52u w=4.36u l=0.4u
X749 A GATE B A sg13_hv_pmos ad=5.5584p pd=15.52u as=3.052p ps=10.12u w=4.36u l=0.4u
X750 B GATE A A sg13_hv_pmos ad=5.4312p pd=15.6u as=5.5584p ps=15.52u w=4.36u l=0.4u
X751 A GATE B A sg13_hv_pmos ad=5.5584p pd=15.52u as=5.4312p ps=15.6u w=4.36u l=0.4u
X752 B GATE A A sg13_hv_pmos ad=5.4312p pd=15.6u as=5.5584p ps=15.52u w=4.36u l=0.4u
X753 B GATE A A sg13_hv_pmos ad=5.4312p pd=15.6u as=5.5584p ps=15.52u w=4.36u l=0.4u
X754 A GATE B A sg13_hv_pmos ad=5.5584p pd=15.52u as=5.4312p ps=15.6u w=4.36u l=0.4u
X755 A GATE B A sg13_hv_pmos ad=5.5584p pd=15.52u as=5.4312p ps=15.6u w=4.36u l=0.4u
X756 A GATE B A sg13_hv_pmos ad=5.5584p pd=15.52u as=5.4312p ps=15.6u w=4.36u l=0.4u
X757 B GATE A A sg13_hv_pmos ad=3.052p pd=10.12u as=5.5584p ps=15.52u w=4.36u l=0.4u
X758 B GATE A A sg13_hv_pmos ad=5.4312p pd=15.6u as=5.5584p ps=15.52u w=4.36u l=0.4u
X759 B GATE A A sg13_hv_pmos ad=5.4312p pd=15.6u as=5.5584p ps=15.52u w=4.36u l=0.4u
.ends

.subckt sg13cmos5l_inv_4 Y A VDD VSS
X0 Y A VSS VSS sg13_lv_nmos ad=0.1406p pd=1.12u as=0.2516p ps=2.16u w=0.74u l=0.13u
X1 Y A VDD VDD sg13_lv_pmos ad=0.2128p pd=1.5u as=0.3808p ps=2.92u w=1.12u l=0.13u
X2 VSS A Y VSS sg13_lv_nmos ad=0.1406p pd=1.12u as=0.1406p ps=1.12u w=0.74u l=0.13u
X3 Y A VSS VSS sg13_lv_nmos ad=0.1406p pd=1.12u as=0.1406p ps=1.12u w=0.74u l=0.13u
X4 VDD A Y VDD sg13_lv_pmos ad=0.2128p pd=1.5u as=0.2128p ps=1.5u w=1.12u l=0.13u
X5 VSS A Y VSS sg13_lv_nmos ad=0.2516p pd=2.16u as=0.1406p ps=1.12u w=0.74u l=0.13u
X6 Y A VDD VDD sg13_lv_pmos ad=0.2128p pd=1.5u as=0.2128p ps=1.5u w=1.12u l=0.13u
X7 VDD A Y VDD sg13_lv_pmos ad=0.3808p pd=2.92u as=0.2128p ps=1.5u w=1.12u l=0.13u
.ends

.subckt power_stage IOVDD_IN IOVDD_OUT DVDD enable sub DVSS
Xgate_drive_0 gate_drive_0/in_p gate_drive_0/in_n gate_drive_0/out sub IOVDD_IN gate_drive
Xsg13cmos5l_antennanp_0 enable DVDD DVSS sg13cmos5l_antennanp
Xsg13cmos5l_decap_4_0 DVDD DVSS sg13cmos5l_decap_4
Xsg13cmos5l_decap_4_1 DVDD DVSS sg13cmos5l_decap_4
Xpmos_waffle_20_0 IOVDD_OUT IOVDD_IN sub gate_drive_0/out pmos_waffle_20
Xsg13cmos5l_inv_4_0 gate_drive_0/in_n enable DVDD DVSS sg13cmos5l_inv_4
Xsg13cmos5l_inv_4_1 gate_drive_0/in_p gate_drive_0/in_n DVDD DVSS sg13cmos5l_inv_4
.ends

.subckt sg13_hv_nmos_2RYP69 D S G sub
X0 S G D sub sg13_hv_nmos ad=0.34p pd=2.68u as=0.34p ps=2.68u w=1u l=1u
.ends

.subckt bias_nstack shld2 shld3 avss a_1030_2157# nbias ena ncasc itail
Xsg13_hv_nmos_2RYP69_0[0] sg13_hv_nmos_2RYP69_0[5]/D itail ena avss sg13_hv_nmos_2RYP69
Xsg13_hv_nmos_2RYP69_0[1] sg13_hv_nmos_2RYP69_0[5]/D itail ena avss sg13_hv_nmos_2RYP69
Xsg13_hv_nmos_2RYP69_0[2] sg13_hv_nmos_2RYP69_0[5]/D itail ena avss sg13_hv_nmos_2RYP69
Xsg13_hv_nmos_2RYP69_0[3] sg13_hv_nmos_2RYP69_0[5]/D sg13_hv_nmos_2RYP69_0[8]/S ncasc
+ avss sg13_hv_nmos_2RYP69
Xsg13_hv_nmos_2RYP69_0[4] sg13_hv_nmos_2RYP69_0[5]/D sg13_hv_nmos_2RYP69_0[8]/S ncasc
+ avss sg13_hv_nmos_2RYP69
Xsg13_hv_nmos_2RYP69_0[5] sg13_hv_nmos_2RYP69_0[5]/D sg13_hv_nmos_2RYP69_0[8]/S ncasc
+ avss sg13_hv_nmos_2RYP69
Xsg13_hv_nmos_2RYP69_0[6] avss sg13_hv_nmos_2RYP69_0[8]/S nbias avss sg13_hv_nmos_2RYP69
Xsg13_hv_nmos_2RYP69_0[7] avss sg13_hv_nmos_2RYP69_0[8]/S nbias avss sg13_hv_nmos_2RYP69
Xsg13_hv_nmos_2RYP69_0[8] avss sg13_hv_nmos_2RYP69_0[8]/S nbias avss sg13_hv_nmos_2RYP69
.ends

.subckt bias_amp_large avdd out inn inp nbias ena avss
Xsg13_hv_pmos_7A8CUW_0 avdd avdd avdd XM6/S7 avdd XM6/S7 avdd out XM6/S7 XM6/S7 avdd
+ XM6/S7 avdd out XM6/S7 XM6/S7 avdd XM6/S7 avdd out XM6/S7 XM6/S7 avdd XM6/S7 avdd
+ out XM6/S7 XM6/S7 avdd XM6/S7 avdd out XM6/S7 avdd avdd avdd avdd sg13_hv_pmos_7A8CUW
XXM1 avss XM1/S8_1 nbias avss XM1/S8_1 nbias XM1/S8_1 avss nbias XM1/S8_1 avss nbias
+ avss XM1/S8_1 nbias avss XM1/S8_1 nbias XM1/S8_1 avss nbias XM1/S8_1 avss nbias
+ avss XM1/S8_1 nbias avss XM1/S8_1 nbias XM1/S8_1 avss nbias XM1/S8_1 avss nbias
+ avss XM1/S8_1 nbias avss XM1/S8_1 nbias XM1/S8_1 avss nbias XM1/S8_1 avss nbias
+ avss XM1/S8_1 nbias avss XM1/S8_1 nbias XM1/S8_1 avss nbias XM1/S8_1 avss nbias
+ avss sg13_hv_nmos_XVVFQX
XXM2 avdd avdd avdd out avdd XM6/S7 avdd XM6/S7 XM6/S7 out avdd XM6/S7 avdd XM6/S7
+ XM6/S7 out avdd XM6/S7 avdd XM6/S7 XM6/S7 out avdd XM6/S7 avdd XM6/S7 XM6/S7 out
+ avdd XM6/S7 avdd XM6/S7 XM6/S7 avdd avdd avdd avdd sg13_hv_pmos_7A8CUW
XXM5 XM6/D8 inp XM6/S7 inp XM6/D8 inn out inn XM6/D8 inp XM6/S7 inp XM6/D8 inn out
+ inn XM6/D8 inp XM6/S7 inp XM6/D8 inn out inn XM6/D8 inp XM6/S7 inp XM6/D8 inn out
+ inn XM6/D8 inp XM6/S7 inp XM6/D8 inn out inn XM6/D8 avss sg13_hv_nmos_666RAL
XXM6 XM6/D8 inn out inn XM6/D8 inp XM6/S7 inp XM6/D8 inn out inn XM6/D8 inp XM6/S7
+ inp XM6/D8 inn out inn XM6/D8 inp XM6/S7 inp XM6/D8 inn out inn XM6/D8 inp XM6/S7
+ inp XM6/D8 inn out inn XM6/D8 inp XM6/S7 inp XM6/D8 avss sg13_hv_nmos_666RAL
Xsg13_hv_nmos_666RAL_0 XM1/S8_1 ena XM6/D8 ena XM1/S8_1 ena XM6/D8 ena XM1/S8_1 ena
+ XM6/D8 ena XM1/S8_1 ena XM6/D8 ena XM1/S8_1 ena XM6/D8 ena XM1/S8_1 ena XM6/D8 ena
+ XM1/S8_1 ena XM6/D8 ena XM1/S8_1 ena XM6/D8 ena XM1/S8_1 ena XM6/D8 ena XM1/S8_1
+ ena XM6/D8 ena XM1/S8_1 avss sg13_hv_nmos_666RAL
.ends

.subckt sg13_hv_pmos_KGSGVN D S G w_n292_n205#
X0 S G D w_n292_n205# sg13_hv_pmos ad=0.34p pd=2.68u as=0.34p ps=2.68u w=1u l=1u
.ends

.subckt bias_pset pbias pcasc enb itail shld3 avdd
Xsg13_hv_pmos_KGSGVN_0[0] pcasc itail enb avdd sg13_hv_pmos_KGSGVN
Xsg13_hv_pmos_KGSGVN_0[1] pcasc itail enb avdd sg13_hv_pmos_KGSGVN
Xsg13_hv_pmos_KGSGVN_0[2] pcasc itail enb avdd sg13_hv_pmos_KGSGVN
Xsg13_hv_pmos_KGSGVN_0[3] pcasc pbias pcasc avdd sg13_hv_pmos_KGSGVN
Xsg13_hv_pmos_KGSGVN_0[4] pcasc pbias pcasc avdd sg13_hv_pmos_KGSGVN
Xsg13_hv_pmos_KGSGVN_0[5] pcasc pbias pcasc avdd sg13_hv_pmos_KGSGVN
Xsg13_hv_pmos_KGSGVN_0[6] avdd pbias pbias avdd sg13_hv_pmos_KGSGVN
Xsg13_hv_pmos_KGSGVN_0[7] avdd pbias pbias avdd sg13_hv_pmos_KGSGVN
Xsg13_hv_pmos_KGSGVN_0[8] avdd pbias pbias avdd sg13_hv_pmos_KGSGVN
.ends

.subckt rhigh_GJN3VD B R1_0 R2_0 R1_1 R2_1 R1_2 R2_2 R1_3 R2_3 R1_4 R2_4 R1_5 R2_5
+ R1_6 R2_6 R1_7 R2_7
X0 R1_5 R2_5 B rhigh l=17.32u w=0.5u
X1 R1_6 R2_6 B rhigh l=17.32u w=0.5u
X2 R1_3 R2_3 B rhigh l=17.32u w=0.5u
X3 R1_2 R2_2 B rhigh l=17.32u w=0.5u
X4 R1_7 R2_7 B rhigh l=17.32u w=0.5u
X5 R1_4 R2_4 B rhigh l=17.32u w=0.5u
X6 R1_1 R2_1 B rhigh l=17.32u w=0.5u
X7 R1_0 R2_0 B rhigh l=17.32u w=0.5u
.ends

.subckt bias_pstack avdd itail shld2 shld3 enb pbias pcasc
Xsg13_hv_pmos_KGSGVN_0[0] sg13_hv_pmos_KGSGVN_0[5]/D itail enb avdd sg13_hv_pmos_KGSGVN
Xsg13_hv_pmos_KGSGVN_0[1] sg13_hv_pmos_KGSGVN_0[5]/D itail enb avdd sg13_hv_pmos_KGSGVN
Xsg13_hv_pmos_KGSGVN_0[2] sg13_hv_pmos_KGSGVN_0[5]/D itail enb avdd sg13_hv_pmos_KGSGVN
Xsg13_hv_pmos_KGSGVN_0[3] sg13_hv_pmos_KGSGVN_0[5]/D sg13_hv_pmos_KGSGVN_0[8]/S pcasc
+ avdd sg13_hv_pmos_KGSGVN
Xsg13_hv_pmos_KGSGVN_0[4] sg13_hv_pmos_KGSGVN_0[5]/D sg13_hv_pmos_KGSGVN_0[8]/S pcasc
+ avdd sg13_hv_pmos_KGSGVN
Xsg13_hv_pmos_KGSGVN_0[5] sg13_hv_pmos_KGSGVN_0[5]/D sg13_hv_pmos_KGSGVN_0[8]/S pcasc
+ avdd sg13_hv_pmos_KGSGVN
Xsg13_hv_pmos_KGSGVN_0[6] avdd sg13_hv_pmos_KGSGVN_0[8]/S pbias avdd sg13_hv_pmos_KGSGVN
Xsg13_hv_pmos_KGSGVN_0[7] avdd sg13_hv_pmos_KGSGVN_0[8]/S pbias avdd sg13_hv_pmos_KGSGVN
Xsg13_hv_pmos_KGSGVN_0[8] avdd sg13_hv_pmos_KGSGVN_0[8]/S pbias avdd sg13_hv_pmos_KGSGVN
.ends

.subckt bias_pset2 pbias pcasc enb itail shld2 shld3 avdd
Xsg13_hv_pmos_KGSGVN_0[0] pcasc itail enb avdd sg13_hv_pmos_KGSGVN
Xsg13_hv_pmos_KGSGVN_0[1] pcasc itail enb avdd sg13_hv_pmos_KGSGVN
Xsg13_hv_pmos_KGSGVN_0[2] pcasc itail enb avdd sg13_hv_pmos_KGSGVN
Xsg13_hv_pmos_KGSGVN_0[3] pcasc pbias pcasc avdd sg13_hv_pmos_KGSGVN
Xsg13_hv_pmos_KGSGVN_0[4] pcasc pbias pcasc avdd sg13_hv_pmos_KGSGVN
Xsg13_hv_pmos_KGSGVN_0[5] pcasc pbias pcasc avdd sg13_hv_pmos_KGSGVN
Xsg13_hv_pmos_KGSGVN_0[6] avdd pbias pbias avdd sg13_hv_pmos_KGSGVN
Xsg13_hv_pmos_KGSGVN_0[7] avdd pbias pbias avdd sg13_hv_pmos_KGSGVN
Xsg13_hv_pmos_KGSGVN_0[8] avdd pbias pbias avdd sg13_hv_pmos_KGSGVN
.ends

.subckt capacitor_2JEBXB c1 c2
C0 c1 c2 0.22481p
.ends

.subckt rhigh_AFSZTU B R1_0 R2_0 R1_1 R2_1 R1_2 R2_2 R1_3 R2_3 R1_4 R2_4 R1_5 R2_5
+ R1_6 R2_6 R1_7 R2_7 R1_8 R2_8 R1_9 R2_9 R1_10 R2_10 R1_11 R2_11 R1_12 R2_12 R1_13
+ R2_13 R1_14 R2_14 R1_15 R2_15 R1_16 R2_16 R1_17 R2_17 R1_18 R2_18 R1_19 R2_19
X0 R1_18 R2_18 B rhigh l=16.86u w=0.5u
X1 R1_19 R2_19 B rhigh l=16.86u w=0.5u
X2 R1_4 R2_4 B rhigh l=16.86u w=0.5u
X3 R1_3 R2_3 B rhigh l=16.86u w=0.5u
X4 R1_2 R2_2 B rhigh l=16.86u w=0.5u
X5 R1_11 R2_11 B rhigh l=16.86u w=0.5u
X6 R1_12 R2_12 B rhigh l=16.86u w=0.5u
X7 R1_0 R2_0 B rhigh l=16.86u w=0.5u
X8 R1_1 R2_1 B rhigh l=16.86u w=0.5u
X9 R1_9 R2_9 B rhigh l=16.86u w=0.5u
X10 R1_8 R2_8 B rhigh l=16.86u w=0.5u
X11 R1_13 R2_13 B rhigh l=16.86u w=0.5u
X12 R1_14 R2_14 B rhigh l=16.86u w=0.5u
X13 R1_10 R2_10 B rhigh l=16.86u w=0.5u
X14 R1_15 R2_15 B rhigh l=16.86u w=0.5u
X15 R1_16 R2_16 B rhigh l=16.86u w=0.5u
X16 R1_17 R2_17 B rhigh l=16.86u w=0.5u
X17 R1_7 R2_7 B rhigh l=16.86u w=0.5u
X18 R1_5 R2_5 B rhigh l=16.86u w=0.5u
X19 R1_6 R2_6 B rhigh l=16.86u w=0.5u
.ends

.subckt bias_nset itail shld2 shld3 a_1043_n1378# avss nbias ncasc ena
Xsg13_hv_nmos_2RYP69_0[0] ncasc itail ena avss sg13_hv_nmos_2RYP69
Xsg13_hv_nmos_2RYP69_0[1] ncasc itail ena avss sg13_hv_nmos_2RYP69
Xsg13_hv_nmos_2RYP69_0[2] ncasc itail ena avss sg13_hv_nmos_2RYP69
Xsg13_hv_nmos_2RYP69_0[3] ncasc nbias ncasc avss sg13_hv_nmos_2RYP69
Xsg13_hv_nmos_2RYP69_0[4] ncasc nbias ncasc avss sg13_hv_nmos_2RYP69
Xsg13_hv_nmos_2RYP69_0[5] ncasc nbias ncasc avss sg13_hv_nmos_2RYP69
Xsg13_hv_nmos_2RYP69_0[6] avss nbias nbias avss sg13_hv_nmos_2RYP69
Xsg13_hv_nmos_2RYP69_0[7] avss nbias nbias avss sg13_hv_nmos_2RYP69
Xsg13_hv_nmos_2RYP69_0[8] avss nbias nbias avss sg13_hv_nmos_2RYP69
.ends

.subckt sg13cmos5l_nand2_1 Y A B VDD VSS
X0 a_154_118# B VSS VSS sg13_lv_nmos ad=0.1406p pd=1.12u as=0.2516p ps=2.16u w=0.74u l=0.13u
X1 Y A a_154_118# VSS sg13_lv_nmos ad=0.2516p pd=2.16u as=0.1406p ps=1.12u w=0.74u l=0.13u
X2 Y B VDD VDD sg13_lv_pmos ad=0.2128p pd=1.5u as=0.3808p ps=2.92u w=1.12u l=0.13u
X3 VDD A Y VDD sg13_lv_pmos ad=0.3808p pd=2.92u as=0.2128p ps=1.5u w=1.12u l=0.13u
.ends

.subckt sg13cmos5l_nor2_1 Y A B VDD VSS
X0 Y A VSS VSS sg13_lv_nmos ad=0.1406p pd=1.12u as=0.2516p ps=2.16u w=0.74u l=0.13u
X1 VSS B Y VSS sg13_lv_nmos ad=0.2516p pd=2.16u as=0.1406p ps=1.12u w=0.74u l=0.13u
X2 a_170_412# A VDD VDD sg13_lv_pmos ad=0.1176p pd=1.33u as=0.4032p ps=2.96u w=1.12u l=0.13u
X3 Y B a_170_412# VDD sg13_lv_pmos ad=0.3808p pd=2.92u as=0.1176p ps=1.33u w=1.12u l=0.13u
.ends

.subckt bias_generator_fe ena vbg src_test0 ena_src_test0 ref_sel_vbg ref_in pcasc
+ pbias snk_test0 ena_snk_test0 ref_sel_fine ref_sel_coarse nbias ncasc x13[9]/shld2
+ dvdd sub dvss avdd
Xbias_nstack_0 sub sub sub bias_nstack_0/a_1030_2157# nbias ena_3v3 ncasc bias_pset_1/itail
+ bias_nstack
Xsg13cmos5l_inv_2_0 level_shift_6/in_n level_shift_6/in_p dvdd dvss sg13cmos5l_inv_2
Xbias_nstack_1[0] sub sub sub bias_nstack_1[1]/a_1030_2157# nbias sub ncasc XR4/R2_0
+ bias_nstack
Xbias_nstack_1[1] sub sub sub bias_nstack_1[1]/a_1030_2157# nbias sub ncasc XR4/R2_0
+ bias_nstack
Xsg13cmos5l_inv_2_1 x12/in_n ena_snk_test0 dvdd dvss sg13cmos5l_inv_2
Xx3 avdd pbias vbg C2/c2 nbias ena_vbg_3v3 sub bias_amp_large
Xsg13cmos5l_inv_2_2 level_shift_0/in_n ena dvdd dvss sg13cmos5l_inv_2
Xx4[0] sub sub sub x4[1]/a_1030_2157# nbias ena_test0_3v3 ncasc snk_test0 bias_nstack
Xx4[1] sub sub sub x4[1]/a_1030_2157# nbias ena_test0_3v3 ncasc snk_test0 bias_nstack
Xsg13cmos5l_inv_2_3 level_shift_3/in_p ena_src_test0 dvdd dvss sg13cmos5l_inv_2
Xbias_pset_1 pbias pcasc ena_vbg_3v3 bias_pset_1/itail avdd avdd bias_pset
Xsg13cmos5l_inv_2_4 level_shift_2/in_n ref_sel_vbg dvdd dvss sg13cmos5l_inv_2
Xsg13cmos5l_inv_2_5 level_shift_5/in_n level_shift_5/in_p dvdd dvss sg13cmos5l_inv_2
Xsg13cmos5l_inv_2_6 level_shift_4/in_n level_shift_4/in_p dvdd dvss sg13cmos5l_inv_2
Xsg13cmos5l_inv_2_7 sg13cmos5l_inv_2_7/Y ref_sel_fine dvdd dvss sg13cmos5l_inv_2
XXR4 sub XR4/R1_1 XR4/R2_0 XR4/R1_1 XR4/R2_2 XR4/R1_3 XR4/R2_2 XR4/R1_3 XR4/R2_4 XR4/R1_5
+ XR4/R2_4 XR4/R1_5 XR4/R2_6 XR4/R1_7 XR4/R2_6 XR4/R1_7 ref_in rhigh_GJN3VD
Xsg13cmos5l_antennanp_0 ref_sel_coarse dvdd dvss sg13cmos5l_antennanp
Xbias_pstack_0[0] avdd C2/c2 x13[9]/shld2 avdd enb_std_3v3 pbias pcasc bias_pstack
Xbias_pstack_0[1] avdd C2/c2 x13[9]/shld2 avdd enb_std_3v3 pbias pcasc bias_pstack
Xbias_pstack_0[2] avdd C2/c2 x13[9]/shld2 avdd enb_std_3v3 pbias pcasc bias_pstack
Xsg13cmos5l_antennanp_1 ena_snk_test0 dvdd dvss sg13cmos5l_antennanp
Xbias_pstack_1 avdd C2/c2 x13[9]/shld2 avdd enb_coarse_3v3 pbias pcasc bias_pstack
Xsg13cmos5l_antennanp_2 ena dvdd dvss sg13cmos5l_antennanp
Xbias_pstack_2[0] avdd src_test0 x13[9]/shld2 avdd level_shift_3/out pbias pcasc bias_pstack
Xbias_pstack_2[1] avdd src_test0 x13[9]/shld2 avdd level_shift_3/out pbias pcasc bias_pstack
Xsg13cmos5l_antennanp_3 ena_src_test0 dvdd dvss sg13cmos5l_antennanp
Xbias_pstack_3[0] avdd C2/c2 pbias avdd avdd bias_pset2_0/pbias pcasc bias_pstack
Xbias_pstack_3[1] avdd C2/c2 pbias avdd avdd bias_pset2_0/pbias pcasc bias_pstack
Xsg13cmos5l_antennanp_4 ref_sel_vbg dvdd dvss sg13cmos5l_antennanp
Xbias_pset2_0 bias_pset2_0/pbias pcasc enb_vbg_3v3 bias_pset_1/itail pbias avdd avdd
+ bias_pset2
Xsg13cmos5l_antennanp_5 ref_sel_fine dvdd dvss sg13cmos5l_antennanp
XC2 pbias C2/c2 capacitor_2JEBXB
Xlevel_shift_0 level_shift_0/in_n ena avdd ena_3v3 sub level_shift
Xlevel_shift_1 ref_sel_vbg level_shift_2/in_n avdd enb_vbg_3v3 sub level_shift
Xlevel_shift_2 level_shift_2/in_n ref_sel_vbg avdd ena_vbg_3v3 sub level_shift
Xsg13cmos5l_decap_4_0 dvdd dvss sg13cmos5l_decap_4
Xlevel_shift_3 ena_src_test0 level_shift_3/in_p avdd level_shift_3/out sub level_shift
Xsg13cmos5l_decap_4_1 dvdd dvss sg13cmos5l_decap_4
Xrhigh_AFSZTU_0 sub C2/c2 rhigh_AFSZTU_0/R2_1 rhigh_AFSZTU_0/R1_2 rhigh_AFSZTU_0/R2_1
+ rhigh_AFSZTU_0/R1_2 rhigh_AFSZTU_0/R2_3 rhigh_AFSZTU_0/R1_4 rhigh_AFSZTU_0/R2_3
+ rhigh_AFSZTU_0/R1_4 rhigh_AFSZTU_0/R2_5 rhigh_AFSZTU_0/R1_6 rhigh_AFSZTU_0/R2_5
+ rhigh_AFSZTU_0/R1_6 rhigh_AFSZTU_0/R2_7 rhigh_AFSZTU_0/R1_8 rhigh_AFSZTU_0/R2_7
+ rhigh_AFSZTU_0/R1_8 rhigh_AFSZTU_0/R2_9 rhigh_AFSZTU_0/R1_9 rhigh_AFSZTU_0/R2_9
+ rhigh_AFSZTU_0/R1_9 rhigh_AFSZTU_0/R2_11 rhigh_AFSZTU_0/R1_12 rhigh_AFSZTU_0/R2_11
+ rhigh_AFSZTU_0/R1_12 rhigh_AFSZTU_0/R2_13 rhigh_AFSZTU_0/R1_14 rhigh_AFSZTU_0/R2_13
+ rhigh_AFSZTU_0/R1_14 rhigh_AFSZTU_0/R2_15 rhigh_AFSZTU_0/R1_16 rhigh_AFSZTU_0/R2_15
+ rhigh_AFSZTU_0/R1_16 rhigh_AFSZTU_0/R2_17 rhigh_AFSZTU_0/R1_18 rhigh_AFSZTU_0/R2_17
+ rhigh_AFSZTU_0/R1_18 rhigh_AFSZTU_0/R2_19 sub rhigh_AFSZTU_0/R2_19 rhigh_AFSZTU
Xx12 x12/in_n ena_snk_test0 avdd ena_test0_3v3 sub level_shift
Xlevel_shift_4 level_shift_4/in_n level_shift_4/in_p avdd enb_fine_3v3 sub level_shift
Xbias_nset_0[0] XR4/R2_0 sub sub sub sub nbias ncasc ena_3v3 bias_nset
Xbias_nset_0[1] XR4/R2_0 sub sub sub sub nbias ncasc ena_3v3 bias_nset
Xbias_nset_0[2] XR4/R2_0 sub sub sub sub nbias ncasc ena_3v3 bias_nset
Xbias_nset_0[3] XR4/R2_0 sub sub sub sub nbias ncasc ena_3v3 bias_nset
Xbias_nset_0[4] XR4/R2_0 sub sub sub sub nbias ncasc ena_3v3 bias_nset
Xbias_nset_0[5] XR4/R2_0 sub sub sub sub nbias ncasc ena_3v3 bias_nset
Xbias_nset_0[6] XR4/R2_0 sub sub sub sub nbias ncasc ena_3v3 bias_nset
Xbias_nset_0[7] XR4/R2_0 sub sub sub sub nbias ncasc ena_3v3 bias_nset
Xbias_nset_0[8] XR4/R2_0 sub sub sub sub nbias ncasc ena_3v3 bias_nset
Xbias_nset_0[9] XR4/R2_0 sub sub sub sub nbias ncasc ena_3v3 bias_nset
Xbias_nset_0[10] XR4/R2_0 sub sub sub sub nbias ncasc ena_3v3 bias_nset
Xbias_nset_0[11] XR4/R2_0 sub sub sub sub nbias ncasc ena_3v3 bias_nset
Xbias_nset_0[12] XR4/R2_0 sub sub sub sub nbias ncasc ena_3v3 bias_nset
Xbias_nset_0[13] XR4/R2_0 sub sub sub sub nbias ncasc ena_3v3 bias_nset
Xbias_nset_0[14] XR4/R2_0 sub sub sub sub nbias ncasc ena_3v3 bias_nset
Xbias_nset_0[15] XR4/R2_0 sub sub sub sub nbias ncasc ena_3v3 bias_nset
Xsg13cmos5l_decap_4_2 dvdd dvss sg13cmos5l_decap_4
Xx13[0] avdd C2/c2 x13[9]/shld2 avdd enb_fine_3v3 pbias pcasc bias_pstack
Xx13[1] avdd C2/c2 x13[9]/shld2 avdd enb_fine_3v3 pbias pcasc bias_pstack
Xx13[2] avdd C2/c2 x13[9]/shld2 avdd enb_fine_3v3 pbias pcasc bias_pstack
Xx13[3] avdd C2/c2 x13[9]/shld2 avdd enb_fine_3v3 pbias pcasc bias_pstack
Xx13[4] avdd C2/c2 x13[9]/shld2 avdd enb_fine_3v3 pbias pcasc bias_pstack
Xx13[5] avdd C2/c2 x13[9]/shld2 avdd enb_fine_3v3 pbias pcasc bias_pstack
Xx13[6] avdd C2/c2 x13[9]/shld2 avdd enb_fine_3v3 pbias pcasc bias_pstack
Xx13[7] avdd C2/c2 x13[9]/shld2 avdd enb_fine_3v3 pbias pcasc bias_pstack
Xx13[8] avdd C2/c2 x13[9]/shld2 avdd enb_fine_3v3 pbias pcasc bias_pstack
Xx13[9] avdd C2/c2 x13[9]/shld2 avdd enb_fine_3v3 pbias pcasc bias_pstack
Xx13[10] avdd C2/c2 x13[9]/shld2 avdd enb_fine_3v3 pbias pcasc bias_pstack
Xx13[11] avdd C2/c2 x13[9]/shld2 avdd enb_fine_3v3 pbias pcasc bias_pstack
Xx13[12] avdd C2/c2 x13[9]/shld2 avdd enb_fine_3v3 pbias pcasc bias_pstack
Xx13[13] avdd C2/c2 x13[9]/shld2 avdd enb_fine_3v3 pbias pcasc bias_pstack
Xx13[14] avdd C2/c2 x13[9]/shld2 avdd enb_fine_3v3 pbias pcasc bias_pstack
Xx13[15] avdd C2/c2 x13[9]/shld2 avdd enb_fine_3v3 pbias pcasc bias_pstack
Xsg13cmos5l_nand2_1_0 level_shift_6/in_p sg13cmos5l_nand2_1_3/Y ref_sel_vbg dvdd dvss
+ sg13cmos5l_nand2_1
Xlevel_shift_5 level_shift_5/in_n level_shift_5/in_p avdd enb_coarse_3v3 sub level_shift
Xsg13cmos5l_decap_4_3 dvdd dvss sg13cmos5l_decap_4
Xsg13cmos5l_nand2_1_1 level_shift_5/in_p sg13cmos5l_nand2_1_4/Y ref_sel_vbg dvdd dvss
+ sg13cmos5l_nand2_1
Xlevel_shift_6 level_shift_6/in_n level_shift_6/in_p avdd enb_std_3v3 sub level_shift
Xsg13cmos5l_nor2_1_1 sg13cmos5l_nor2_1_1/Y ref_sel_coarse sg13cmos5l_inv_2_7/Y dvdd
+ dvss sg13cmos5l_nor2_1
Xsg13cmos5l_decap_4_4 dvdd dvss sg13cmos5l_decap_4
Xsg13cmos5l_nand2_1_2 level_shift_4/in_p sg13cmos5l_nor2_1_1/Y ref_sel_vbg dvdd dvss
+ sg13cmos5l_nand2_1
Xsg13cmos5l_decap_4_5 dvdd dvss sg13cmos5l_decap_4
Xsg13cmos5l_nand2_1_3 sg13cmos5l_nand2_1_3/Y sg13cmos5l_inv_2_7/Y ref_sel_coarse dvdd
+ dvss sg13cmos5l_nand2_1
Xsg13cmos5l_decap_4_6 dvdd dvss sg13cmos5l_decap_4
Xsg13cmos5l_nand2_1_4 sg13cmos5l_nand2_1_4/Y ref_sel_coarse ref_sel_fine dvdd dvss
+ sg13cmos5l_nand2_1
.ends

.subckt bias_generator_be1n avdd avss sink_ena[7] sink_ena[5] sink_ena[3] sink_ibias
+ sink_ena[4] sink_ena[0] nbias bias_nstack_6/shld2 sink_ena[1] sink_ena[6] sub sink_ena[2]
+ bias_nstack_6/shld3 ncasc level_shift_7/vdd dvdd dvss
Xbias_nstack_0[0] bias_nstack_6/shld2 bias_nstack_6/shld3 sub sub nbias level_shift_1/out
+ ncasc sink_ibias bias_nstack
Xbias_nstack_0[1] bias_nstack_6/shld2 bias_nstack_6/shld3 sub sub nbias level_shift_1/out
+ ncasc sink_ibias bias_nstack
Xbias_nstack_0[2] bias_nstack_6/shld2 bias_nstack_6/shld3 sub sub nbias level_shift_1/out
+ ncasc sink_ibias bias_nstack
Xbias_nstack_0[3] bias_nstack_6/shld2 bias_nstack_6/shld3 sub sub nbias level_shift_1/out
+ ncasc sink_ibias bias_nstack
Xbias_nstack_0[4] bias_nstack_6/shld2 bias_nstack_6/shld3 sub sub nbias level_shift_1/out
+ ncasc sink_ibias bias_nstack
Xbias_nstack_0[5] bias_nstack_6/shld2 bias_nstack_6/shld3 sub sub nbias level_shift_1/out
+ ncasc sink_ibias bias_nstack
Xbias_nstack_0[6] bias_nstack_6/shld2 bias_nstack_6/shld3 sub sub nbias level_shift_1/out
+ ncasc sink_ibias bias_nstack
Xbias_nstack_0[7] bias_nstack_6/shld2 bias_nstack_6/shld3 sub sub nbias level_shift_1/out
+ ncasc sink_ibias bias_nstack
Xbias_nstack_0[8] bias_nstack_6/shld2 bias_nstack_6/shld3 sub sub nbias level_shift_1/out
+ ncasc sink_ibias bias_nstack
Xbias_nstack_0[9] bias_nstack_6/shld2 bias_nstack_6/shld3 sub sub nbias level_shift_1/out
+ ncasc sink_ibias bias_nstack
Xbias_nstack_0[10] bias_nstack_6/shld2 bias_nstack_6/shld3 sub sub nbias level_shift_1/out
+ ncasc sink_ibias bias_nstack
Xbias_nstack_0[11] bias_nstack_6/shld2 bias_nstack_6/shld3 sub sub nbias level_shift_1/out
+ ncasc sink_ibias bias_nstack
Xbias_nstack_0[12] bias_nstack_6/shld2 bias_nstack_6/shld3 sub sub nbias level_shift_1/out
+ ncasc sink_ibias bias_nstack
Xbias_nstack_0[13] bias_nstack_6/shld2 bias_nstack_6/shld3 sub sub nbias level_shift_1/out
+ ncasc sink_ibias bias_nstack
Xbias_nstack_0[14] bias_nstack_6/shld2 bias_nstack_6/shld3 sub sub nbias level_shift_1/out
+ ncasc sink_ibias bias_nstack
Xbias_nstack_0[15] bias_nstack_6/shld2 bias_nstack_6/shld3 sub sub nbias level_shift_1/out
+ ncasc sink_ibias bias_nstack
Xbias_nstack_0[16] bias_nstack_6/shld2 bias_nstack_6/shld3 sub sub nbias level_shift_1/out
+ ncasc sink_ibias bias_nstack
Xbias_nstack_0[17] bias_nstack_6/shld2 bias_nstack_6/shld3 sub sub nbias level_shift_1/out
+ ncasc sink_ibias bias_nstack
Xbias_nstack_0[18] bias_nstack_6/shld2 bias_nstack_6/shld3 sub sub nbias level_shift_1/out
+ ncasc sink_ibias bias_nstack
Xbias_nstack_0[19] bias_nstack_6/shld2 bias_nstack_6/shld3 sub sub nbias level_shift_1/out
+ ncasc sink_ibias bias_nstack
Xbias_nstack_0[20] bias_nstack_6/shld2 bias_nstack_6/shld3 sub sub nbias level_shift_1/out
+ ncasc sink_ibias bias_nstack
Xbias_nstack_0[21] bias_nstack_6/shld2 bias_nstack_6/shld3 sub sub nbias level_shift_1/out
+ ncasc sink_ibias bias_nstack
Xbias_nstack_0[22] bias_nstack_6/shld2 bias_nstack_6/shld3 sub sub nbias level_shift_1/out
+ ncasc sink_ibias bias_nstack
Xbias_nstack_0[23] bias_nstack_6/shld2 bias_nstack_6/shld3 sub sub nbias level_shift_1/out
+ ncasc sink_ibias bias_nstack
Xbias_nstack_0[24] bias_nstack_6/shld2 bias_nstack_6/shld3 sub sub nbias level_shift_1/out
+ ncasc sink_ibias bias_nstack
Xbias_nstack_0[25] bias_nstack_6/shld2 bias_nstack_6/shld3 sub sub nbias level_shift_1/out
+ ncasc sink_ibias bias_nstack
Xbias_nstack_0[26] bias_nstack_6/shld2 bias_nstack_6/shld3 sub sub nbias level_shift_1/out
+ ncasc sink_ibias bias_nstack
Xbias_nstack_0[27] bias_nstack_6/shld2 bias_nstack_6/shld3 sub sub nbias level_shift_1/out
+ ncasc sink_ibias bias_nstack
Xbias_nstack_0[28] bias_nstack_6/shld2 bias_nstack_6/shld3 sub sub nbias level_shift_1/out
+ ncasc sink_ibias bias_nstack
Xbias_nstack_0[29] bias_nstack_6/shld2 bias_nstack_6/shld3 sub sub nbias level_shift_1/out
+ ncasc sink_ibias bias_nstack
Xbias_nstack_0[30] bias_nstack_6/shld2 bias_nstack_6/shld3 sub sub nbias level_shift_1/out
+ ncasc sink_ibias bias_nstack
Xbias_nstack_0[31] bias_nstack_6/shld2 bias_nstack_6/shld3 sub sub nbias level_shift_1/out
+ ncasc sink_ibias bias_nstack
Xbias_nstack_0[32] bias_nstack_6/shld2 bias_nstack_6/shld3 sub sub nbias level_shift_1/out
+ ncasc sink_ibias bias_nstack
Xbias_nstack_0[33] bias_nstack_6/shld2 bias_nstack_6/shld3 sub sub nbias level_shift_1/out
+ ncasc sink_ibias bias_nstack
Xbias_nstack_0[34] bias_nstack_6/shld2 bias_nstack_6/shld3 sub sub nbias level_shift_1/out
+ ncasc sink_ibias bias_nstack
Xbias_nstack_0[35] bias_nstack_6/shld2 bias_nstack_6/shld3 sub sub nbias level_shift_1/out
+ ncasc sink_ibias bias_nstack
Xbias_nstack_0[36] bias_nstack_6/shld2 bias_nstack_6/shld3 sub sub nbias level_shift_1/out
+ ncasc sink_ibias bias_nstack
Xbias_nstack_0[37] bias_nstack_6/shld2 bias_nstack_6/shld3 sub sub nbias level_shift_1/out
+ ncasc sink_ibias bias_nstack
Xbias_nstack_0[38] bias_nstack_6/shld2 bias_nstack_6/shld3 sub sub nbias level_shift_1/out
+ ncasc sink_ibias bias_nstack
Xbias_nstack_0[39] bias_nstack_6/shld2 bias_nstack_6/shld3 sub sub nbias level_shift_1/out
+ ncasc sink_ibias bias_nstack
Xbias_nstack_0[40] bias_nstack_6/shld2 bias_nstack_6/shld3 sub sub nbias level_shift_1/out
+ ncasc sink_ibias bias_nstack
Xbias_nstack_0[41] bias_nstack_6/shld2 bias_nstack_6/shld3 sub sub nbias level_shift_1/out
+ ncasc sink_ibias bias_nstack
Xbias_nstack_0[42] bias_nstack_6/shld2 bias_nstack_6/shld3 sub sub nbias level_shift_1/out
+ ncasc sink_ibias bias_nstack
Xbias_nstack_0[43] bias_nstack_6/shld2 bias_nstack_6/shld3 sub sub nbias level_shift_1/out
+ ncasc sink_ibias bias_nstack
Xbias_nstack_0[44] bias_nstack_6/shld2 bias_nstack_6/shld3 sub sub nbias level_shift_1/out
+ ncasc sink_ibias bias_nstack
Xbias_nstack_0[45] bias_nstack_6/shld2 bias_nstack_6/shld3 sub sub nbias level_shift_1/out
+ ncasc sink_ibias bias_nstack
Xbias_nstack_0[46] bias_nstack_6/shld2 bias_nstack_6/shld3 sub sub nbias level_shift_1/out
+ ncasc sink_ibias bias_nstack
Xbias_nstack_0[47] bias_nstack_6/shld2 bias_nstack_6/shld3 sub sub nbias level_shift_1/out
+ ncasc sink_ibias bias_nstack
Xbias_nstack_0[48] bias_nstack_6/shld2 bias_nstack_6/shld3 sub sub nbias level_shift_1/out
+ ncasc sink_ibias bias_nstack
Xbias_nstack_0[49] bias_nstack_6/shld2 bias_nstack_6/shld3 sub sub nbias level_shift_1/out
+ ncasc sink_ibias bias_nstack
Xbias_nstack_0[50] bias_nstack_6/shld2 bias_nstack_6/shld3 sub sub nbias level_shift_1/out
+ ncasc sink_ibias bias_nstack
Xbias_nstack_0[51] bias_nstack_6/shld2 bias_nstack_6/shld3 sub sub nbias level_shift_1/out
+ ncasc sink_ibias bias_nstack
Xbias_nstack_0[52] bias_nstack_6/shld2 bias_nstack_6/shld3 sub sub nbias level_shift_1/out
+ ncasc sink_ibias bias_nstack
Xbias_nstack_0[53] bias_nstack_6/shld2 bias_nstack_6/shld3 sub sub nbias level_shift_1/out
+ ncasc sink_ibias bias_nstack
Xbias_nstack_0[54] bias_nstack_6/shld2 bias_nstack_6/shld3 sub sub nbias level_shift_1/out
+ ncasc sink_ibias bias_nstack
Xbias_nstack_0[55] bias_nstack_6/shld2 bias_nstack_6/shld3 sub sub nbias level_shift_1/out
+ ncasc sink_ibias bias_nstack
Xbias_nstack_0[56] bias_nstack_6/shld2 bias_nstack_6/shld3 sub sub nbias level_shift_1/out
+ ncasc sink_ibias bias_nstack
Xbias_nstack_0[57] bias_nstack_6/shld2 bias_nstack_6/shld3 sub sub nbias level_shift_1/out
+ ncasc sink_ibias bias_nstack
Xbias_nstack_0[58] bias_nstack_6/shld2 bias_nstack_6/shld3 sub sub nbias level_shift_1/out
+ ncasc sink_ibias bias_nstack
Xbias_nstack_0[59] bias_nstack_6/shld2 bias_nstack_6/shld3 sub sub nbias level_shift_1/out
+ ncasc sink_ibias bias_nstack
Xbias_nstack_0[60] bias_nstack_6/shld2 bias_nstack_6/shld3 sub sub nbias level_shift_1/out
+ ncasc sink_ibias bias_nstack
Xbias_nstack_0[61] bias_nstack_6/shld2 bias_nstack_6/shld3 sub sub nbias level_shift_1/out
+ ncasc sink_ibias bias_nstack
Xbias_nstack_0[62] bias_nstack_6/shld2 bias_nstack_6/shld3 sub sub nbias level_shift_1/out
+ ncasc sink_ibias bias_nstack
Xbias_nstack_0[63] bias_nstack_6/shld2 bias_nstack_6/shld3 sub sub nbias level_shift_1/out
+ ncasc sink_ibias bias_nstack
Xsg13cmos5l_inv_2_0 level_shift_4/in_n sink_ena[3] dvdd dvss sg13cmos5l_inv_2
Xbias_nstack_1[0] bias_nstack_6/shld2 bias_nstack_6/shld3 sub sub nbias level_shift_2/out
+ ncasc sink_ibias bias_nstack
Xbias_nstack_1[1] bias_nstack_6/shld2 bias_nstack_6/shld3 sub sub nbias level_shift_2/out
+ ncasc sink_ibias bias_nstack
Xbias_nstack_1[2] bias_nstack_6/shld2 bias_nstack_6/shld3 sub sub nbias level_shift_2/out
+ ncasc sink_ibias bias_nstack
Xbias_nstack_1[3] bias_nstack_6/shld2 bias_nstack_6/shld3 sub sub nbias level_shift_2/out
+ ncasc sink_ibias bias_nstack
Xbias_nstack_1[4] bias_nstack_6/shld2 bias_nstack_6/shld3 sub sub nbias level_shift_2/out
+ ncasc sink_ibias bias_nstack
Xbias_nstack_1[5] bias_nstack_6/shld2 bias_nstack_6/shld3 sub sub nbias level_shift_2/out
+ ncasc sink_ibias bias_nstack
Xbias_nstack_1[6] bias_nstack_6/shld2 bias_nstack_6/shld3 sub sub nbias level_shift_2/out
+ ncasc sink_ibias bias_nstack
Xbias_nstack_1[7] bias_nstack_6/shld2 bias_nstack_6/shld3 sub sub nbias level_shift_2/out
+ ncasc sink_ibias bias_nstack
Xbias_nstack_1[8] bias_nstack_6/shld2 bias_nstack_6/shld3 sub sub nbias level_shift_2/out
+ ncasc sink_ibias bias_nstack
Xbias_nstack_1[9] bias_nstack_6/shld2 bias_nstack_6/shld3 sub sub nbias level_shift_2/out
+ ncasc sink_ibias bias_nstack
Xbias_nstack_1[10] bias_nstack_6/shld2 bias_nstack_6/shld3 sub sub nbias level_shift_2/out
+ ncasc sink_ibias bias_nstack
Xbias_nstack_1[11] bias_nstack_6/shld2 bias_nstack_6/shld3 sub sub nbias level_shift_2/out
+ ncasc sink_ibias bias_nstack
Xbias_nstack_1[12] bias_nstack_6/shld2 bias_nstack_6/shld3 sub sub nbias level_shift_2/out
+ ncasc sink_ibias bias_nstack
Xbias_nstack_1[13] bias_nstack_6/shld2 bias_nstack_6/shld3 sub sub nbias level_shift_2/out
+ ncasc sink_ibias bias_nstack
Xbias_nstack_1[14] bias_nstack_6/shld2 bias_nstack_6/shld3 sub sub nbias level_shift_2/out
+ ncasc sink_ibias bias_nstack
Xbias_nstack_1[15] bias_nstack_6/shld2 bias_nstack_6/shld3 sub sub nbias level_shift_2/out
+ ncasc sink_ibias bias_nstack
Xbias_nstack_1[16] bias_nstack_6/shld2 bias_nstack_6/shld3 sub sub nbias level_shift_2/out
+ ncasc sink_ibias bias_nstack
Xbias_nstack_1[17] bias_nstack_6/shld2 bias_nstack_6/shld3 sub sub nbias level_shift_2/out
+ ncasc sink_ibias bias_nstack
Xbias_nstack_1[18] bias_nstack_6/shld2 bias_nstack_6/shld3 sub sub nbias level_shift_2/out
+ ncasc sink_ibias bias_nstack
Xbias_nstack_1[19] bias_nstack_6/shld2 bias_nstack_6/shld3 sub sub nbias level_shift_2/out
+ ncasc sink_ibias bias_nstack
Xbias_nstack_1[20] bias_nstack_6/shld2 bias_nstack_6/shld3 sub sub nbias level_shift_2/out
+ ncasc sink_ibias bias_nstack
Xbias_nstack_1[21] bias_nstack_6/shld2 bias_nstack_6/shld3 sub sub nbias level_shift_2/out
+ ncasc sink_ibias bias_nstack
Xbias_nstack_1[22] bias_nstack_6/shld2 bias_nstack_6/shld3 sub sub nbias level_shift_2/out
+ ncasc sink_ibias bias_nstack
Xbias_nstack_1[23] bias_nstack_6/shld2 bias_nstack_6/shld3 sub sub nbias level_shift_2/out
+ ncasc sink_ibias bias_nstack
Xbias_nstack_1[24] bias_nstack_6/shld2 bias_nstack_6/shld3 sub sub nbias level_shift_2/out
+ ncasc sink_ibias bias_nstack
Xbias_nstack_1[25] bias_nstack_6/shld2 bias_nstack_6/shld3 sub sub nbias level_shift_2/out
+ ncasc sink_ibias bias_nstack
Xbias_nstack_1[26] bias_nstack_6/shld2 bias_nstack_6/shld3 sub sub nbias level_shift_2/out
+ ncasc sink_ibias bias_nstack
Xbias_nstack_1[27] bias_nstack_6/shld2 bias_nstack_6/shld3 sub sub nbias level_shift_2/out
+ ncasc sink_ibias bias_nstack
Xbias_nstack_1[28] bias_nstack_6/shld2 bias_nstack_6/shld3 sub sub nbias level_shift_2/out
+ ncasc sink_ibias bias_nstack
Xbias_nstack_1[29] bias_nstack_6/shld2 bias_nstack_6/shld3 sub sub nbias level_shift_2/out
+ ncasc sink_ibias bias_nstack
Xbias_nstack_1[30] bias_nstack_6/shld2 bias_nstack_6/shld3 sub sub nbias level_shift_2/out
+ ncasc sink_ibias bias_nstack
Xbias_nstack_1[31] bias_nstack_6/shld2 bias_nstack_6/shld3 sub sub nbias level_shift_2/out
+ ncasc sink_ibias bias_nstack
Xsg13cmos5l_inv_2_1 level_shift_7/in_n sink_ena[0] dvdd dvss sg13cmos5l_inv_2
Xbias_nstack_2[0] bias_nstack_6/shld2 bias_nstack_6/shld3 sub sub nbias level_shift_3/out
+ ncasc sink_ibias bias_nstack
Xbias_nstack_2[1] bias_nstack_6/shld2 bias_nstack_6/shld3 sub sub nbias level_shift_3/out
+ ncasc sink_ibias bias_nstack
Xbias_nstack_2[2] bias_nstack_6/shld2 bias_nstack_6/shld3 sub sub nbias level_shift_3/out
+ ncasc sink_ibias bias_nstack
Xbias_nstack_2[3] bias_nstack_6/shld2 bias_nstack_6/shld3 sub sub nbias level_shift_3/out
+ ncasc sink_ibias bias_nstack
Xbias_nstack_2[4] bias_nstack_6/shld2 bias_nstack_6/shld3 sub sub nbias level_shift_3/out
+ ncasc sink_ibias bias_nstack
Xbias_nstack_2[5] bias_nstack_6/shld2 bias_nstack_6/shld3 sub sub nbias level_shift_3/out
+ ncasc sink_ibias bias_nstack
Xbias_nstack_2[6] bias_nstack_6/shld2 bias_nstack_6/shld3 sub sub nbias level_shift_3/out
+ ncasc sink_ibias bias_nstack
Xbias_nstack_2[7] bias_nstack_6/shld2 bias_nstack_6/shld3 sub sub nbias level_shift_3/out
+ ncasc sink_ibias bias_nstack
Xbias_nstack_2[8] bias_nstack_6/shld2 bias_nstack_6/shld3 sub sub nbias level_shift_3/out
+ ncasc sink_ibias bias_nstack
Xbias_nstack_2[9] bias_nstack_6/shld2 bias_nstack_6/shld3 sub sub nbias level_shift_3/out
+ ncasc sink_ibias bias_nstack
Xbias_nstack_2[10] bias_nstack_6/shld2 bias_nstack_6/shld3 sub sub nbias level_shift_3/out
+ ncasc sink_ibias bias_nstack
Xbias_nstack_2[11] bias_nstack_6/shld2 bias_nstack_6/shld3 sub sub nbias level_shift_3/out
+ ncasc sink_ibias bias_nstack
Xbias_nstack_2[12] bias_nstack_6/shld2 bias_nstack_6/shld3 sub sub nbias level_shift_3/out
+ ncasc sink_ibias bias_nstack
Xbias_nstack_2[13] bias_nstack_6/shld2 bias_nstack_6/shld3 sub sub nbias level_shift_3/out
+ ncasc sink_ibias bias_nstack
Xbias_nstack_2[14] bias_nstack_6/shld2 bias_nstack_6/shld3 sub sub nbias level_shift_3/out
+ ncasc sink_ibias bias_nstack
Xbias_nstack_2[15] bias_nstack_6/shld2 bias_nstack_6/shld3 sub sub nbias level_shift_3/out
+ ncasc sink_ibias bias_nstack
Xsg13cmos5l_inv_2_2 level_shift_2/in_n sink_ena[5] dvdd dvss sg13cmos5l_inv_2
Xbias_nstack_3[0] bias_nstack_6/shld2 bias_nstack_6/shld3 sub sub nbias level_shift_4/out
+ ncasc sink_ibias bias_nstack
Xbias_nstack_3[1] bias_nstack_6/shld2 bias_nstack_6/shld3 sub sub nbias level_shift_4/out
+ ncasc sink_ibias bias_nstack
Xbias_nstack_3[2] bias_nstack_6/shld2 bias_nstack_6/shld3 sub sub nbias level_shift_4/out
+ ncasc sink_ibias bias_nstack
Xbias_nstack_3[3] bias_nstack_6/shld2 bias_nstack_6/shld3 sub sub nbias level_shift_4/out
+ ncasc sink_ibias bias_nstack
Xbias_nstack_3[4] bias_nstack_6/shld2 bias_nstack_6/shld3 sub sub nbias level_shift_4/out
+ ncasc sink_ibias bias_nstack
Xbias_nstack_3[5] bias_nstack_6/shld2 bias_nstack_6/shld3 sub sub nbias level_shift_4/out
+ ncasc sink_ibias bias_nstack
Xbias_nstack_3[6] bias_nstack_6/shld2 bias_nstack_6/shld3 sub sub nbias level_shift_4/out
+ ncasc sink_ibias bias_nstack
Xbias_nstack_3[7] bias_nstack_6/shld2 bias_nstack_6/shld3 sub sub nbias level_shift_4/out
+ ncasc sink_ibias bias_nstack
Xsg13cmos5l_inv_2_3 level_shift_6/in_n sink_ena[1] dvdd dvss sg13cmos5l_inv_2
Xbias_nstack_4[0] bias_nstack_6/shld2 bias_nstack_6/shld3 sub sub nbias level_shift_5/out
+ ncasc sink_ibias bias_nstack
Xbias_nstack_4[1] bias_nstack_6/shld2 bias_nstack_6/shld3 sub sub nbias level_shift_5/out
+ ncasc sink_ibias bias_nstack
Xbias_nstack_4[2] bias_nstack_6/shld2 bias_nstack_6/shld3 sub sub nbias level_shift_5/out
+ ncasc sink_ibias bias_nstack
Xbias_nstack_4[3] bias_nstack_6/shld2 bias_nstack_6/shld3 sub sub nbias level_shift_5/out
+ ncasc sink_ibias bias_nstack
Xsg13cmos5l_inv_2_4 level_shift_0/in_n sink_ena[7] dvdd dvss sg13cmos5l_inv_2
Xbias_nstack_5[0] bias_nstack_6/shld2 bias_nstack_6/shld3 sub bias_nstack_5[1]/a_1030_2157#
+ nbias level_shift_6/out ncasc sink_ibias bias_nstack
Xbias_nstack_5[1] bias_nstack_6/shld2 bias_nstack_6/shld3 sub bias_nstack_5[1]/a_1030_2157#
+ nbias level_shift_6/out ncasc sink_ibias bias_nstack
Xsg13cmos5l_inv_2_5 level_shift_1/in_n sink_ena[6] dvdd dvss sg13cmos5l_inv_2
Xbias_nstack_6 bias_nstack_6/shld2 bias_nstack_6/shld3 sub bias_nstack_6/a_1030_2157#
+ nbias level_shift_7/out ncasc sink_ibias bias_nstack
Xsg13cmos5l_inv_2_6 level_shift_3/in_n sink_ena[4] dvdd dvss sg13cmos5l_inv_2
Xbias_nstack_7[0] bias_nstack_6/shld2 bias_nstack_6/shld3 sub sub nbias level_shift_0/out
+ ncasc sink_ibias bias_nstack
Xbias_nstack_7[1] bias_nstack_6/shld2 bias_nstack_6/shld3 sub sub nbias level_shift_0/out
+ ncasc sink_ibias bias_nstack
Xbias_nstack_7[2] bias_nstack_6/shld2 bias_nstack_6/shld3 sub sub nbias level_shift_0/out
+ ncasc sink_ibias bias_nstack
Xbias_nstack_7[3] bias_nstack_6/shld2 bias_nstack_6/shld3 sub sub nbias level_shift_0/out
+ ncasc sink_ibias bias_nstack
Xbias_nstack_7[4] bias_nstack_6/shld2 bias_nstack_6/shld3 sub sub nbias level_shift_0/out
+ ncasc sink_ibias bias_nstack
Xbias_nstack_7[5] bias_nstack_6/shld2 bias_nstack_6/shld3 sub sub nbias level_shift_0/out
+ ncasc sink_ibias bias_nstack
Xbias_nstack_7[6] bias_nstack_6/shld2 bias_nstack_6/shld3 sub sub nbias level_shift_0/out
+ ncasc sink_ibias bias_nstack
Xbias_nstack_7[7] bias_nstack_6/shld2 bias_nstack_6/shld3 sub sub nbias level_shift_0/out
+ ncasc sink_ibias bias_nstack
Xbias_nstack_7[8] bias_nstack_6/shld2 bias_nstack_6/shld3 sub sub nbias level_shift_0/out
+ ncasc sink_ibias bias_nstack
Xbias_nstack_7[9] bias_nstack_6/shld2 bias_nstack_6/shld3 sub sub nbias level_shift_0/out
+ ncasc sink_ibias bias_nstack
Xbias_nstack_7[10] bias_nstack_6/shld2 bias_nstack_6/shld3 sub sub nbias level_shift_0/out
+ ncasc sink_ibias bias_nstack
Xbias_nstack_7[11] bias_nstack_6/shld2 bias_nstack_6/shld3 sub sub nbias level_shift_0/out
+ ncasc sink_ibias bias_nstack
Xbias_nstack_7[12] bias_nstack_6/shld2 bias_nstack_6/shld3 sub sub nbias level_shift_0/out
+ ncasc sink_ibias bias_nstack
Xbias_nstack_7[13] bias_nstack_6/shld2 bias_nstack_6/shld3 sub sub nbias level_shift_0/out
+ ncasc sink_ibias bias_nstack
Xbias_nstack_7[14] bias_nstack_6/shld2 bias_nstack_6/shld3 sub sub nbias level_shift_0/out
+ ncasc sink_ibias bias_nstack
Xbias_nstack_7[15] bias_nstack_6/shld2 bias_nstack_6/shld3 sub sub nbias level_shift_0/out
+ ncasc sink_ibias bias_nstack
Xbias_nstack_7[16] bias_nstack_6/shld2 bias_nstack_6/shld3 sub sub nbias level_shift_0/out
+ ncasc sink_ibias bias_nstack
Xbias_nstack_7[17] bias_nstack_6/shld2 bias_nstack_6/shld3 sub sub nbias level_shift_0/out
+ ncasc sink_ibias bias_nstack
Xbias_nstack_7[18] bias_nstack_6/shld2 bias_nstack_6/shld3 sub sub nbias level_shift_0/out
+ ncasc sink_ibias bias_nstack
Xbias_nstack_7[19] bias_nstack_6/shld2 bias_nstack_6/shld3 sub sub nbias level_shift_0/out
+ ncasc sink_ibias bias_nstack
Xbias_nstack_7[20] bias_nstack_6/shld2 bias_nstack_6/shld3 sub sub nbias level_shift_0/out
+ ncasc sink_ibias bias_nstack
Xbias_nstack_7[21] bias_nstack_6/shld2 bias_nstack_6/shld3 sub sub nbias level_shift_0/out
+ ncasc sink_ibias bias_nstack
Xbias_nstack_7[22] bias_nstack_6/shld2 bias_nstack_6/shld3 sub sub nbias level_shift_0/out
+ ncasc sink_ibias bias_nstack
Xbias_nstack_7[23] bias_nstack_6/shld2 bias_nstack_6/shld3 sub sub nbias level_shift_0/out
+ ncasc sink_ibias bias_nstack
Xbias_nstack_7[24] bias_nstack_6/shld2 bias_nstack_6/shld3 sub sub nbias level_shift_0/out
+ ncasc sink_ibias bias_nstack
Xbias_nstack_7[25] bias_nstack_6/shld2 bias_nstack_6/shld3 sub sub nbias level_shift_0/out
+ ncasc sink_ibias bias_nstack
Xbias_nstack_7[26] bias_nstack_6/shld2 bias_nstack_6/shld3 sub sub nbias level_shift_0/out
+ ncasc sink_ibias bias_nstack
Xbias_nstack_7[27] bias_nstack_6/shld2 bias_nstack_6/shld3 sub sub nbias level_shift_0/out
+ ncasc sink_ibias bias_nstack
Xbias_nstack_7[28] bias_nstack_6/shld2 bias_nstack_6/shld3 sub sub nbias level_shift_0/out
+ ncasc sink_ibias bias_nstack
Xbias_nstack_7[29] bias_nstack_6/shld2 bias_nstack_6/shld3 sub sub nbias level_shift_0/out
+ ncasc sink_ibias bias_nstack
Xbias_nstack_7[30] bias_nstack_6/shld2 bias_nstack_6/shld3 sub sub nbias level_shift_0/out
+ ncasc sink_ibias bias_nstack
Xbias_nstack_7[31] bias_nstack_6/shld2 bias_nstack_6/shld3 sub sub nbias level_shift_0/out
+ ncasc sink_ibias bias_nstack
Xbias_nstack_7[32] bias_nstack_6/shld2 bias_nstack_6/shld3 sub sub nbias level_shift_0/out
+ ncasc sink_ibias bias_nstack
Xbias_nstack_7[33] bias_nstack_6/shld2 bias_nstack_6/shld3 sub sub nbias level_shift_0/out
+ ncasc sink_ibias bias_nstack
Xbias_nstack_7[34] bias_nstack_6/shld2 bias_nstack_6/shld3 sub sub nbias level_shift_0/out
+ ncasc sink_ibias bias_nstack
Xbias_nstack_7[35] bias_nstack_6/shld2 bias_nstack_6/shld3 sub sub nbias level_shift_0/out
+ ncasc sink_ibias bias_nstack
Xbias_nstack_7[36] bias_nstack_6/shld2 bias_nstack_6/shld3 sub sub nbias level_shift_0/out
+ ncasc sink_ibias bias_nstack
Xbias_nstack_7[37] bias_nstack_6/shld2 bias_nstack_6/shld3 sub sub nbias level_shift_0/out
+ ncasc sink_ibias bias_nstack
Xbias_nstack_7[38] bias_nstack_6/shld2 bias_nstack_6/shld3 sub sub nbias level_shift_0/out
+ ncasc sink_ibias bias_nstack
Xbias_nstack_7[39] bias_nstack_6/shld2 bias_nstack_6/shld3 sub sub nbias level_shift_0/out
+ ncasc sink_ibias bias_nstack
Xbias_nstack_7[40] bias_nstack_6/shld2 bias_nstack_6/shld3 sub sub nbias level_shift_0/out
+ ncasc sink_ibias bias_nstack
Xbias_nstack_7[41] bias_nstack_6/shld2 bias_nstack_6/shld3 sub sub nbias level_shift_0/out
+ ncasc sink_ibias bias_nstack
Xbias_nstack_7[42] bias_nstack_6/shld2 bias_nstack_6/shld3 sub sub nbias level_shift_0/out
+ ncasc sink_ibias bias_nstack
Xbias_nstack_7[43] bias_nstack_6/shld2 bias_nstack_6/shld3 sub sub nbias level_shift_0/out
+ ncasc sink_ibias bias_nstack
Xbias_nstack_7[44] bias_nstack_6/shld2 bias_nstack_6/shld3 sub sub nbias level_shift_0/out
+ ncasc sink_ibias bias_nstack
Xbias_nstack_7[45] bias_nstack_6/shld2 bias_nstack_6/shld3 sub sub nbias level_shift_0/out
+ ncasc sink_ibias bias_nstack
Xbias_nstack_7[46] bias_nstack_6/shld2 bias_nstack_6/shld3 sub sub nbias level_shift_0/out
+ ncasc sink_ibias bias_nstack
Xbias_nstack_7[47] bias_nstack_6/shld2 bias_nstack_6/shld3 sub sub nbias level_shift_0/out
+ ncasc sink_ibias bias_nstack
Xbias_nstack_7[48] bias_nstack_6/shld2 bias_nstack_6/shld3 sub sub nbias level_shift_0/out
+ ncasc sink_ibias bias_nstack
Xbias_nstack_7[49] bias_nstack_6/shld2 bias_nstack_6/shld3 sub sub nbias level_shift_0/out
+ ncasc sink_ibias bias_nstack
Xbias_nstack_7[50] bias_nstack_6/shld2 bias_nstack_6/shld3 sub sub nbias level_shift_0/out
+ ncasc sink_ibias bias_nstack
Xbias_nstack_7[51] bias_nstack_6/shld2 bias_nstack_6/shld3 sub sub nbias level_shift_0/out
+ ncasc sink_ibias bias_nstack
Xbias_nstack_7[52] bias_nstack_6/shld2 bias_nstack_6/shld3 sub sub nbias level_shift_0/out
+ ncasc sink_ibias bias_nstack
Xbias_nstack_7[53] bias_nstack_6/shld2 bias_nstack_6/shld3 sub sub nbias level_shift_0/out
+ ncasc sink_ibias bias_nstack
Xbias_nstack_7[54] bias_nstack_6/shld2 bias_nstack_6/shld3 sub sub nbias level_shift_0/out
+ ncasc sink_ibias bias_nstack
Xbias_nstack_7[55] bias_nstack_6/shld2 bias_nstack_6/shld3 sub sub nbias level_shift_0/out
+ ncasc sink_ibias bias_nstack
Xbias_nstack_7[56] bias_nstack_6/shld2 bias_nstack_6/shld3 sub sub nbias level_shift_0/out
+ ncasc sink_ibias bias_nstack
Xbias_nstack_7[57] bias_nstack_6/shld2 bias_nstack_6/shld3 sub sub nbias level_shift_0/out
+ ncasc sink_ibias bias_nstack
Xbias_nstack_7[58] bias_nstack_6/shld2 bias_nstack_6/shld3 sub sub nbias level_shift_0/out
+ ncasc sink_ibias bias_nstack
Xbias_nstack_7[59] bias_nstack_6/shld2 bias_nstack_6/shld3 sub sub nbias level_shift_0/out
+ ncasc sink_ibias bias_nstack
Xbias_nstack_7[60] bias_nstack_6/shld2 bias_nstack_6/shld3 sub sub nbias level_shift_0/out
+ ncasc sink_ibias bias_nstack
Xbias_nstack_7[61] bias_nstack_6/shld2 bias_nstack_6/shld3 sub sub nbias level_shift_0/out
+ ncasc sink_ibias bias_nstack
Xbias_nstack_7[62] bias_nstack_6/shld2 bias_nstack_6/shld3 sub sub nbias level_shift_0/out
+ ncasc sink_ibias bias_nstack
Xbias_nstack_7[63] bias_nstack_6/shld2 bias_nstack_6/shld3 sub sub nbias level_shift_0/out
+ ncasc sink_ibias bias_nstack
Xbias_nstack_7[64] bias_nstack_6/shld2 bias_nstack_6/shld3 sub sub nbias level_shift_0/out
+ ncasc sink_ibias bias_nstack
Xbias_nstack_7[65] bias_nstack_6/shld2 bias_nstack_6/shld3 sub sub nbias level_shift_0/out
+ ncasc sink_ibias bias_nstack
Xbias_nstack_7[66] bias_nstack_6/shld2 bias_nstack_6/shld3 sub sub nbias level_shift_0/out
+ ncasc sink_ibias bias_nstack
Xbias_nstack_7[67] bias_nstack_6/shld2 bias_nstack_6/shld3 sub sub nbias level_shift_0/out
+ ncasc sink_ibias bias_nstack
Xbias_nstack_7[68] bias_nstack_6/shld2 bias_nstack_6/shld3 sub sub nbias level_shift_0/out
+ ncasc sink_ibias bias_nstack
Xbias_nstack_7[69] bias_nstack_6/shld2 bias_nstack_6/shld3 sub sub nbias level_shift_0/out
+ ncasc sink_ibias bias_nstack
Xbias_nstack_7[70] bias_nstack_6/shld2 bias_nstack_6/shld3 sub sub nbias level_shift_0/out
+ ncasc sink_ibias bias_nstack
Xbias_nstack_7[71] bias_nstack_6/shld2 bias_nstack_6/shld3 sub sub nbias level_shift_0/out
+ ncasc sink_ibias bias_nstack
Xbias_nstack_7[72] bias_nstack_6/shld2 bias_nstack_6/shld3 sub sub nbias level_shift_0/out
+ ncasc sink_ibias bias_nstack
Xbias_nstack_7[73] bias_nstack_6/shld2 bias_nstack_6/shld3 sub sub nbias level_shift_0/out
+ ncasc sink_ibias bias_nstack
Xbias_nstack_7[74] bias_nstack_6/shld2 bias_nstack_6/shld3 sub sub nbias level_shift_0/out
+ ncasc sink_ibias bias_nstack
Xbias_nstack_7[75] bias_nstack_6/shld2 bias_nstack_6/shld3 sub sub nbias level_shift_0/out
+ ncasc sink_ibias bias_nstack
Xbias_nstack_7[76] bias_nstack_6/shld2 bias_nstack_6/shld3 sub sub nbias level_shift_0/out
+ ncasc sink_ibias bias_nstack
Xbias_nstack_7[77] bias_nstack_6/shld2 bias_nstack_6/shld3 sub sub nbias level_shift_0/out
+ ncasc sink_ibias bias_nstack
Xbias_nstack_7[78] bias_nstack_6/shld2 bias_nstack_6/shld3 sub sub nbias level_shift_0/out
+ ncasc sink_ibias bias_nstack
Xbias_nstack_7[79] bias_nstack_6/shld2 bias_nstack_6/shld3 sub sub nbias level_shift_0/out
+ ncasc sink_ibias bias_nstack
Xbias_nstack_7[80] bias_nstack_6/shld2 bias_nstack_6/shld3 sub sub nbias level_shift_0/out
+ ncasc sink_ibias bias_nstack
Xbias_nstack_7[81] bias_nstack_6/shld2 bias_nstack_6/shld3 sub sub nbias level_shift_0/out
+ ncasc sink_ibias bias_nstack
Xbias_nstack_7[82] bias_nstack_6/shld2 bias_nstack_6/shld3 sub sub nbias level_shift_0/out
+ ncasc sink_ibias bias_nstack
Xbias_nstack_7[83] bias_nstack_6/shld2 bias_nstack_6/shld3 sub sub nbias level_shift_0/out
+ ncasc sink_ibias bias_nstack
Xbias_nstack_7[84] bias_nstack_6/shld2 bias_nstack_6/shld3 sub sub nbias level_shift_0/out
+ ncasc sink_ibias bias_nstack
Xbias_nstack_7[85] bias_nstack_6/shld2 bias_nstack_6/shld3 sub sub nbias level_shift_0/out
+ ncasc sink_ibias bias_nstack
Xbias_nstack_7[86] bias_nstack_6/shld2 bias_nstack_6/shld3 sub sub nbias level_shift_0/out
+ ncasc sink_ibias bias_nstack
Xbias_nstack_7[87] bias_nstack_6/shld2 bias_nstack_6/shld3 sub sub nbias level_shift_0/out
+ ncasc sink_ibias bias_nstack
Xbias_nstack_7[88] bias_nstack_6/shld2 bias_nstack_6/shld3 sub sub nbias level_shift_0/out
+ ncasc sink_ibias bias_nstack
Xbias_nstack_7[89] bias_nstack_6/shld2 bias_nstack_6/shld3 sub sub nbias level_shift_0/out
+ ncasc sink_ibias bias_nstack
Xbias_nstack_7[90] bias_nstack_6/shld2 bias_nstack_6/shld3 sub sub nbias level_shift_0/out
+ ncasc sink_ibias bias_nstack
Xbias_nstack_7[91] bias_nstack_6/shld2 bias_nstack_6/shld3 sub sub nbias level_shift_0/out
+ ncasc sink_ibias bias_nstack
Xbias_nstack_7[92] bias_nstack_6/shld2 bias_nstack_6/shld3 sub sub nbias level_shift_0/out
+ ncasc sink_ibias bias_nstack
Xbias_nstack_7[93] bias_nstack_6/shld2 bias_nstack_6/shld3 sub sub nbias level_shift_0/out
+ ncasc sink_ibias bias_nstack
Xbias_nstack_7[94] bias_nstack_6/shld2 bias_nstack_6/shld3 sub sub nbias level_shift_0/out
+ ncasc sink_ibias bias_nstack
Xbias_nstack_7[95] bias_nstack_6/shld2 bias_nstack_6/shld3 sub sub nbias level_shift_0/out
+ ncasc sink_ibias bias_nstack
Xbias_nstack_7[96] bias_nstack_6/shld2 bias_nstack_6/shld3 sub sub nbias level_shift_0/out
+ ncasc sink_ibias bias_nstack
Xbias_nstack_7[97] bias_nstack_6/shld2 bias_nstack_6/shld3 sub sub nbias level_shift_0/out
+ ncasc sink_ibias bias_nstack
Xbias_nstack_7[98] bias_nstack_6/shld2 bias_nstack_6/shld3 sub sub nbias level_shift_0/out
+ ncasc sink_ibias bias_nstack
Xbias_nstack_7[99] bias_nstack_6/shld2 bias_nstack_6/shld3 sub sub nbias level_shift_0/out
+ ncasc sink_ibias bias_nstack
Xbias_nstack_7[100] bias_nstack_6/shld2 bias_nstack_6/shld3 sub sub nbias level_shift_0/out
+ ncasc sink_ibias bias_nstack
Xbias_nstack_7[101] bias_nstack_6/shld2 bias_nstack_6/shld3 sub sub nbias level_shift_0/out
+ ncasc sink_ibias bias_nstack
Xbias_nstack_7[102] bias_nstack_6/shld2 bias_nstack_6/shld3 sub sub nbias level_shift_0/out
+ ncasc sink_ibias bias_nstack
Xbias_nstack_7[103] bias_nstack_6/shld2 bias_nstack_6/shld3 sub sub nbias level_shift_0/out
+ ncasc sink_ibias bias_nstack
Xbias_nstack_7[104] bias_nstack_6/shld2 bias_nstack_6/shld3 sub sub nbias level_shift_0/out
+ ncasc sink_ibias bias_nstack
Xbias_nstack_7[105] bias_nstack_6/shld2 bias_nstack_6/shld3 sub sub nbias level_shift_0/out
+ ncasc sink_ibias bias_nstack
Xbias_nstack_7[106] bias_nstack_6/shld2 bias_nstack_6/shld3 sub sub nbias level_shift_0/out
+ ncasc sink_ibias bias_nstack
Xbias_nstack_7[107] bias_nstack_6/shld2 bias_nstack_6/shld3 sub sub nbias level_shift_0/out
+ ncasc sink_ibias bias_nstack
Xbias_nstack_7[108] bias_nstack_6/shld2 bias_nstack_6/shld3 sub sub nbias level_shift_0/out
+ ncasc sink_ibias bias_nstack
Xbias_nstack_7[109] bias_nstack_6/shld2 bias_nstack_6/shld3 sub sub nbias level_shift_0/out
+ ncasc sink_ibias bias_nstack
Xbias_nstack_7[110] bias_nstack_6/shld2 bias_nstack_6/shld3 sub sub nbias level_shift_0/out
+ ncasc sink_ibias bias_nstack
Xbias_nstack_7[111] bias_nstack_6/shld2 bias_nstack_6/shld3 sub sub nbias level_shift_0/out
+ ncasc sink_ibias bias_nstack
Xbias_nstack_7[112] bias_nstack_6/shld2 bias_nstack_6/shld3 sub sub nbias level_shift_0/out
+ ncasc sink_ibias bias_nstack
Xbias_nstack_7[113] bias_nstack_6/shld2 bias_nstack_6/shld3 sub sub nbias level_shift_0/out
+ ncasc sink_ibias bias_nstack
Xbias_nstack_7[114] bias_nstack_6/shld2 bias_nstack_6/shld3 sub sub nbias level_shift_0/out
+ ncasc sink_ibias bias_nstack
Xbias_nstack_7[115] bias_nstack_6/shld2 bias_nstack_6/shld3 sub sub nbias level_shift_0/out
+ ncasc sink_ibias bias_nstack
Xbias_nstack_7[116] bias_nstack_6/shld2 bias_nstack_6/shld3 sub sub nbias level_shift_0/out
+ ncasc sink_ibias bias_nstack
Xbias_nstack_7[117] bias_nstack_6/shld2 bias_nstack_6/shld3 sub sub nbias level_shift_0/out
+ ncasc sink_ibias bias_nstack
Xbias_nstack_7[118] bias_nstack_6/shld2 bias_nstack_6/shld3 sub sub nbias level_shift_0/out
+ ncasc sink_ibias bias_nstack
Xbias_nstack_7[119] bias_nstack_6/shld2 bias_nstack_6/shld3 sub sub nbias level_shift_0/out
+ ncasc sink_ibias bias_nstack
Xbias_nstack_7[120] bias_nstack_6/shld2 bias_nstack_6/shld3 sub sub nbias level_shift_0/out
+ ncasc sink_ibias bias_nstack
Xbias_nstack_7[121] bias_nstack_6/shld2 bias_nstack_6/shld3 sub sub nbias level_shift_0/out
+ ncasc sink_ibias bias_nstack
Xbias_nstack_7[122] bias_nstack_6/shld2 bias_nstack_6/shld3 sub sub nbias level_shift_0/out
+ ncasc sink_ibias bias_nstack
Xbias_nstack_7[123] bias_nstack_6/shld2 bias_nstack_6/shld3 sub sub nbias level_shift_0/out
+ ncasc sink_ibias bias_nstack
Xbias_nstack_7[124] bias_nstack_6/shld2 bias_nstack_6/shld3 sub sub nbias level_shift_0/out
+ ncasc sink_ibias bias_nstack
Xbias_nstack_7[125] bias_nstack_6/shld2 bias_nstack_6/shld3 sub sub nbias level_shift_0/out
+ ncasc sink_ibias bias_nstack
Xbias_nstack_7[126] bias_nstack_6/shld2 bias_nstack_6/shld3 sub sub nbias level_shift_0/out
+ ncasc sink_ibias bias_nstack
Xbias_nstack_7[127] bias_nstack_6/shld2 bias_nstack_6/shld3 sub sub nbias level_shift_0/out
+ ncasc sink_ibias bias_nstack
Xsg13cmos5l_inv_2_7 level_shift_5/in_n sink_ena[2] dvdd dvss sg13cmos5l_inv_2
Xsg13cmos5l_antennanp_0 sink_ena[3] dvdd dvss sg13cmos5l_antennanp
Xsg13cmos5l_antennanp_1 sink_ena[0] dvdd dvss sg13cmos5l_antennanp
Xsg13cmos5l_antennanp_2 sink_ena[5] dvdd dvss sg13cmos5l_antennanp
Xsg13cmos5l_antennanp_3 sink_ena[1] dvdd dvss sg13cmos5l_antennanp
Xsg13cmos5l_antennanp_4 sink_ena[7] dvdd dvss sg13cmos5l_antennanp
Xsg13cmos5l_antennanp_5 sink_ena[6] dvdd dvss sg13cmos5l_antennanp
Xsg13cmos5l_antennanp_6 sink_ena[4] dvdd dvss sg13cmos5l_antennanp
Xsg13cmos5l_antennanp_7 sink_ena[2] dvdd dvss sg13cmos5l_antennanp
Xlevel_shift_0 level_shift_0/in_n sink_ena[7] level_shift_7/vdd level_shift_0/out
+ sub level_shift
Xlevel_shift_1 level_shift_1/in_n sink_ena[6] level_shift_7/vdd level_shift_1/out
+ sub level_shift
Xlevel_shift_2 level_shift_2/in_n sink_ena[5] level_shift_7/vdd level_shift_2/out
+ sub level_shift
Xsg13cmos5l_decap_4_0 dvdd dvss sg13cmos5l_decap_4
Xsg13cmos5l_decap_4_1 dvdd dvss sg13cmos5l_decap_4
Xlevel_shift_3 level_shift_3/in_n sink_ena[4] level_shift_7/vdd level_shift_3/out
+ sub level_shift
Xlevel_shift_4 level_shift_4/in_n sink_ena[3] level_shift_7/vdd level_shift_4/out
+ sub level_shift
Xsg13cmos5l_decap_4_2 dvdd dvss sg13cmos5l_decap_4
Xlevel_shift_5 level_shift_5/in_n sink_ena[2] level_shift_7/vdd level_shift_5/out
+ sub level_shift
Xsg13cmos5l_decap_4_3 dvdd dvss sg13cmos5l_decap_4
Xlevel_shift_6 level_shift_6/in_n sink_ena[1] level_shift_7/vdd level_shift_6/out
+ sub level_shift
Xsg13cmos5l_decap_4_4 dvdd dvss sg13cmos5l_decap_4
Xlevel_shift_7 level_shift_7/in_n sink_ena[0] level_shift_7/vdd level_shift_7/out
+ sub level_shift
Xsg13cmos5l_decap_4_5 dvdd dvss sg13cmos5l_decap_4
Xsg13cmos5l_decap_4_6 dvdd dvss sg13cmos5l_decap_4
Xsg13cmos5l_decap_4_7 dvdd dvss sg13cmos5l_decap_4
.ends

.subckt bias_generator_be0n avdd avss dvdd bias_nstack_3/shld2 sink_ena[3] sink_ena[2]
+ bias_nstack_3/a_1030_2157# sink_ena[0] nbias sink_ena[1] ncasc level_shift_4/vdd
+ sink_ibias sub sink_ena[4] dvss bias_nstack_3/shld3
Xbias_nstack_0[0] bias_nstack_3/shld2 bias_nstack_3/shld3 sub sub nbias level_shift_2/out
+ ncasc sink_ibias bias_nstack
Xbias_nstack_0[1] bias_nstack_3/shld2 bias_nstack_3/shld3 sub sub nbias level_shift_2/out
+ ncasc sink_ibias bias_nstack
Xbias_nstack_0[2] bias_nstack_3/shld2 bias_nstack_3/shld3 sub sub nbias level_shift_2/out
+ ncasc sink_ibias bias_nstack
Xbias_nstack_0[3] bias_nstack_3/shld2 bias_nstack_3/shld3 sub sub nbias level_shift_2/out
+ ncasc sink_ibias bias_nstack
Xbias_nstack_0[4] bias_nstack_3/shld2 bias_nstack_3/shld3 sub sub nbias level_shift_2/out
+ ncasc sink_ibias bias_nstack
Xbias_nstack_0[5] bias_nstack_3/shld2 bias_nstack_3/shld3 sub sub nbias level_shift_2/out
+ ncasc sink_ibias bias_nstack
Xbias_nstack_0[6] bias_nstack_3/shld2 bias_nstack_3/shld3 sub sub nbias level_shift_2/out
+ ncasc sink_ibias bias_nstack
Xbias_nstack_0[7] bias_nstack_3/shld2 bias_nstack_3/shld3 sub sub nbias level_shift_2/out
+ ncasc sink_ibias bias_nstack
Xsg13cmos5l_inv_2_0 level_shift_2/in_n sink_ena[3] dvdd dvss sg13cmos5l_inv_2
Xbias_nstack_1[0] bias_nstack_3/shld2 bias_nstack_3/shld3 sub sub nbias level_shift_1/out
+ ncasc sink_ibias bias_nstack
Xbias_nstack_1[1] bias_nstack_3/shld2 bias_nstack_3/shld3 sub sub nbias level_shift_1/out
+ ncasc sink_ibias bias_nstack
Xbias_nstack_1[2] bias_nstack_3/shld2 bias_nstack_3/shld3 sub sub nbias level_shift_1/out
+ ncasc sink_ibias bias_nstack
Xbias_nstack_1[3] bias_nstack_3/shld2 bias_nstack_3/shld3 sub sub nbias level_shift_1/out
+ ncasc sink_ibias bias_nstack
Xsg13cmos5l_inv_2_1 level_shift_0/in_n sink_ena[1] dvdd dvss sg13cmos5l_inv_2
Xbias_nstack_2[0] bias_nstack_3/shld2 bias_nstack_3/shld3 sub bias_nstack_2[1]/a_1030_2157#
+ nbias level_shift_0/out ncasc sink_ibias bias_nstack
Xbias_nstack_2[1] bias_nstack_3/shld2 bias_nstack_3/shld3 sub bias_nstack_2[1]/a_1030_2157#
+ nbias level_shift_0/out ncasc sink_ibias bias_nstack
Xsg13cmos5l_inv_2_2 level_shift_1/in_n sink_ena[2] dvdd dvss sg13cmos5l_inv_2
Xbias_nstack_3 bias_nstack_3/shld2 bias_nstack_3/shld3 sub bias_nstack_3/a_1030_2157#
+ nbias level_shift_4/out ncasc sink_ibias bias_nstack
Xsg13cmos5l_inv_2_3 level_shift_3/in_n sink_ena[4] dvdd dvss sg13cmos5l_inv_2
Xbias_nstack_4[0] bias_nstack_3/shld2 bias_nstack_3/shld3 sub sub nbias level_shift_3/out
+ ncasc sink_ibias bias_nstack
Xbias_nstack_4[1] bias_nstack_3/shld2 bias_nstack_3/shld3 sub sub nbias level_shift_3/out
+ ncasc sink_ibias bias_nstack
Xbias_nstack_4[2] bias_nstack_3/shld2 bias_nstack_3/shld3 sub sub nbias level_shift_3/out
+ ncasc sink_ibias bias_nstack
Xbias_nstack_4[3] bias_nstack_3/shld2 bias_nstack_3/shld3 sub sub nbias level_shift_3/out
+ ncasc sink_ibias bias_nstack
Xbias_nstack_4[4] bias_nstack_3/shld2 bias_nstack_3/shld3 sub sub nbias level_shift_3/out
+ ncasc sink_ibias bias_nstack
Xbias_nstack_4[5] bias_nstack_3/shld2 bias_nstack_3/shld3 sub sub nbias level_shift_3/out
+ ncasc sink_ibias bias_nstack
Xbias_nstack_4[6] bias_nstack_3/shld2 bias_nstack_3/shld3 sub sub nbias level_shift_3/out
+ ncasc sink_ibias bias_nstack
Xbias_nstack_4[7] bias_nstack_3/shld2 bias_nstack_3/shld3 sub sub nbias level_shift_3/out
+ ncasc sink_ibias bias_nstack
Xbias_nstack_4[8] bias_nstack_3/shld2 bias_nstack_3/shld3 sub sub nbias level_shift_3/out
+ ncasc sink_ibias bias_nstack
Xbias_nstack_4[9] bias_nstack_3/shld2 bias_nstack_3/shld3 sub sub nbias level_shift_3/out
+ ncasc sink_ibias bias_nstack
Xbias_nstack_4[10] bias_nstack_3/shld2 bias_nstack_3/shld3 sub sub nbias level_shift_3/out
+ ncasc sink_ibias bias_nstack
Xbias_nstack_4[11] bias_nstack_3/shld2 bias_nstack_3/shld3 sub sub nbias level_shift_3/out
+ ncasc sink_ibias bias_nstack
Xbias_nstack_4[12] bias_nstack_3/shld2 bias_nstack_3/shld3 sub sub nbias level_shift_3/out
+ ncasc sink_ibias bias_nstack
Xbias_nstack_4[13] bias_nstack_3/shld2 bias_nstack_3/shld3 sub sub nbias level_shift_3/out
+ ncasc sink_ibias bias_nstack
Xbias_nstack_4[14] bias_nstack_3/shld2 bias_nstack_3/shld3 sub sub nbias level_shift_3/out
+ ncasc sink_ibias bias_nstack
Xbias_nstack_4[15] bias_nstack_3/shld2 bias_nstack_3/shld3 sub sub nbias level_shift_3/out
+ ncasc sink_ibias bias_nstack
Xsg13cmos5l_inv_2_4 level_shift_4/in_n sink_ena[0] dvdd dvss sg13cmos5l_inv_2
Xsg13cmos5l_antennanp_0 sink_ena[3] dvdd dvss sg13cmos5l_antennanp
Xsg13cmos5l_antennanp_1 sink_ena[1] dvdd dvss sg13cmos5l_antennanp
Xsg13cmos5l_antennanp_2 sink_ena[2] dvdd dvss sg13cmos5l_antennanp
Xsg13cmos5l_antennanp_3 sink_ena[4] dvdd dvss sg13cmos5l_antennanp
Xsg13cmos5l_antennanp_4 sink_ena[0] dvdd dvss sg13cmos5l_antennanp
Xlevel_shift_0 level_shift_0/in_n sink_ena[1] level_shift_4/vdd level_shift_0/out
+ sub level_shift
Xlevel_shift_1 level_shift_1/in_n sink_ena[2] level_shift_4/vdd level_shift_1/out
+ sub level_shift
Xsg13cmos5l_decap_4_0 dvdd dvss sg13cmos5l_decap_4
Xlevel_shift_2 level_shift_2/in_n sink_ena[3] level_shift_4/vdd level_shift_2/out
+ sub level_shift
Xlevel_shift_3 level_shift_3/in_n sink_ena[4] level_shift_4/vdd level_shift_3/out
+ sub level_shift
Xsg13cmos5l_decap_4_1 dvdd dvss sg13cmos5l_decap_4
Xlevel_shift_4 level_shift_4/in_n sink_ena[0] level_shift_4/vdd level_shift_4/out
+ sub level_shift
Xsg13cmos5l_decap_4_2 dvdd dvss sg13cmos5l_decap_4
Xsg13cmos5l_decap_4_3 dvdd dvss sg13cmos5l_decap_4
Xsg13cmos5l_decap_4_4 dvdd dvss sg13cmos5l_decap_4
.ends

.subckt bias_generator_be0p pcasc source_ibias source_ena[2] dvdd source_ena[1] bias_pstack_3/avdd
+ source_ena[4] sub source_ena[0] avdd bias_pstack_3/shld3 source_ena[3] bias_pstack_3/shld2
+ pbias dvss
Xsg13cmos5l_inv_2_0 level_shift_0/in_p source_ena[1] dvdd dvss sg13cmos5l_inv_2
Xsg13cmos5l_inv_2_1 level_shift_2/in_p source_ena[3] dvdd dvss sg13cmos5l_inv_2
Xsg13cmos5l_inv_2_2 level_shift_3/in_p source_ena[4] dvdd dvss sg13cmos5l_inv_2
Xsg13cmos5l_inv_2_4 level_shift_1/in_p source_ena[2] dvdd dvss sg13cmos5l_inv_2
Xsg13cmos5l_inv_2_3 level_shift_4/in_p source_ena[0] dvdd dvss sg13cmos5l_inv_2
Xsg13cmos5l_antennanp_0 source_ena[1] dvdd dvss sg13cmos5l_antennanp
Xsg13cmos5l_antennanp_1 source_ena[3] dvdd dvss sg13cmos5l_antennanp
Xbias_pstack_0[0] bias_pstack_3/avdd source_ibias bias_pstack_3/shld2 bias_pstack_3/shld3
+ level_shift_2/out pbias pcasc bias_pstack
Xbias_pstack_0[1] bias_pstack_3/avdd source_ibias bias_pstack_3/shld2 bias_pstack_3/shld3
+ level_shift_2/out pbias pcasc bias_pstack
Xbias_pstack_0[2] bias_pstack_3/avdd source_ibias bias_pstack_3/shld2 bias_pstack_3/shld3
+ level_shift_2/out pbias pcasc bias_pstack
Xbias_pstack_0[3] bias_pstack_3/avdd source_ibias bias_pstack_3/shld2 bias_pstack_3/shld3
+ level_shift_2/out pbias pcasc bias_pstack
Xbias_pstack_0[4] bias_pstack_3/avdd source_ibias bias_pstack_3/shld2 bias_pstack_3/shld3
+ level_shift_2/out pbias pcasc bias_pstack
Xbias_pstack_0[5] bias_pstack_3/avdd source_ibias bias_pstack_3/shld2 bias_pstack_3/shld3
+ level_shift_2/out pbias pcasc bias_pstack
Xbias_pstack_0[6] bias_pstack_3/avdd source_ibias bias_pstack_3/shld2 bias_pstack_3/shld3
+ level_shift_2/out pbias pcasc bias_pstack
Xbias_pstack_0[7] bias_pstack_3/avdd source_ibias bias_pstack_3/shld2 bias_pstack_3/shld3
+ level_shift_2/out pbias pcasc bias_pstack
Xsg13cmos5l_antennanp_2 source_ena[4] dvdd dvss sg13cmos5l_antennanp
Xbias_pstack_1[0] bias_pstack_3/avdd source_ibias bias_pstack_3/shld2 bias_pstack_3/shld3
+ level_shift_1/out pbias pcasc bias_pstack
Xbias_pstack_1[1] bias_pstack_3/avdd source_ibias bias_pstack_3/shld2 bias_pstack_3/shld3
+ level_shift_1/out pbias pcasc bias_pstack
Xbias_pstack_1[2] bias_pstack_3/avdd source_ibias bias_pstack_3/shld2 bias_pstack_3/shld3
+ level_shift_1/out pbias pcasc bias_pstack
Xbias_pstack_1[3] bias_pstack_3/avdd source_ibias bias_pstack_3/shld2 bias_pstack_3/shld3
+ level_shift_1/out pbias pcasc bias_pstack
Xsg13cmos5l_antennanp_3 source_ena[0] dvdd dvss sg13cmos5l_antennanp
Xbias_pstack_2[0] bias_pstack_3/avdd source_ibias bias_pstack_3/shld2 bias_pstack_3/shld3
+ level_shift_0/out pbias pcasc bias_pstack
Xbias_pstack_2[1] bias_pstack_3/avdd source_ibias bias_pstack_3/shld2 bias_pstack_3/shld3
+ level_shift_0/out pbias pcasc bias_pstack
Xbias_pstack_4[0] bias_pstack_3/avdd source_ibias bias_pstack_3/shld2 bias_pstack_3/shld3
+ level_shift_3/out pbias pcasc bias_pstack
Xbias_pstack_4[1] bias_pstack_3/avdd source_ibias bias_pstack_3/shld2 bias_pstack_3/shld3
+ level_shift_3/out pbias pcasc bias_pstack
Xbias_pstack_4[2] bias_pstack_3/avdd source_ibias bias_pstack_3/shld2 bias_pstack_3/shld3
+ level_shift_3/out pbias pcasc bias_pstack
Xbias_pstack_4[3] bias_pstack_3/avdd source_ibias bias_pstack_3/shld2 bias_pstack_3/shld3
+ level_shift_3/out pbias pcasc bias_pstack
Xbias_pstack_4[4] bias_pstack_3/avdd source_ibias bias_pstack_3/shld2 bias_pstack_3/shld3
+ level_shift_3/out pbias pcasc bias_pstack
Xbias_pstack_4[5] bias_pstack_3/avdd source_ibias bias_pstack_3/shld2 bias_pstack_3/shld3
+ level_shift_3/out pbias pcasc bias_pstack
Xbias_pstack_4[6] bias_pstack_3/avdd source_ibias bias_pstack_3/shld2 bias_pstack_3/shld3
+ level_shift_3/out pbias pcasc bias_pstack
Xbias_pstack_4[7] bias_pstack_3/avdd source_ibias bias_pstack_3/shld2 bias_pstack_3/shld3
+ level_shift_3/out pbias pcasc bias_pstack
Xbias_pstack_4[8] bias_pstack_3/avdd source_ibias bias_pstack_3/shld2 bias_pstack_3/shld3
+ level_shift_3/out pbias pcasc bias_pstack
Xbias_pstack_4[9] bias_pstack_3/avdd source_ibias bias_pstack_3/shld2 bias_pstack_3/shld3
+ level_shift_3/out pbias pcasc bias_pstack
Xbias_pstack_4[10] bias_pstack_3/avdd source_ibias bias_pstack_3/shld2 bias_pstack_3/shld3
+ level_shift_3/out pbias pcasc bias_pstack
Xbias_pstack_4[11] bias_pstack_3/avdd source_ibias bias_pstack_3/shld2 bias_pstack_3/shld3
+ level_shift_3/out pbias pcasc bias_pstack
Xbias_pstack_4[12] bias_pstack_3/avdd source_ibias bias_pstack_3/shld2 bias_pstack_3/shld3
+ level_shift_3/out pbias pcasc bias_pstack
Xbias_pstack_4[13] bias_pstack_3/avdd source_ibias bias_pstack_3/shld2 bias_pstack_3/shld3
+ level_shift_3/out pbias pcasc bias_pstack
Xbias_pstack_4[14] bias_pstack_3/avdd source_ibias bias_pstack_3/shld2 bias_pstack_3/shld3
+ level_shift_3/out pbias pcasc bias_pstack
Xbias_pstack_4[15] bias_pstack_3/avdd source_ibias bias_pstack_3/shld2 bias_pstack_3/shld3
+ level_shift_3/out pbias pcasc bias_pstack
Xsg13cmos5l_antennanp_4 source_ena[2] dvdd dvss sg13cmos5l_antennanp
Xbias_pstack_3 bias_pstack_3/avdd source_ibias bias_pstack_3/shld2 bias_pstack_3/shld3
+ level_shift_4/out pbias pcasc bias_pstack
Xlevel_shift_0 source_ena[1] level_shift_0/in_p avdd level_shift_0/out sub level_shift
Xlevel_shift_1 source_ena[2] level_shift_1/in_p avdd level_shift_1/out sub level_shift
Xlevel_shift_2 source_ena[3] level_shift_2/in_p avdd level_shift_2/out sub level_shift
Xsg13cmos5l_decap_4_0 dvdd dvss sg13cmos5l_decap_4
Xsg13cmos5l_decap_4_1 dvdd dvss sg13cmos5l_decap_4
Xlevel_shift_3 source_ena[4] level_shift_3/in_p avdd level_shift_3/out sub level_shift
Xsg13cmos5l_decap_4_2 dvdd dvss sg13cmos5l_decap_4
Xlevel_shift_4 source_ena[0] level_shift_4/in_p avdd level_shift_4/out sub level_shift
Xsg13cmos5l_decap_4_3 dvdd dvss sg13cmos5l_decap_4
Xsg13cmos5l_decap_4_4 dvdd dvss sg13cmos5l_decap_4
.ends

.subckt bias_generator_be1p pcasc source_ena[6] source_ena[5] source_ena[1] source_ibias
+ source_ena[4] sub source_ena[7] source_ena[3] source_ena[0] avdd source_ena[2] dvdd
+ dvss pbias bias_pstack_6/shld3 bias_pstack_6/avdd bias_pstack_6/shld2
Xsg13cmos5l_inv_2_0 level_shift_2/in_p source_ena[5] dvdd dvss sg13cmos5l_inv_2
Xsg13cmos5l_inv_2_1 level_shift_4/in_p source_ena[3] dvdd dvss sg13cmos5l_inv_2
Xsg13cmos5l_inv_2_2 level_shift_6/in_p source_ena[1] dvdd dvss sg13cmos5l_inv_2
Xsg13cmos5l_inv_2_3 level_shift_7/in_p source_ena[0] dvdd dvss sg13cmos5l_inv_2
Xsg13cmos5l_inv_2_4 level_shift_0/in_p source_ena[7] dvdd dvss sg13cmos5l_inv_2
Xsg13cmos5l_inv_2_5 level_shift_1/in_p source_ena[6] dvdd dvss sg13cmos5l_inv_2
Xsg13cmos5l_inv_2_6 level_shift_3/in_p source_ena[4] dvdd dvss sg13cmos5l_inv_2
Xsg13cmos5l_inv_2_7 level_shift_5/in_p source_ena[2] dvdd dvss sg13cmos5l_inv_2
Xsg13cmos5l_antennanp_0 source_ena[5] dvdd dvss sg13cmos5l_antennanp
Xbias_pstack_0[0] bias_pstack_6/avdd source_ibias bias_pstack_6/shld2 bias_pstack_6/shld3
+ level_shift_1/out pbias pcasc bias_pstack
Xbias_pstack_0[1] bias_pstack_6/avdd source_ibias bias_pstack_6/shld2 bias_pstack_6/shld3
+ level_shift_1/out pbias pcasc bias_pstack
Xbias_pstack_0[2] bias_pstack_6/avdd source_ibias bias_pstack_6/shld2 bias_pstack_6/shld3
+ level_shift_1/out pbias pcasc bias_pstack
Xbias_pstack_0[3] bias_pstack_6/avdd source_ibias bias_pstack_6/shld2 bias_pstack_6/shld3
+ level_shift_1/out pbias pcasc bias_pstack
Xbias_pstack_0[4] bias_pstack_6/avdd source_ibias bias_pstack_6/shld2 bias_pstack_6/shld3
+ level_shift_1/out pbias pcasc bias_pstack
Xbias_pstack_0[5] bias_pstack_6/avdd source_ibias bias_pstack_6/shld2 bias_pstack_6/shld3
+ level_shift_1/out pbias pcasc bias_pstack
Xbias_pstack_0[6] bias_pstack_6/avdd source_ibias bias_pstack_6/shld2 bias_pstack_6/shld3
+ level_shift_1/out pbias pcasc bias_pstack
Xbias_pstack_0[7] bias_pstack_6/avdd source_ibias bias_pstack_6/shld2 bias_pstack_6/shld3
+ level_shift_1/out pbias pcasc bias_pstack
Xbias_pstack_0[8] bias_pstack_6/avdd source_ibias bias_pstack_6/shld2 bias_pstack_6/shld3
+ level_shift_1/out pbias pcasc bias_pstack
Xbias_pstack_0[9] bias_pstack_6/avdd source_ibias bias_pstack_6/shld2 bias_pstack_6/shld3
+ level_shift_1/out pbias pcasc bias_pstack
Xbias_pstack_0[10] bias_pstack_6/avdd source_ibias bias_pstack_6/shld2 bias_pstack_6/shld3
+ level_shift_1/out pbias pcasc bias_pstack
Xbias_pstack_0[11] bias_pstack_6/avdd source_ibias bias_pstack_6/shld2 bias_pstack_6/shld3
+ level_shift_1/out pbias pcasc bias_pstack
Xbias_pstack_0[12] bias_pstack_6/avdd source_ibias bias_pstack_6/shld2 bias_pstack_6/shld3
+ level_shift_1/out pbias pcasc bias_pstack
Xbias_pstack_0[13] bias_pstack_6/avdd source_ibias bias_pstack_6/shld2 bias_pstack_6/shld3
+ level_shift_1/out pbias pcasc bias_pstack
Xbias_pstack_0[14] bias_pstack_6/avdd source_ibias bias_pstack_6/shld2 bias_pstack_6/shld3
+ level_shift_1/out pbias pcasc bias_pstack
Xbias_pstack_0[15] bias_pstack_6/avdd source_ibias bias_pstack_6/shld2 bias_pstack_6/shld3
+ level_shift_1/out pbias pcasc bias_pstack
Xbias_pstack_0[16] bias_pstack_6/avdd source_ibias bias_pstack_6/shld2 bias_pstack_6/shld3
+ level_shift_1/out pbias pcasc bias_pstack
Xbias_pstack_0[17] bias_pstack_6/avdd source_ibias bias_pstack_6/shld2 bias_pstack_6/shld3
+ level_shift_1/out pbias pcasc bias_pstack
Xbias_pstack_0[18] bias_pstack_6/avdd source_ibias bias_pstack_6/shld2 bias_pstack_6/shld3
+ level_shift_1/out pbias pcasc bias_pstack
Xbias_pstack_0[19] bias_pstack_6/avdd source_ibias bias_pstack_6/shld2 bias_pstack_6/shld3
+ level_shift_1/out pbias pcasc bias_pstack
Xbias_pstack_0[20] bias_pstack_6/avdd source_ibias bias_pstack_6/shld2 bias_pstack_6/shld3
+ level_shift_1/out pbias pcasc bias_pstack
Xbias_pstack_0[21] bias_pstack_6/avdd source_ibias bias_pstack_6/shld2 bias_pstack_6/shld3
+ level_shift_1/out pbias pcasc bias_pstack
Xbias_pstack_0[22] bias_pstack_6/avdd source_ibias bias_pstack_6/shld2 bias_pstack_6/shld3
+ level_shift_1/out pbias pcasc bias_pstack
Xbias_pstack_0[23] bias_pstack_6/avdd source_ibias bias_pstack_6/shld2 bias_pstack_6/shld3
+ level_shift_1/out pbias pcasc bias_pstack
Xbias_pstack_0[24] bias_pstack_6/avdd source_ibias bias_pstack_6/shld2 bias_pstack_6/shld3
+ level_shift_1/out pbias pcasc bias_pstack
Xbias_pstack_0[25] bias_pstack_6/avdd source_ibias bias_pstack_6/shld2 bias_pstack_6/shld3
+ level_shift_1/out pbias pcasc bias_pstack
Xbias_pstack_0[26] bias_pstack_6/avdd source_ibias bias_pstack_6/shld2 bias_pstack_6/shld3
+ level_shift_1/out pbias pcasc bias_pstack
Xbias_pstack_0[27] bias_pstack_6/avdd source_ibias bias_pstack_6/shld2 bias_pstack_6/shld3
+ level_shift_1/out pbias pcasc bias_pstack
Xbias_pstack_0[28] bias_pstack_6/avdd source_ibias bias_pstack_6/shld2 bias_pstack_6/shld3
+ level_shift_1/out pbias pcasc bias_pstack
Xbias_pstack_0[29] bias_pstack_6/avdd source_ibias bias_pstack_6/shld2 bias_pstack_6/shld3
+ level_shift_1/out pbias pcasc bias_pstack
Xbias_pstack_0[30] bias_pstack_6/avdd source_ibias bias_pstack_6/shld2 bias_pstack_6/shld3
+ level_shift_1/out pbias pcasc bias_pstack
Xbias_pstack_0[31] bias_pstack_6/avdd source_ibias bias_pstack_6/shld2 bias_pstack_6/shld3
+ level_shift_1/out pbias pcasc bias_pstack
Xbias_pstack_0[32] bias_pstack_6/avdd source_ibias bias_pstack_6/shld2 bias_pstack_6/shld3
+ level_shift_1/out pbias pcasc bias_pstack
Xbias_pstack_0[33] bias_pstack_6/avdd source_ibias bias_pstack_6/shld2 bias_pstack_6/shld3
+ level_shift_1/out pbias pcasc bias_pstack
Xbias_pstack_0[34] bias_pstack_6/avdd source_ibias bias_pstack_6/shld2 bias_pstack_6/shld3
+ level_shift_1/out pbias pcasc bias_pstack
Xbias_pstack_0[35] bias_pstack_6/avdd source_ibias bias_pstack_6/shld2 bias_pstack_6/shld3
+ level_shift_1/out pbias pcasc bias_pstack
Xbias_pstack_0[36] bias_pstack_6/avdd source_ibias bias_pstack_6/shld2 bias_pstack_6/shld3
+ level_shift_1/out pbias pcasc bias_pstack
Xbias_pstack_0[37] bias_pstack_6/avdd source_ibias bias_pstack_6/shld2 bias_pstack_6/shld3
+ level_shift_1/out pbias pcasc bias_pstack
Xbias_pstack_0[38] bias_pstack_6/avdd source_ibias bias_pstack_6/shld2 bias_pstack_6/shld3
+ level_shift_1/out pbias pcasc bias_pstack
Xbias_pstack_0[39] bias_pstack_6/avdd source_ibias bias_pstack_6/shld2 bias_pstack_6/shld3
+ level_shift_1/out pbias pcasc bias_pstack
Xbias_pstack_0[40] bias_pstack_6/avdd source_ibias bias_pstack_6/shld2 bias_pstack_6/shld3
+ level_shift_1/out pbias pcasc bias_pstack
Xbias_pstack_0[41] bias_pstack_6/avdd source_ibias bias_pstack_6/shld2 bias_pstack_6/shld3
+ level_shift_1/out pbias pcasc bias_pstack
Xbias_pstack_0[42] bias_pstack_6/avdd source_ibias bias_pstack_6/shld2 bias_pstack_6/shld3
+ level_shift_1/out pbias pcasc bias_pstack
Xbias_pstack_0[43] bias_pstack_6/avdd source_ibias bias_pstack_6/shld2 bias_pstack_6/shld3
+ level_shift_1/out pbias pcasc bias_pstack
Xbias_pstack_0[44] bias_pstack_6/avdd source_ibias bias_pstack_6/shld2 bias_pstack_6/shld3
+ level_shift_1/out pbias pcasc bias_pstack
Xbias_pstack_0[45] bias_pstack_6/avdd source_ibias bias_pstack_6/shld2 bias_pstack_6/shld3
+ level_shift_1/out pbias pcasc bias_pstack
Xbias_pstack_0[46] bias_pstack_6/avdd source_ibias bias_pstack_6/shld2 bias_pstack_6/shld3
+ level_shift_1/out pbias pcasc bias_pstack
Xbias_pstack_0[47] bias_pstack_6/avdd source_ibias bias_pstack_6/shld2 bias_pstack_6/shld3
+ level_shift_1/out pbias pcasc bias_pstack
Xbias_pstack_0[48] bias_pstack_6/avdd source_ibias bias_pstack_6/shld2 bias_pstack_6/shld3
+ level_shift_1/out pbias pcasc bias_pstack
Xbias_pstack_0[49] bias_pstack_6/avdd source_ibias bias_pstack_6/shld2 bias_pstack_6/shld3
+ level_shift_1/out pbias pcasc bias_pstack
Xbias_pstack_0[50] bias_pstack_6/avdd source_ibias bias_pstack_6/shld2 bias_pstack_6/shld3
+ level_shift_1/out pbias pcasc bias_pstack
Xbias_pstack_0[51] bias_pstack_6/avdd source_ibias bias_pstack_6/shld2 bias_pstack_6/shld3
+ level_shift_1/out pbias pcasc bias_pstack
Xbias_pstack_0[52] bias_pstack_6/avdd source_ibias bias_pstack_6/shld2 bias_pstack_6/shld3
+ level_shift_1/out pbias pcasc bias_pstack
Xbias_pstack_0[53] bias_pstack_6/avdd source_ibias bias_pstack_6/shld2 bias_pstack_6/shld3
+ level_shift_1/out pbias pcasc bias_pstack
Xbias_pstack_0[54] bias_pstack_6/avdd source_ibias bias_pstack_6/shld2 bias_pstack_6/shld3
+ level_shift_1/out pbias pcasc bias_pstack
Xbias_pstack_0[55] bias_pstack_6/avdd source_ibias bias_pstack_6/shld2 bias_pstack_6/shld3
+ level_shift_1/out pbias pcasc bias_pstack
Xbias_pstack_0[56] bias_pstack_6/avdd source_ibias bias_pstack_6/shld2 bias_pstack_6/shld3
+ level_shift_1/out pbias pcasc bias_pstack
Xbias_pstack_0[57] bias_pstack_6/avdd source_ibias bias_pstack_6/shld2 bias_pstack_6/shld3
+ level_shift_1/out pbias pcasc bias_pstack
Xbias_pstack_0[58] bias_pstack_6/avdd source_ibias bias_pstack_6/shld2 bias_pstack_6/shld3
+ level_shift_1/out pbias pcasc bias_pstack
Xbias_pstack_0[59] bias_pstack_6/avdd source_ibias bias_pstack_6/shld2 bias_pstack_6/shld3
+ level_shift_1/out pbias pcasc bias_pstack
Xbias_pstack_0[60] bias_pstack_6/avdd source_ibias bias_pstack_6/shld2 bias_pstack_6/shld3
+ level_shift_1/out pbias pcasc bias_pstack
Xbias_pstack_0[61] bias_pstack_6/avdd source_ibias bias_pstack_6/shld2 bias_pstack_6/shld3
+ level_shift_1/out pbias pcasc bias_pstack
Xbias_pstack_0[62] bias_pstack_6/avdd source_ibias bias_pstack_6/shld2 bias_pstack_6/shld3
+ level_shift_1/out pbias pcasc bias_pstack
Xbias_pstack_0[63] bias_pstack_6/avdd source_ibias bias_pstack_6/shld2 bias_pstack_6/shld3
+ level_shift_1/out pbias pcasc bias_pstack
Xsg13cmos5l_antennanp_1 source_ena[3] dvdd dvss sg13cmos5l_antennanp
Xbias_pstack_1[0] bias_pstack_6/avdd source_ibias bias_pstack_6/shld2 bias_pstack_6/shld3
+ level_shift_2/out pbias pcasc bias_pstack
Xbias_pstack_1[1] bias_pstack_6/avdd source_ibias bias_pstack_6/shld2 bias_pstack_6/shld3
+ level_shift_2/out pbias pcasc bias_pstack
Xbias_pstack_1[2] bias_pstack_6/avdd source_ibias bias_pstack_6/shld2 bias_pstack_6/shld3
+ level_shift_2/out pbias pcasc bias_pstack
Xbias_pstack_1[3] bias_pstack_6/avdd source_ibias bias_pstack_6/shld2 bias_pstack_6/shld3
+ level_shift_2/out pbias pcasc bias_pstack
Xbias_pstack_1[4] bias_pstack_6/avdd source_ibias bias_pstack_6/shld2 bias_pstack_6/shld3
+ level_shift_2/out pbias pcasc bias_pstack
Xbias_pstack_1[5] bias_pstack_6/avdd source_ibias bias_pstack_6/shld2 bias_pstack_6/shld3
+ level_shift_2/out pbias pcasc bias_pstack
Xbias_pstack_1[6] bias_pstack_6/avdd source_ibias bias_pstack_6/shld2 bias_pstack_6/shld3
+ level_shift_2/out pbias pcasc bias_pstack
Xbias_pstack_1[7] bias_pstack_6/avdd source_ibias bias_pstack_6/shld2 bias_pstack_6/shld3
+ level_shift_2/out pbias pcasc bias_pstack
Xbias_pstack_1[8] bias_pstack_6/avdd source_ibias bias_pstack_6/shld2 bias_pstack_6/shld3
+ level_shift_2/out pbias pcasc bias_pstack
Xbias_pstack_1[9] bias_pstack_6/avdd source_ibias bias_pstack_6/shld2 bias_pstack_6/shld3
+ level_shift_2/out pbias pcasc bias_pstack
Xbias_pstack_1[10] bias_pstack_6/avdd source_ibias bias_pstack_6/shld2 bias_pstack_6/shld3
+ level_shift_2/out pbias pcasc bias_pstack
Xbias_pstack_1[11] bias_pstack_6/avdd source_ibias bias_pstack_6/shld2 bias_pstack_6/shld3
+ level_shift_2/out pbias pcasc bias_pstack
Xbias_pstack_1[12] bias_pstack_6/avdd source_ibias bias_pstack_6/shld2 bias_pstack_6/shld3
+ level_shift_2/out pbias pcasc bias_pstack
Xbias_pstack_1[13] bias_pstack_6/avdd source_ibias bias_pstack_6/shld2 bias_pstack_6/shld3
+ level_shift_2/out pbias pcasc bias_pstack
Xbias_pstack_1[14] bias_pstack_6/avdd source_ibias bias_pstack_6/shld2 bias_pstack_6/shld3
+ level_shift_2/out pbias pcasc bias_pstack
Xbias_pstack_1[15] bias_pstack_6/avdd source_ibias bias_pstack_6/shld2 bias_pstack_6/shld3
+ level_shift_2/out pbias pcasc bias_pstack
Xbias_pstack_1[16] bias_pstack_6/avdd source_ibias bias_pstack_6/shld2 bias_pstack_6/shld3
+ level_shift_2/out pbias pcasc bias_pstack
Xbias_pstack_1[17] bias_pstack_6/avdd source_ibias bias_pstack_6/shld2 bias_pstack_6/shld3
+ level_shift_2/out pbias pcasc bias_pstack
Xbias_pstack_1[18] bias_pstack_6/avdd source_ibias bias_pstack_6/shld2 bias_pstack_6/shld3
+ level_shift_2/out pbias pcasc bias_pstack
Xbias_pstack_1[19] bias_pstack_6/avdd source_ibias bias_pstack_6/shld2 bias_pstack_6/shld3
+ level_shift_2/out pbias pcasc bias_pstack
Xbias_pstack_1[20] bias_pstack_6/avdd source_ibias bias_pstack_6/shld2 bias_pstack_6/shld3
+ level_shift_2/out pbias pcasc bias_pstack
Xbias_pstack_1[21] bias_pstack_6/avdd source_ibias bias_pstack_6/shld2 bias_pstack_6/shld3
+ level_shift_2/out pbias pcasc bias_pstack
Xbias_pstack_1[22] bias_pstack_6/avdd source_ibias bias_pstack_6/shld2 bias_pstack_6/shld3
+ level_shift_2/out pbias pcasc bias_pstack
Xbias_pstack_1[23] bias_pstack_6/avdd source_ibias bias_pstack_6/shld2 bias_pstack_6/shld3
+ level_shift_2/out pbias pcasc bias_pstack
Xbias_pstack_1[24] bias_pstack_6/avdd source_ibias bias_pstack_6/shld2 bias_pstack_6/shld3
+ level_shift_2/out pbias pcasc bias_pstack
Xbias_pstack_1[25] bias_pstack_6/avdd source_ibias bias_pstack_6/shld2 bias_pstack_6/shld3
+ level_shift_2/out pbias pcasc bias_pstack
Xbias_pstack_1[26] bias_pstack_6/avdd source_ibias bias_pstack_6/shld2 bias_pstack_6/shld3
+ level_shift_2/out pbias pcasc bias_pstack
Xbias_pstack_1[27] bias_pstack_6/avdd source_ibias bias_pstack_6/shld2 bias_pstack_6/shld3
+ level_shift_2/out pbias pcasc bias_pstack
Xbias_pstack_1[28] bias_pstack_6/avdd source_ibias bias_pstack_6/shld2 bias_pstack_6/shld3
+ level_shift_2/out pbias pcasc bias_pstack
Xbias_pstack_1[29] bias_pstack_6/avdd source_ibias bias_pstack_6/shld2 bias_pstack_6/shld3
+ level_shift_2/out pbias pcasc bias_pstack
Xbias_pstack_1[30] bias_pstack_6/avdd source_ibias bias_pstack_6/shld2 bias_pstack_6/shld3
+ level_shift_2/out pbias pcasc bias_pstack
Xbias_pstack_1[31] bias_pstack_6/avdd source_ibias bias_pstack_6/shld2 bias_pstack_6/shld3
+ level_shift_2/out pbias pcasc bias_pstack
Xsg13cmos5l_antennanp_2 source_ena[1] dvdd dvss sg13cmos5l_antennanp
Xsg13cmos5l_antennanp_3 source_ena[0] dvdd dvss sg13cmos5l_antennanp
Xbias_pstack_2[0] bias_pstack_6/avdd source_ibias bias_pstack_6/shld2 bias_pstack_6/shld3
+ level_shift_3/out pbias pcasc bias_pstack
Xbias_pstack_2[1] bias_pstack_6/avdd source_ibias bias_pstack_6/shld2 bias_pstack_6/shld3
+ level_shift_3/out pbias pcasc bias_pstack
Xbias_pstack_2[2] bias_pstack_6/avdd source_ibias bias_pstack_6/shld2 bias_pstack_6/shld3
+ level_shift_3/out pbias pcasc bias_pstack
Xbias_pstack_2[3] bias_pstack_6/avdd source_ibias bias_pstack_6/shld2 bias_pstack_6/shld3
+ level_shift_3/out pbias pcasc bias_pstack
Xbias_pstack_2[4] bias_pstack_6/avdd source_ibias bias_pstack_6/shld2 bias_pstack_6/shld3
+ level_shift_3/out pbias pcasc bias_pstack
Xbias_pstack_2[5] bias_pstack_6/avdd source_ibias bias_pstack_6/shld2 bias_pstack_6/shld3
+ level_shift_3/out pbias pcasc bias_pstack
Xbias_pstack_2[6] bias_pstack_6/avdd source_ibias bias_pstack_6/shld2 bias_pstack_6/shld3
+ level_shift_3/out pbias pcasc bias_pstack
Xbias_pstack_2[7] bias_pstack_6/avdd source_ibias bias_pstack_6/shld2 bias_pstack_6/shld3
+ level_shift_3/out pbias pcasc bias_pstack
Xbias_pstack_2[8] bias_pstack_6/avdd source_ibias bias_pstack_6/shld2 bias_pstack_6/shld3
+ level_shift_3/out pbias pcasc bias_pstack
Xbias_pstack_2[9] bias_pstack_6/avdd source_ibias bias_pstack_6/shld2 bias_pstack_6/shld3
+ level_shift_3/out pbias pcasc bias_pstack
Xbias_pstack_2[10] bias_pstack_6/avdd source_ibias bias_pstack_6/shld2 bias_pstack_6/shld3
+ level_shift_3/out pbias pcasc bias_pstack
Xbias_pstack_2[11] bias_pstack_6/avdd source_ibias bias_pstack_6/shld2 bias_pstack_6/shld3
+ level_shift_3/out pbias pcasc bias_pstack
Xbias_pstack_2[12] bias_pstack_6/avdd source_ibias bias_pstack_6/shld2 bias_pstack_6/shld3
+ level_shift_3/out pbias pcasc bias_pstack
Xbias_pstack_2[13] bias_pstack_6/avdd source_ibias bias_pstack_6/shld2 bias_pstack_6/shld3
+ level_shift_3/out pbias pcasc bias_pstack
Xbias_pstack_2[14] bias_pstack_6/avdd source_ibias bias_pstack_6/shld2 bias_pstack_6/shld3
+ level_shift_3/out pbias pcasc bias_pstack
Xbias_pstack_2[15] bias_pstack_6/avdd source_ibias bias_pstack_6/shld2 bias_pstack_6/shld3
+ level_shift_3/out pbias pcasc bias_pstack
Xsg13cmos5l_antennanp_4 source_ena[7] dvdd dvss sg13cmos5l_antennanp
Xbias_pstack_3[0] bias_pstack_6/avdd source_ibias bias_pstack_6/shld2 bias_pstack_6/shld3
+ level_shift_4/out pbias pcasc bias_pstack
Xbias_pstack_3[1] bias_pstack_6/avdd source_ibias bias_pstack_6/shld2 bias_pstack_6/shld3
+ level_shift_4/out pbias pcasc bias_pstack
Xbias_pstack_3[2] bias_pstack_6/avdd source_ibias bias_pstack_6/shld2 bias_pstack_6/shld3
+ level_shift_4/out pbias pcasc bias_pstack
Xbias_pstack_3[3] bias_pstack_6/avdd source_ibias bias_pstack_6/shld2 bias_pstack_6/shld3
+ level_shift_4/out pbias pcasc bias_pstack
Xbias_pstack_3[4] bias_pstack_6/avdd source_ibias bias_pstack_6/shld2 bias_pstack_6/shld3
+ level_shift_4/out pbias pcasc bias_pstack
Xbias_pstack_3[5] bias_pstack_6/avdd source_ibias bias_pstack_6/shld2 bias_pstack_6/shld3
+ level_shift_4/out pbias pcasc bias_pstack
Xbias_pstack_3[6] bias_pstack_6/avdd source_ibias bias_pstack_6/shld2 bias_pstack_6/shld3
+ level_shift_4/out pbias pcasc bias_pstack
Xbias_pstack_3[7] bias_pstack_6/avdd source_ibias bias_pstack_6/shld2 bias_pstack_6/shld3
+ level_shift_4/out pbias pcasc bias_pstack
Xbias_pstack_4[0] bias_pstack_6/avdd source_ibias bias_pstack_6/shld2 bias_pstack_6/shld3
+ level_shift_5/out pbias pcasc bias_pstack
Xbias_pstack_4[1] bias_pstack_6/avdd source_ibias bias_pstack_6/shld2 bias_pstack_6/shld3
+ level_shift_5/out pbias pcasc bias_pstack
Xbias_pstack_4[2] bias_pstack_6/avdd source_ibias bias_pstack_6/shld2 bias_pstack_6/shld3
+ level_shift_5/out pbias pcasc bias_pstack
Xbias_pstack_4[3] bias_pstack_6/avdd source_ibias bias_pstack_6/shld2 bias_pstack_6/shld3
+ level_shift_5/out pbias pcasc bias_pstack
Xsg13cmos5l_antennanp_5 source_ena[6] dvdd dvss sg13cmos5l_antennanp
Xbias_pstack_5[0] bias_pstack_6/avdd source_ibias bias_pstack_6/shld2 bias_pstack_6/shld3
+ level_shift_6/out pbias pcasc bias_pstack
Xbias_pstack_5[1] bias_pstack_6/avdd source_ibias bias_pstack_6/shld2 bias_pstack_6/shld3
+ level_shift_6/out pbias pcasc bias_pstack
Xsg13cmos5l_antennanp_6 source_ena[4] dvdd dvss sg13cmos5l_antennanp
Xbias_pstack_6 bias_pstack_6/avdd source_ibias bias_pstack_6/shld2 bias_pstack_6/shld3
+ level_shift_7/out pbias pcasc bias_pstack
Xsg13cmos5l_antennanp_7 source_ena[2] dvdd dvss sg13cmos5l_antennanp
Xbias_pstack_7[0] bias_pstack_6/avdd source_ibias bias_pstack_6/shld2 bias_pstack_6/shld3
+ level_shift_0/out pbias pcasc bias_pstack
Xbias_pstack_7[1] bias_pstack_6/avdd source_ibias bias_pstack_6/shld2 bias_pstack_6/shld3
+ level_shift_0/out pbias pcasc bias_pstack
Xbias_pstack_7[2] bias_pstack_6/avdd source_ibias bias_pstack_6/shld2 bias_pstack_6/shld3
+ level_shift_0/out pbias pcasc bias_pstack
Xbias_pstack_7[3] bias_pstack_6/avdd source_ibias bias_pstack_6/shld2 bias_pstack_6/shld3
+ level_shift_0/out pbias pcasc bias_pstack
Xbias_pstack_7[4] bias_pstack_6/avdd source_ibias bias_pstack_6/shld2 bias_pstack_6/shld3
+ level_shift_0/out pbias pcasc bias_pstack
Xbias_pstack_7[5] bias_pstack_6/avdd source_ibias bias_pstack_6/shld2 bias_pstack_6/shld3
+ level_shift_0/out pbias pcasc bias_pstack
Xbias_pstack_7[6] bias_pstack_6/avdd source_ibias bias_pstack_6/shld2 bias_pstack_6/shld3
+ level_shift_0/out pbias pcasc bias_pstack
Xbias_pstack_7[7] bias_pstack_6/avdd source_ibias bias_pstack_6/shld2 bias_pstack_6/shld3
+ level_shift_0/out pbias pcasc bias_pstack
Xbias_pstack_7[8] bias_pstack_6/avdd source_ibias bias_pstack_6/shld2 bias_pstack_6/shld3
+ level_shift_0/out pbias pcasc bias_pstack
Xbias_pstack_7[9] bias_pstack_6/avdd source_ibias bias_pstack_6/shld2 bias_pstack_6/shld3
+ level_shift_0/out pbias pcasc bias_pstack
Xbias_pstack_7[10] bias_pstack_6/avdd source_ibias bias_pstack_6/shld2 bias_pstack_6/shld3
+ level_shift_0/out pbias pcasc bias_pstack
Xbias_pstack_7[11] bias_pstack_6/avdd source_ibias bias_pstack_6/shld2 bias_pstack_6/shld3
+ level_shift_0/out pbias pcasc bias_pstack
Xbias_pstack_7[12] bias_pstack_6/avdd source_ibias bias_pstack_6/shld2 bias_pstack_6/shld3
+ level_shift_0/out pbias pcasc bias_pstack
Xbias_pstack_7[13] bias_pstack_6/avdd source_ibias bias_pstack_6/shld2 bias_pstack_6/shld3
+ level_shift_0/out pbias pcasc bias_pstack
Xbias_pstack_7[14] bias_pstack_6/avdd source_ibias bias_pstack_6/shld2 bias_pstack_6/shld3
+ level_shift_0/out pbias pcasc bias_pstack
Xbias_pstack_7[15] bias_pstack_6/avdd source_ibias bias_pstack_6/shld2 bias_pstack_6/shld3
+ level_shift_0/out pbias pcasc bias_pstack
Xbias_pstack_7[16] bias_pstack_6/avdd source_ibias bias_pstack_6/shld2 bias_pstack_6/shld3
+ level_shift_0/out pbias pcasc bias_pstack
Xbias_pstack_7[17] bias_pstack_6/avdd source_ibias bias_pstack_6/shld2 bias_pstack_6/shld3
+ level_shift_0/out pbias pcasc bias_pstack
Xbias_pstack_7[18] bias_pstack_6/avdd source_ibias bias_pstack_6/shld2 bias_pstack_6/shld3
+ level_shift_0/out pbias pcasc bias_pstack
Xbias_pstack_7[19] bias_pstack_6/avdd source_ibias bias_pstack_6/shld2 bias_pstack_6/shld3
+ level_shift_0/out pbias pcasc bias_pstack
Xbias_pstack_7[20] bias_pstack_6/avdd source_ibias bias_pstack_6/shld2 bias_pstack_6/shld3
+ level_shift_0/out pbias pcasc bias_pstack
Xbias_pstack_7[21] bias_pstack_6/avdd source_ibias bias_pstack_6/shld2 bias_pstack_6/shld3
+ level_shift_0/out pbias pcasc bias_pstack
Xbias_pstack_7[22] bias_pstack_6/avdd source_ibias bias_pstack_6/shld2 bias_pstack_6/shld3
+ level_shift_0/out pbias pcasc bias_pstack
Xbias_pstack_7[23] bias_pstack_6/avdd source_ibias bias_pstack_6/shld2 bias_pstack_6/shld3
+ level_shift_0/out pbias pcasc bias_pstack
Xbias_pstack_7[24] bias_pstack_6/avdd source_ibias bias_pstack_6/shld2 bias_pstack_6/shld3
+ level_shift_0/out pbias pcasc bias_pstack
Xbias_pstack_7[25] bias_pstack_6/avdd source_ibias bias_pstack_6/shld2 bias_pstack_6/shld3
+ level_shift_0/out pbias pcasc bias_pstack
Xbias_pstack_7[26] bias_pstack_6/avdd source_ibias bias_pstack_6/shld2 bias_pstack_6/shld3
+ level_shift_0/out pbias pcasc bias_pstack
Xbias_pstack_7[27] bias_pstack_6/avdd source_ibias bias_pstack_6/shld2 bias_pstack_6/shld3
+ level_shift_0/out pbias pcasc bias_pstack
Xbias_pstack_7[28] bias_pstack_6/avdd source_ibias bias_pstack_6/shld2 bias_pstack_6/shld3
+ level_shift_0/out pbias pcasc bias_pstack
Xbias_pstack_7[29] bias_pstack_6/avdd source_ibias bias_pstack_6/shld2 bias_pstack_6/shld3
+ level_shift_0/out pbias pcasc bias_pstack
Xbias_pstack_7[30] bias_pstack_6/avdd source_ibias bias_pstack_6/shld2 bias_pstack_6/shld3
+ level_shift_0/out pbias pcasc bias_pstack
Xbias_pstack_7[31] bias_pstack_6/avdd source_ibias bias_pstack_6/shld2 bias_pstack_6/shld3
+ level_shift_0/out pbias pcasc bias_pstack
Xbias_pstack_7[32] bias_pstack_6/avdd source_ibias bias_pstack_6/shld2 bias_pstack_6/shld3
+ level_shift_0/out pbias pcasc bias_pstack
Xbias_pstack_7[33] bias_pstack_6/avdd source_ibias bias_pstack_6/shld2 bias_pstack_6/shld3
+ level_shift_0/out pbias pcasc bias_pstack
Xbias_pstack_7[34] bias_pstack_6/avdd source_ibias bias_pstack_6/shld2 bias_pstack_6/shld3
+ level_shift_0/out pbias pcasc bias_pstack
Xbias_pstack_7[35] bias_pstack_6/avdd source_ibias bias_pstack_6/shld2 bias_pstack_6/shld3
+ level_shift_0/out pbias pcasc bias_pstack
Xbias_pstack_7[36] bias_pstack_6/avdd source_ibias bias_pstack_6/shld2 bias_pstack_6/shld3
+ level_shift_0/out pbias pcasc bias_pstack
Xbias_pstack_7[37] bias_pstack_6/avdd source_ibias bias_pstack_6/shld2 bias_pstack_6/shld3
+ level_shift_0/out pbias pcasc bias_pstack
Xbias_pstack_7[38] bias_pstack_6/avdd source_ibias bias_pstack_6/shld2 bias_pstack_6/shld3
+ level_shift_0/out pbias pcasc bias_pstack
Xbias_pstack_7[39] bias_pstack_6/avdd source_ibias bias_pstack_6/shld2 bias_pstack_6/shld3
+ level_shift_0/out pbias pcasc bias_pstack
Xbias_pstack_7[40] bias_pstack_6/avdd source_ibias bias_pstack_6/shld2 bias_pstack_6/shld3
+ level_shift_0/out pbias pcasc bias_pstack
Xbias_pstack_7[41] bias_pstack_6/avdd source_ibias bias_pstack_6/shld2 bias_pstack_6/shld3
+ level_shift_0/out pbias pcasc bias_pstack
Xbias_pstack_7[42] bias_pstack_6/avdd source_ibias bias_pstack_6/shld2 bias_pstack_6/shld3
+ level_shift_0/out pbias pcasc bias_pstack
Xbias_pstack_7[43] bias_pstack_6/avdd source_ibias bias_pstack_6/shld2 bias_pstack_6/shld3
+ level_shift_0/out pbias pcasc bias_pstack
Xbias_pstack_7[44] bias_pstack_6/avdd source_ibias bias_pstack_6/shld2 bias_pstack_6/shld3
+ level_shift_0/out pbias pcasc bias_pstack
Xbias_pstack_7[45] bias_pstack_6/avdd source_ibias bias_pstack_6/shld2 bias_pstack_6/shld3
+ level_shift_0/out pbias pcasc bias_pstack
Xbias_pstack_7[46] bias_pstack_6/avdd source_ibias bias_pstack_6/shld2 bias_pstack_6/shld3
+ level_shift_0/out pbias pcasc bias_pstack
Xbias_pstack_7[47] bias_pstack_6/avdd source_ibias bias_pstack_6/shld2 bias_pstack_6/shld3
+ level_shift_0/out pbias pcasc bias_pstack
Xbias_pstack_7[48] bias_pstack_6/avdd source_ibias bias_pstack_6/shld2 bias_pstack_6/shld3
+ level_shift_0/out pbias pcasc bias_pstack
Xbias_pstack_7[49] bias_pstack_6/avdd source_ibias bias_pstack_6/shld2 bias_pstack_6/shld3
+ level_shift_0/out pbias pcasc bias_pstack
Xbias_pstack_7[50] bias_pstack_6/avdd source_ibias bias_pstack_6/shld2 bias_pstack_6/shld3
+ level_shift_0/out pbias pcasc bias_pstack
Xbias_pstack_7[51] bias_pstack_6/avdd source_ibias bias_pstack_6/shld2 bias_pstack_6/shld3
+ level_shift_0/out pbias pcasc bias_pstack
Xbias_pstack_7[52] bias_pstack_6/avdd source_ibias bias_pstack_6/shld2 bias_pstack_6/shld3
+ level_shift_0/out pbias pcasc bias_pstack
Xbias_pstack_7[53] bias_pstack_6/avdd source_ibias bias_pstack_6/shld2 bias_pstack_6/shld3
+ level_shift_0/out pbias pcasc bias_pstack
Xbias_pstack_7[54] bias_pstack_6/avdd source_ibias bias_pstack_6/shld2 bias_pstack_6/shld3
+ level_shift_0/out pbias pcasc bias_pstack
Xbias_pstack_7[55] bias_pstack_6/avdd source_ibias bias_pstack_6/shld2 bias_pstack_6/shld3
+ level_shift_0/out pbias pcasc bias_pstack
Xbias_pstack_7[56] bias_pstack_6/avdd source_ibias bias_pstack_6/shld2 bias_pstack_6/shld3
+ level_shift_0/out pbias pcasc bias_pstack
Xbias_pstack_7[57] bias_pstack_6/avdd source_ibias bias_pstack_6/shld2 bias_pstack_6/shld3
+ level_shift_0/out pbias pcasc bias_pstack
Xbias_pstack_7[58] bias_pstack_6/avdd source_ibias bias_pstack_6/shld2 bias_pstack_6/shld3
+ level_shift_0/out pbias pcasc bias_pstack
Xbias_pstack_7[59] bias_pstack_6/avdd source_ibias bias_pstack_6/shld2 bias_pstack_6/shld3
+ level_shift_0/out pbias pcasc bias_pstack
Xbias_pstack_7[60] bias_pstack_6/avdd source_ibias bias_pstack_6/shld2 bias_pstack_6/shld3
+ level_shift_0/out pbias pcasc bias_pstack
Xbias_pstack_7[61] bias_pstack_6/avdd source_ibias bias_pstack_6/shld2 bias_pstack_6/shld3
+ level_shift_0/out pbias pcasc bias_pstack
Xbias_pstack_7[62] bias_pstack_6/avdd source_ibias bias_pstack_6/shld2 bias_pstack_6/shld3
+ level_shift_0/out pbias pcasc bias_pstack
Xbias_pstack_7[63] bias_pstack_6/avdd source_ibias bias_pstack_6/shld2 bias_pstack_6/shld3
+ level_shift_0/out pbias pcasc bias_pstack
Xbias_pstack_7[64] bias_pstack_6/avdd source_ibias bias_pstack_6/shld2 bias_pstack_6/shld3
+ level_shift_0/out pbias pcasc bias_pstack
Xbias_pstack_7[65] bias_pstack_6/avdd source_ibias bias_pstack_6/shld2 bias_pstack_6/shld3
+ level_shift_0/out pbias pcasc bias_pstack
Xbias_pstack_7[66] bias_pstack_6/avdd source_ibias bias_pstack_6/shld2 bias_pstack_6/shld3
+ level_shift_0/out pbias pcasc bias_pstack
Xbias_pstack_7[67] bias_pstack_6/avdd source_ibias bias_pstack_6/shld2 bias_pstack_6/shld3
+ level_shift_0/out pbias pcasc bias_pstack
Xbias_pstack_7[68] bias_pstack_6/avdd source_ibias bias_pstack_6/shld2 bias_pstack_6/shld3
+ level_shift_0/out pbias pcasc bias_pstack
Xbias_pstack_7[69] bias_pstack_6/avdd source_ibias bias_pstack_6/shld2 bias_pstack_6/shld3
+ level_shift_0/out pbias pcasc bias_pstack
Xbias_pstack_7[70] bias_pstack_6/avdd source_ibias bias_pstack_6/shld2 bias_pstack_6/shld3
+ level_shift_0/out pbias pcasc bias_pstack
Xbias_pstack_7[71] bias_pstack_6/avdd source_ibias bias_pstack_6/shld2 bias_pstack_6/shld3
+ level_shift_0/out pbias pcasc bias_pstack
Xbias_pstack_7[72] bias_pstack_6/avdd source_ibias bias_pstack_6/shld2 bias_pstack_6/shld3
+ level_shift_0/out pbias pcasc bias_pstack
Xbias_pstack_7[73] bias_pstack_6/avdd source_ibias bias_pstack_6/shld2 bias_pstack_6/shld3
+ level_shift_0/out pbias pcasc bias_pstack
Xbias_pstack_7[74] bias_pstack_6/avdd source_ibias bias_pstack_6/shld2 bias_pstack_6/shld3
+ level_shift_0/out pbias pcasc bias_pstack
Xbias_pstack_7[75] bias_pstack_6/avdd source_ibias bias_pstack_6/shld2 bias_pstack_6/shld3
+ level_shift_0/out pbias pcasc bias_pstack
Xbias_pstack_7[76] bias_pstack_6/avdd source_ibias bias_pstack_6/shld2 bias_pstack_6/shld3
+ level_shift_0/out pbias pcasc bias_pstack
Xbias_pstack_7[77] bias_pstack_6/avdd source_ibias bias_pstack_6/shld2 bias_pstack_6/shld3
+ level_shift_0/out pbias pcasc bias_pstack
Xbias_pstack_7[78] bias_pstack_6/avdd source_ibias bias_pstack_6/shld2 bias_pstack_6/shld3
+ level_shift_0/out pbias pcasc bias_pstack
Xbias_pstack_7[79] bias_pstack_6/avdd source_ibias bias_pstack_6/shld2 bias_pstack_6/shld3
+ level_shift_0/out pbias pcasc bias_pstack
Xbias_pstack_7[80] bias_pstack_6/avdd source_ibias bias_pstack_6/shld2 bias_pstack_6/shld3
+ level_shift_0/out pbias pcasc bias_pstack
Xbias_pstack_7[81] bias_pstack_6/avdd source_ibias bias_pstack_6/shld2 bias_pstack_6/shld3
+ level_shift_0/out pbias pcasc bias_pstack
Xbias_pstack_7[82] bias_pstack_6/avdd source_ibias bias_pstack_6/shld2 bias_pstack_6/shld3
+ level_shift_0/out pbias pcasc bias_pstack
Xbias_pstack_7[83] bias_pstack_6/avdd source_ibias bias_pstack_6/shld2 bias_pstack_6/shld3
+ level_shift_0/out pbias pcasc bias_pstack
Xbias_pstack_7[84] bias_pstack_6/avdd source_ibias bias_pstack_6/shld2 bias_pstack_6/shld3
+ level_shift_0/out pbias pcasc bias_pstack
Xbias_pstack_7[85] bias_pstack_6/avdd source_ibias bias_pstack_6/shld2 bias_pstack_6/shld3
+ level_shift_0/out pbias pcasc bias_pstack
Xbias_pstack_7[86] bias_pstack_6/avdd source_ibias bias_pstack_6/shld2 bias_pstack_6/shld3
+ level_shift_0/out pbias pcasc bias_pstack
Xbias_pstack_7[87] bias_pstack_6/avdd source_ibias bias_pstack_6/shld2 bias_pstack_6/shld3
+ level_shift_0/out pbias pcasc bias_pstack
Xbias_pstack_7[88] bias_pstack_6/avdd source_ibias bias_pstack_6/shld2 bias_pstack_6/shld3
+ level_shift_0/out pbias pcasc bias_pstack
Xbias_pstack_7[89] bias_pstack_6/avdd source_ibias bias_pstack_6/shld2 bias_pstack_6/shld3
+ level_shift_0/out pbias pcasc bias_pstack
Xbias_pstack_7[90] bias_pstack_6/avdd source_ibias bias_pstack_6/shld2 bias_pstack_6/shld3
+ level_shift_0/out pbias pcasc bias_pstack
Xbias_pstack_7[91] bias_pstack_6/avdd source_ibias bias_pstack_6/shld2 bias_pstack_6/shld3
+ level_shift_0/out pbias pcasc bias_pstack
Xbias_pstack_7[92] bias_pstack_6/avdd source_ibias bias_pstack_6/shld2 bias_pstack_6/shld3
+ level_shift_0/out pbias pcasc bias_pstack
Xbias_pstack_7[93] bias_pstack_6/avdd source_ibias bias_pstack_6/shld2 bias_pstack_6/shld3
+ level_shift_0/out pbias pcasc bias_pstack
Xbias_pstack_7[94] bias_pstack_6/avdd source_ibias bias_pstack_6/shld2 bias_pstack_6/shld3
+ level_shift_0/out pbias pcasc bias_pstack
Xbias_pstack_7[95] bias_pstack_6/avdd source_ibias bias_pstack_6/shld2 bias_pstack_6/shld3
+ level_shift_0/out pbias pcasc bias_pstack
Xbias_pstack_7[96] bias_pstack_6/avdd source_ibias bias_pstack_6/shld2 bias_pstack_6/shld3
+ level_shift_0/out pbias pcasc bias_pstack
Xbias_pstack_7[97] bias_pstack_6/avdd source_ibias bias_pstack_6/shld2 bias_pstack_6/shld3
+ level_shift_0/out pbias pcasc bias_pstack
Xbias_pstack_7[98] bias_pstack_6/avdd source_ibias bias_pstack_6/shld2 bias_pstack_6/shld3
+ level_shift_0/out pbias pcasc bias_pstack
Xbias_pstack_7[99] bias_pstack_6/avdd source_ibias bias_pstack_6/shld2 bias_pstack_6/shld3
+ level_shift_0/out pbias pcasc bias_pstack
Xbias_pstack_7[100] bias_pstack_6/avdd source_ibias bias_pstack_6/shld2 bias_pstack_6/shld3
+ level_shift_0/out pbias pcasc bias_pstack
Xbias_pstack_7[101] bias_pstack_6/avdd source_ibias bias_pstack_6/shld2 bias_pstack_6/shld3
+ level_shift_0/out pbias pcasc bias_pstack
Xbias_pstack_7[102] bias_pstack_6/avdd source_ibias bias_pstack_6/shld2 bias_pstack_6/shld3
+ level_shift_0/out pbias pcasc bias_pstack
Xbias_pstack_7[103] bias_pstack_6/avdd source_ibias bias_pstack_6/shld2 bias_pstack_6/shld3
+ level_shift_0/out pbias pcasc bias_pstack
Xbias_pstack_7[104] bias_pstack_6/avdd source_ibias bias_pstack_6/shld2 bias_pstack_6/shld3
+ level_shift_0/out pbias pcasc bias_pstack
Xbias_pstack_7[105] bias_pstack_6/avdd source_ibias bias_pstack_6/shld2 bias_pstack_6/shld3
+ level_shift_0/out pbias pcasc bias_pstack
Xbias_pstack_7[106] bias_pstack_6/avdd source_ibias bias_pstack_6/shld2 bias_pstack_6/shld3
+ level_shift_0/out pbias pcasc bias_pstack
Xbias_pstack_7[107] bias_pstack_6/avdd source_ibias bias_pstack_6/shld2 bias_pstack_6/shld3
+ level_shift_0/out pbias pcasc bias_pstack
Xbias_pstack_7[108] bias_pstack_6/avdd source_ibias bias_pstack_6/shld2 bias_pstack_6/shld3
+ level_shift_0/out pbias pcasc bias_pstack
Xbias_pstack_7[109] bias_pstack_6/avdd source_ibias bias_pstack_6/shld2 bias_pstack_6/shld3
+ level_shift_0/out pbias pcasc bias_pstack
Xbias_pstack_7[110] bias_pstack_6/avdd source_ibias bias_pstack_6/shld2 bias_pstack_6/shld3
+ level_shift_0/out pbias pcasc bias_pstack
Xbias_pstack_7[111] bias_pstack_6/avdd source_ibias bias_pstack_6/shld2 bias_pstack_6/shld3
+ level_shift_0/out pbias pcasc bias_pstack
Xbias_pstack_7[112] bias_pstack_6/avdd source_ibias bias_pstack_6/shld2 bias_pstack_6/shld3
+ level_shift_0/out pbias pcasc bias_pstack
Xbias_pstack_7[113] bias_pstack_6/avdd source_ibias bias_pstack_6/shld2 bias_pstack_6/shld3
+ level_shift_0/out pbias pcasc bias_pstack
Xbias_pstack_7[114] bias_pstack_6/avdd source_ibias bias_pstack_6/shld2 bias_pstack_6/shld3
+ level_shift_0/out pbias pcasc bias_pstack
Xbias_pstack_7[115] bias_pstack_6/avdd source_ibias bias_pstack_6/shld2 bias_pstack_6/shld3
+ level_shift_0/out pbias pcasc bias_pstack
Xbias_pstack_7[116] bias_pstack_6/avdd source_ibias bias_pstack_6/shld2 bias_pstack_6/shld3
+ level_shift_0/out pbias pcasc bias_pstack
Xbias_pstack_7[117] bias_pstack_6/avdd source_ibias bias_pstack_6/shld2 bias_pstack_6/shld3
+ level_shift_0/out pbias pcasc bias_pstack
Xbias_pstack_7[118] bias_pstack_6/avdd source_ibias bias_pstack_6/shld2 bias_pstack_6/shld3
+ level_shift_0/out pbias pcasc bias_pstack
Xbias_pstack_7[119] bias_pstack_6/avdd source_ibias bias_pstack_6/shld2 bias_pstack_6/shld3
+ level_shift_0/out pbias pcasc bias_pstack
Xbias_pstack_7[120] bias_pstack_6/avdd source_ibias bias_pstack_6/shld2 bias_pstack_6/shld3
+ level_shift_0/out pbias pcasc bias_pstack
Xbias_pstack_7[121] bias_pstack_6/avdd source_ibias bias_pstack_6/shld2 bias_pstack_6/shld3
+ level_shift_0/out pbias pcasc bias_pstack
Xbias_pstack_7[122] bias_pstack_6/avdd source_ibias bias_pstack_6/shld2 bias_pstack_6/shld3
+ level_shift_0/out pbias pcasc bias_pstack
Xbias_pstack_7[123] bias_pstack_6/avdd source_ibias bias_pstack_6/shld2 bias_pstack_6/shld3
+ level_shift_0/out pbias pcasc bias_pstack
Xbias_pstack_7[124] bias_pstack_6/avdd source_ibias bias_pstack_6/shld2 bias_pstack_6/shld3
+ level_shift_0/out pbias pcasc bias_pstack
Xbias_pstack_7[125] bias_pstack_6/avdd source_ibias bias_pstack_6/shld2 bias_pstack_6/shld3
+ level_shift_0/out pbias pcasc bias_pstack
Xbias_pstack_7[126] bias_pstack_6/avdd source_ibias bias_pstack_6/shld2 bias_pstack_6/shld3
+ level_shift_0/out pbias pcasc bias_pstack
Xbias_pstack_7[127] bias_pstack_6/avdd source_ibias bias_pstack_6/shld2 bias_pstack_6/shld3
+ level_shift_0/out pbias pcasc bias_pstack
Xlevel_shift_0 source_ena[7] level_shift_0/in_p avdd level_shift_0/out sub level_shift
Xlevel_shift_1 source_ena[6] level_shift_1/in_p avdd level_shift_1/out sub level_shift
Xlevel_shift_2 source_ena[5] level_shift_2/in_p avdd level_shift_2/out sub level_shift
Xsg13cmos5l_decap_4_0 dvdd dvss sg13cmos5l_decap_4
Xsg13cmos5l_decap_4_1 dvdd dvss sg13cmos5l_decap_4
Xlevel_shift_3 source_ena[4] level_shift_3/in_p avdd level_shift_3/out sub level_shift
Xlevel_shift_4 source_ena[3] level_shift_4/in_p avdd level_shift_4/out sub level_shift
Xsg13cmos5l_decap_4_2 dvdd dvss sg13cmos5l_decap_4
Xlevel_shift_5 source_ena[2] level_shift_5/in_p avdd level_shift_5/out sub level_shift
Xsg13cmos5l_decap_4_3 dvdd dvss sg13cmos5l_decap_4
Xlevel_shift_6 source_ena[1] level_shift_6/in_p avdd level_shift_6/out sub level_shift
Xsg13cmos5l_decap_4_4 dvdd dvss sg13cmos5l_decap_4
Xlevel_shift_7 source_ena[0] level_shift_7/in_p avdd level_shift_7/out sub level_shift
Xsg13cmos5l_decap_4_5 dvdd dvss sg13cmos5l_decap_4
Xsg13cmos5l_decap_4_6 dvdd dvss sg13cmos5l_decap_4
Xsg13cmos5l_decap_4_7 dvdd dvss sg13cmos5l_decap_4
.ends

.subckt sg13cmos5l_ocd_ip__biasgen1 ena ref_in ref_sel_vbg bandgap_source_ibias bandgap_source[4]
+ bandgap_source[3] bandgap_source[2] bandgap_source[1] bandgap_source[0] bandgap_sink[4]
+ bandgap_sink[3] bandgap_sink[2] bandgap_sink[1] bandgap_sink[0] voltgen_source1[4]
+ voltgen_source1[3] voltgen_source1[2] voltgen_source1[1] voltgen_source1[0] bandgap_sink_ibias
+ voltgen_source2[4] voltgen_source2[3] voltgen_source2[2] voltgen_source2[1] voltgen_source2[0]
+ voltgen_sink[4] voltgen_sink[3] voltgen_sink[2] voltgen_sink[1] voltgen_sink[0]
+ voltgen_source1_ibias test_sink[4] test_sink[3] test_sink[2] test_sink[1] test_sink[0]
+ voltgen_source2_ibias idac1_source[7] idac1_source[6] idac1_source[5] idac1_source[4]
+ idac1_source[3] idac1_source[2] idac1_source[1] idac1_source[0] voltgen_sink_ibias
+ test_sink_ibias idac1_source idac2_source idac1_sink[7] idac1_sink[6] idac1_sink[5]
+ idac1_sink[4] idac1_sink[3] idac1_sink[2] idac1_sink[1] idac1_sink[0] idac2_source[7]
+ idac2_source[6] idac2_source[5] idac2_source[4] idac2_source[3] idac2_source[2]
+ idac2_source[1] idac2_source[0] idac2_sink[7] idac2_sink[6] idac2_sink[5] idac2_sink[4]
+ idac2_sink[3] idac2_sink[2] idac2_sink[1] idac2_sink[0] idac1_sink idac2_sink ref_sel_coarse
+ ref_sel_fine vbg dvdd avdd sub dvss
Xbias_nstack_0[0] sub sub sub bias_nstack_0[9]/a_1030_2157# x6/nbias sub x6/ncasc
+ bias_nstack_0[9]/itail bias_nstack
Xbias_nstack_0[1] sub sub sub bias_nstack_0[9]/a_1030_2157# x6/nbias sub x6/ncasc
+ bias_nstack_0[9]/itail bias_nstack
Xbias_nstack_0[2] sub sub sub bias_nstack_0[9]/a_1030_2157# x6/nbias sub x6/ncasc
+ bias_nstack_0[9]/itail bias_nstack
Xbias_nstack_0[3] sub sub sub bias_nstack_0[9]/a_1030_2157# x6/nbias sub x6/ncasc
+ bias_nstack_0[9]/itail bias_nstack
Xbias_nstack_0[4] sub sub sub bias_nstack_0[9]/a_1030_2157# x6/nbias sub x6/ncasc
+ bias_nstack_0[9]/itail bias_nstack
Xbias_nstack_0[5] sub sub sub bias_nstack_0[9]/a_1030_2157# x6/nbias sub x6/ncasc
+ bias_nstack_0[9]/itail bias_nstack
Xbias_nstack_0[6] sub sub sub bias_nstack_0[9]/a_1030_2157# x6/nbias sub x6/ncasc
+ bias_nstack_0[9]/itail bias_nstack
Xbias_nstack_0[7] sub sub sub bias_nstack_0[9]/a_1030_2157# x6/nbias sub x6/ncasc
+ bias_nstack_0[9]/itail bias_nstack
Xbias_nstack_0[8] sub sub sub bias_nstack_0[9]/a_1030_2157# x6/nbias sub x6/ncasc
+ bias_nstack_0[9]/itail bias_nstack
Xbias_nstack_0[9] sub sub sub bias_nstack_0[9]/a_1030_2157# x6/nbias sub x6/ncasc
+ bias_nstack_0[9]/itail bias_nstack
Xbias_nstack_0[10] sub sub sub bias_nstack_0[9]/a_1030_2157# x6/nbias sub x6/ncasc
+ bias_nstack_0[9]/itail bias_nstack
Xbias_nstack_0[11] sub sub sub bias_nstack_0[9]/a_1030_2157# x6/nbias sub x6/ncasc
+ bias_nstack_0[9]/itail bias_nstack
Xx1 ena vbg x1/src_test0 dvss ref_sel_vbg ref_in x1/pcasc x1/pbias x1/snk_test0 dvss
+ ref_sel_fine ref_sel_coarse x6/nbias x6/ncasc avdd dvdd sub dvss avdd bias_generator_fe
Xx3 x6/avdd sub idac2_sink[7] idac2_sink[5] idac2_sink[3] idac2_sink idac2_sink[4]
+ idac2_sink[0] x6/nbias sub idac2_sink[1] idac2_sink[6] sub idac2_sink[2] sub x6/ncasc
+ avdd dvdd dvss bias_generator_be1n
Xx2 x6/avdd sub dvdd sub voltgen_sink[3] voltgen_sink[2] sub voltgen_sink[0] x6/nbias
+ voltgen_sink[1] x6/ncasc avdd voltgen_sink_ibias sub voltgen_sink[4] dvss sub bias_generator_be0n
Xx4 x6/avdd sub dvdd sub test_sink[3] test_sink[2] sub test_sink[0] x6/nbias test_sink[1]
+ x6/ncasc avdd test_sink_ibias sub test_sink[4] dvss sub bias_generator_be0n
Xx5 x6/avdd sub dvdd sub bandgap_sink[3] bandgap_sink[2] sub bandgap_sink[0] x6/nbias
+ bandgap_sink[1] x6/ncasc avdd bandgap_sink_ibias sub bandgap_sink[4] dvss sub bias_generator_be0n
Xx6 x6/avdd sub idac1_sink[7] idac1_sink[5] idac1_sink[3] idac1_sink idac1_sink[4]
+ idac1_sink[0] x6/nbias sub idac1_sink[1] idac1_sink[6] sub idac1_sink[2] sub x6/ncasc
+ avdd dvdd dvss bias_generator_be1n
Xbias_generator_be0p_0 x1/pcasc voltgen_source2_ibias voltgen_source2[2] dvdd voltgen_source2[1]
+ avdd voltgen_source2[4] sub voltgen_source2[0] avdd avdd voltgen_source2[3] avdd
+ x1/pbias dvss bias_generator_be0p
Xbias_generator_be0p_1 x1/pcasc bandgap_source_ibias bandgap_source[2] dvdd bandgap_source[1]
+ avdd bandgap_source[4] sub bandgap_source[0] avdd avdd bandgap_source[3] avdd x1/pbias
+ dvss bias_generator_be0p
Xbias_generator_be0p_2 x1/pcasc voltgen_source1_ibias voltgen_source1[2] dvdd voltgen_source1[1]
+ avdd voltgen_source1[4] sub voltgen_source1[0] avdd avdd voltgen_source1[3] avdd
+ x1/pbias dvss bias_generator_be0p
Xbias_pstack_0[0] avdd bias_pstack_0[9]/itail avdd avdd avdd x1/pbias x1/pcasc bias_pstack
Xbias_pstack_0[1] avdd bias_pstack_0[9]/itail avdd avdd avdd x1/pbias x1/pcasc bias_pstack
Xbias_pstack_0[2] avdd bias_pstack_0[9]/itail avdd avdd avdd x1/pbias x1/pcasc bias_pstack
Xbias_pstack_0[3] avdd bias_pstack_0[9]/itail avdd avdd avdd x1/pbias x1/pcasc bias_pstack
Xbias_pstack_0[4] avdd bias_pstack_0[9]/itail avdd avdd avdd x1/pbias x1/pcasc bias_pstack
Xbias_pstack_0[5] avdd bias_pstack_0[9]/itail avdd avdd avdd x1/pbias x1/pcasc bias_pstack
Xbias_pstack_0[6] avdd bias_pstack_0[9]/itail avdd avdd avdd x1/pbias x1/pcasc bias_pstack
Xbias_pstack_0[7] avdd bias_pstack_0[9]/itail avdd avdd avdd x1/pbias x1/pcasc bias_pstack
Xbias_pstack_0[8] avdd bias_pstack_0[9]/itail avdd avdd avdd x1/pbias x1/pcasc bias_pstack
Xbias_pstack_0[9] avdd bias_pstack_0[9]/itail avdd avdd avdd x1/pbias x1/pcasc bias_pstack
Xbias_pstack_0[10] avdd bias_pstack_0[9]/itail avdd avdd avdd x1/pbias x1/pcasc bias_pstack
Xbias_pstack_0[11] avdd bias_pstack_0[9]/itail avdd avdd avdd x1/pbias x1/pcasc bias_pstack
Xbias_generator_be1p_0 x1/pcasc idac1_source[6] idac1_source[5] idac1_source[1] idac1_source
+ idac1_source[4] sub idac1_source[7] idac1_source[3] idac1_source[0] avdd idac1_source[2]
+ dvdd dvss x1/pbias avdd avdd avdd bias_generator_be1p
Xbias_generator_be1p_1 x1/pcasc idac2_source[6] idac2_source[5] idac2_source[1] idac2_source
+ idac2_source[4] sub idac2_source[7] idac2_source[3] idac2_source[0] avdd idac2_source[2]
+ dvdd dvss x1/pbias avdd avdd avdd bias_generator_be1p
.ends

.subckt sg13cmos5l_decap_8 VDD VSS
X0 VSS VDD VSS VSS sg13_lv_nmos ad=0.1428p pd=1.52u as=0 ps=0 w=0.42u l=1u
X1 VDD VSS VDD VDD sg13_lv_pmos ad=0.19p pd=1.38u as=0 ps=0 w=1u l=1u
X2 VSS VDD VSS VSS sg13_lv_nmos ad=79.8f pd=0.8u as=0 ps=0 w=0.42u l=1u
X3 VDD VSS VDD VDD sg13_lv_pmos ad=0.34p pd=2.68u as=0 ps=0 w=1u l=1u
.ends

.subckt sg13cmos5l_dlygate4sd3_1 X A VDD VSS
X0 VDD A a_56_118# VDD sg13_lv_pmos ad=0.1523p pd=1.38u as=0.1428p ps=1.52u w=0.42u l=0.13u
X1 VSS a_326_118# a_438_182# VSS sg13_lv_nmos ad=0.1426p pd=1.16u as=0.1428p ps=1.52u w=0.42u l=0.5u
X2 VDD a_326_118# a_438_182# VDD sg13_lv_pmos ad=0.2254p pd=1.53u as=0.34p ps=2.68u w=1u l=0.5u
X3 X a_438_182# VDD VDD sg13_lv_pmos ad=0.4256p pd=3u as=0.2254p ps=1.53u w=1.12u l=0.13u
X4 a_326_118# a_56_118# VDD VDD sg13_lv_pmos ad=0.34p pd=2.68u as=0.1523p ps=1.38u w=1u l=0.5u
X5 VSS A a_56_118# VSS sg13_lv_nmos ad=79.8f pd=0.8u as=0.1428p ps=1.52u w=0.42u l=0.13u
X6 X a_438_182# VSS VSS sg13_lv_nmos ad=0.2516p pd=2.16u as=0.1426p ps=1.16u w=0.74u l=0.13u
X7 a_326_118# a_56_118# VSS VSS sg13_lv_nmos ad=0.1428p pd=1.52u as=79.8f ps=0.8u w=0.42u l=0.5u
.ends

.subckt sg13cmos5l_o21ai_1 Y A1 A2 B1 VDD VSS
X0 VSS A1 a_22_110# VSS sg13_lv_nmos ad=0.1406p pd=1.12u as=0.2516p ps=2.16u w=0.74u l=0.15u
X1 a_120_432# A1 VDD VDD sg13_lv_pmos ad=0.2128p pd=1.5u as=0.3808p ps=2.92u w=1.12u l=0.15u
X2 a_22_110# A2 VSS VSS sg13_lv_nmos ad=0.1406p pd=1.12u as=0.1406p ps=1.12u w=0.74u l=0.15u
X3 Y B1 a_22_110# VSS sg13_lv_nmos ad=0.2516p pd=2.16u as=0.1406p ps=1.12u w=0.74u l=0.15u
X4 Y A2 a_120_432# VDD sg13_lv_pmos ad=0.2128p pd=1.5u as=0.2128p ps=1.5u w=1.12u l=0.15u
X5 VDD B1 Y VDD sg13_lv_pmos ad=0.3808p pd=2.92u as=0.2128p ps=1.5u w=1.12u l=0.15u
.ends

.subckt sg13cmos5l_nor2b_1 Y A B_N VDD VSS
X0 VDD B_N a_46_156# VDD sg13_lv_pmos ad=0.2618p pd=1.63u as=0.2856p ps=2.36u w=0.84u l=0.13u
X1 VSS B_N a_46_156# VSS sg13_lv_nmos ad=0.17255p pd=1.25u as=0.187p ps=1.78u w=0.55u l=0.13u
X2 Y a_46_156# VSS VSS sg13_lv_nmos ad=0.1406p pd=1.12u as=0.17255p ps=1.25u w=0.74u l=0.13u
X3 VSS A Y VSS sg13_lv_nmos ad=0.2516p pd=2.16u as=0.1406p ps=1.12u w=0.74u l=0.13u
X4 a_268_412# a_46_156# VDD VDD sg13_lv_pmos ad=0.1176p pd=1.33u as=0.2618p ps=1.63u w=1.12u l=0.13u
X5 Y A a_268_412# VDD sg13_lv_pmos ad=0.3808p pd=2.92u as=0.1176p ps=1.33u w=1.12u l=0.13u
.ends

.subckt sg13cmos5l_buf_1 X A VDD VSS
X0 X a_40_152# VSS VSS sg13_lv_nmos ad=0.2886p pd=2.26u as=0.14875p ps=1.16u w=0.74u l=0.13u
X1 X a_40_152# VDD VDD sg13_lv_pmos ad=0.42p pd=2.99u as=0.2114p ps=1.54u w=1.12u l=0.13u
X2 VDD A a_40_152# VDD sg13_lv_pmos ad=0.2114p pd=1.54u as=0.2856p ps=2.36u w=0.84u l=0.13u
X3 VSS A a_40_152# VSS sg13_lv_nmos ad=0.14875p pd=1.16u as=0.187p ps=1.78u w=0.55u l=0.13u
.ends

.subckt sg13cmos5l_mux2_1 X A0 A1 S VDD VSS
X0 a_559_412# A1 a_382_118# VDD sg13_lv_pmos ad=0.2975p pd=1.595u as=0.2225p ps=1.445u w=1u l=0.13u
X1 VDD S a_59_156# VDD sg13_lv_pmos ad=0.253p pd=1.53u as=0.2856p ps=2.36u w=0.84u l=0.13u
X2 VSS S a_59_156# VSS sg13_lv_nmos ad=0.18945p pd=1.27u as=0.187p ps=1.78u w=0.55u l=0.13u
X3 X a_382_118# VSS VSS sg13_lv_nmos ad=0.4033p pd=2.57u as=0.148p ps=1.14u w=0.74u l=0.13u
X4 X a_382_118# VDD VDD sg13_lv_pmos ad=0.6048p pd=3.32u as=0.2198p ps=1.52u w=1.12u l=0.13u
X5 a_285_118# S VSS VSS sg13_lv_nmos ad=0.13135p pd=1.095u as=0.18945p ps=1.27u w=0.74u l=0.13u
X6 a_285_412# S VDD VDD sg13_lv_pmos ad=0.3325p pd=1.665u as=0.253p ps=1.53u w=1u l=0.13u
X7 VSS a_59_156# a_496_118# VSS sg13_lv_nmos ad=0.148p pd=1.14u as=0.3367p ps=1.65u w=0.74u l=0.13u
X8 VDD a_59_156# a_559_412# VDD sg13_lv_pmos ad=0.2198p pd=1.52u as=0.2975p ps=1.595u w=1u l=0.13u
X9 a_382_118# A1 a_285_118# VSS sg13_lv_nmos ad=0.1628p pd=1.18u as=0.13135p ps=1.095u w=0.74u l=0.13u
X10 a_496_118# A0 a_382_118# VSS sg13_lv_nmos ad=0.3367p pd=1.65u as=0.1628p ps=1.18u w=0.74u l=0.13u
X11 a_382_118# A0 a_285_412# VDD sg13_lv_pmos ad=0.2225p pd=1.445u as=0.3325p ps=1.665u w=1u l=0.13u
.ends

.subckt sg13cmos5l_a21oi_1 Y A1 A2 B1 VDD VSS
X0 Y B1 VSS VSS sg13_lv_nmos ad=0.1406p pd=1.12u as=0.2516p ps=2.16u w=0.74u l=0.13u
X1 a_257_140# A1 Y VSS sg13_lv_nmos ad=0.1406p pd=1.12u as=0.1406p ps=1.12u w=0.74u l=0.13u
X2 VSS A2 a_257_140# VSS sg13_lv_nmos ad=0.2516p pd=2.16u as=0.1406p ps=1.12u w=0.74u l=0.13u
X3 a_155_412# B1 Y VDD sg13_lv_pmos ad=0.2128p pd=1.5u as=0.3808p ps=2.92u w=1.12u l=0.13u
X4 VDD A1 a_155_412# VDD sg13_lv_pmos ad=0.2128p pd=1.5u as=0.2128p ps=1.5u w=1.12u l=0.13u
X5 a_155_412# A2 VDD VDD sg13_lv_pmos ad=0.3808p pd=2.92u as=0.2128p ps=1.5u w=1.12u l=0.13u
.ends

.subckt sg13cmos5l_a221oi_1 Y A1 A2 B1 B2 C1 VDD VSS
X0 a_550_140# A1 Y VSS sg13_lv_nmos ad=0.1406p pd=1.12u as=0.2516p ps=2.16u w=0.74u l=0.13u
X1 VSS A2 a_550_140# VSS sg13_lv_nmos ad=0.2516p pd=2.16u as=0.1406p ps=1.12u w=0.74u l=0.13u
X2 a_142_412# C1 Y VDD sg13_lv_pmos ad=0.2128p pd=1.5u as=0.3808p ps=2.92u w=1.12u l=0.13u
X3 a_244_412# B2 a_142_412# VDD sg13_lv_pmos ad=0.2128p pd=1.5u as=0.2128p ps=1.5u w=1.12u l=0.13u
X4 a_142_412# B1 a_244_412# VDD sg13_lv_pmos ad=0.3808p pd=2.92u as=0.2128p ps=1.5u w=1.12u l=0.13u
X5 a_244_412# A1 VDD VDD sg13_lv_pmos ad=0.2128p pd=1.5u as=0.3808p ps=2.92u w=1.12u l=0.13u
X6 VDD A2 a_244_412# VDD sg13_lv_pmos ad=0.3808p pd=2.92u as=0.2128p ps=1.5u w=1.12u l=0.13u
X7 VSS C1 Y VSS sg13_lv_nmos ad=0.1406p pd=1.12u as=0.2516p ps=2.16u w=0.74u l=0.13u
X8 a_244_140# B2 VSS VSS sg13_lv_nmos ad=0.1406p pd=1.12u as=0.1406p ps=1.12u w=0.74u l=0.13u
X9 Y B1 a_244_140# VSS sg13_lv_nmos ad=0.2516p pd=2.16u as=0.1406p ps=1.12u w=0.74u l=0.13u
.ends

.subckt sg13cmos5l_or2_1 X A B VDD VSS
X0 a_142_492# B a_48_492# VDD sg13_lv_pmos ad=0.1596p pd=1.22u as=0.2856p ps=2.36u w=0.84u l=0.13u
X1 VDD A a_142_492# VDD sg13_lv_pmos ad=0.2226p pd=1.535u as=0.1596p ps=1.22u w=0.84u l=0.13u
X2 X a_48_492# VSS VSS sg13_lv_nmos ad=0.2516p pd=2.16u as=0.1469p ps=1.155u w=0.74u l=0.13u
X3 VSS A a_48_492# VSS sg13_lv_nmos ad=0.1469p pd=1.155u as=0.1045p ps=0.93u w=0.55u l=0.13u
X4 a_48_492# B VSS VSS sg13_lv_nmos ad=0.1045p pd=0.93u as=0.187p ps=1.78u w=0.55u l=0.13u
X5 X a_48_492# VDD VDD sg13_lv_pmos ad=0.3976p pd=2.95u as=0.2226p ps=1.535u w=1.12u l=0.13u
.ends

.subckt sg13cmos5l_inv_1 Y A VDD VSS
X0 Y A VSS VSS sg13_lv_nmos ad=0.2516p pd=2.16u as=0.2516p ps=2.16u w=0.74u l=0.13u
X1 Y A VDD VDD sg13_lv_pmos ad=0.3808p pd=2.92u as=0.3808p ps=2.92u w=1.12u l=0.13u
.ends

.subckt sg13cmos5l_a22oi_1 Y A1 A2 B1 B2 VDD VSS
X0 a_398_96# A1 Y VSS sg13_lv_nmos ad=96.2f pd=1u as=0.2664p ps=1.46u w=0.74u l=0.13u
X1 Y B2 a_127_96# VSS sg13_lv_nmos ad=0.2664p pd=1.46u as=0.13875p ps=1.115u w=0.74u l=0.13u
X2 VDD A2 a_127_436# VDD sg13_lv_pmos ad=0.3808p pd=2.92u as=0.2744p ps=1.61u w=1.12u l=0.13u
X3 Y B1 a_127_436# VDD sg13_lv_pmos ad=0.2128p pd=1.5u as=0.2716p ps=1.605u w=1.12u l=0.13u
X4 a_127_436# B2 Y VDD sg13_lv_pmos ad=0.2744p pd=1.61u as=0.2128p ps=1.5u w=1.12u l=0.13u
X5 a_127_96# B1 VSS VSS sg13_lv_nmos ad=0.13875p pd=1.115u as=0.2553p ps=2.17u w=0.74u l=0.13u
X6 a_127_436# A1 VDD VDD sg13_lv_pmos ad=0.2716p pd=1.605u as=0.3808p ps=2.92u w=1.12u l=0.13u
X7 VSS A2 a_398_96# VSS sg13_lv_nmos ad=0.2516p pd=2.16u as=96.2f ps=1u w=0.74u l=0.13u
.ends

.subckt sg13cmos5l_nand2b_1 Y A_N B VDD VSS
X0 VDD a_27_156# Y VDD sg13_lv_pmos ad=0.3808p pd=2.92u as=0.2128p ps=1.5u w=1.12u l=0.13u
X1 a_229_118# B VSS VSS sg13_lv_nmos ad=0.1406p pd=1.12u as=0.14505p ps=1.15u w=0.74u l=0.13u
X2 VDD A_N a_27_156# VDD sg13_lv_pmos ad=0.2198p pd=1.53u as=0.2856p ps=2.36u w=0.84u l=0.13u
X3 Y B VDD VDD sg13_lv_pmos ad=0.2128p pd=1.5u as=0.2198p ps=1.53u w=1.12u l=0.13u
X4 Y a_27_156# a_229_118# VSS sg13_lv_nmos ad=0.333p pd=2.38u as=0.1406p ps=1.12u w=0.74u l=0.13u
X5 VSS A_N a_27_156# VSS sg13_lv_nmos ad=0.14505p pd=1.15u as=0.187p ps=1.78u w=0.55u l=0.13u
.ends

.subckt sg13cmos5l_nor3_1 Y A B C VDD VSS
X0 Y A VSS VSS sg13_lv_nmos ad=0.1694p pd=1.21u as=0.2618p ps=2.22u w=0.77u l=0.13u
X1 a_165_412# A VDD VDD sg13_lv_pmos ad=0.2464p pd=1.56u as=0.3808p ps=2.92u w=1.12u l=0.13u
X2 VSS B Y VSS sg13_lv_nmos ad=0.1463p pd=1.15u as=0.1694p ps=1.21u w=0.77u l=0.13u
X3 Y C VSS VSS sg13_lv_nmos ad=0.2618p pd=2.22u as=0.1463p ps=1.15u w=0.77u l=0.13u
X4 a_279_412# B a_165_412# VDD sg13_lv_pmos ad=0.2128p pd=1.5u as=0.2464p ps=1.56u w=1.12u l=0.13u
X5 Y C a_279_412# VDD sg13_lv_pmos ad=0.3808p pd=2.92u as=0.2128p ps=1.5u w=1.12u l=0.13u
.ends

.subckt sg13cmos5l_dfrbpq_1 Q CLK D RESET_B VDD VSS
X0 a_550_127# RESET_B VSS VSS sg13_lv_nmos ad=37.8f pd=0.6u as=0.1701p ps=1.65u w=0.42u l=0.13u
X1 a_298_337# a_741_93# a_681_505# VDD sg13_lv_pmos ad=79.8f pd=0.8u as=63f ps=0.72u w=0.42u l=0.13u
X2 a_1840_334# a_1583_191# a_2002_114# VSS sg13_lv_nmos ad=0.1428p pd=1.52u as=37.8f ps=0.6u w=0.42u l=0.13u
X3 a_38_114# a_843_236# a_298_337# VDD sg13_lv_pmos ad=0.1428p pd=1.52u as=79.8f ps=0.8u w=0.42u l=0.13u
X4 a_741_93# CLK VSS VSS sg13_lv_nmos ad=0.2516p pd=2.16u as=2.26778p ps=14.665u w=0.74u l=0.13u
X5 a_38_114# D VDD VDD sg13_lv_pmos ad=79.8f pd=0.8u as=0.1428p ps=1.52u w=0.42u l=0.13u
X6 a_741_93# CLK VDD VDD sg13_lv_pmos ad=0.4088p pd=2.97u as=1.12285p ps=7.26u w=1.12u l=0.13u
X7 VSS a_741_93# a_843_236# VSS sg13_lv_nmos ad=2.26778p pd=14.665u as=0.2516p ps=2.16u w=0.74u l=0.13u
X8 VSS a_1840_334# a_1489_191# VSS sg13_lv_nmos ad=79.8f pd=0.8u as=0.1428p ps=1.52u w=0.42u l=0.13u
X9 VDD RESET_B a_38_114# VDD sg13_lv_pmos ad=0.36237p pd=2.605u as=79.8f ps=0.8u w=0.42u l=0.13u
X10 a_324_432# a_298_337# VSS VSS sg13_lv_nmos ad=0.2516p pd=2.16u as=0.1626p ps=1.415u w=0.74u l=0.13u
X11 VDD a_741_93# a_843_236# VDD sg13_lv_pmos ad=1.12285p pd=7.26u as=0.3864p ps=2.93u w=1.12u l=0.13u
X12 a_2002_114# RESET_B VSS VSS sg13_lv_nmos ad=37.8f pd=0.6u as=79.8f ps=0.8u w=0.42u l=0.13u
X13 VDD a_1583_191# a_2250_412# VDD sg13_lv_pmos ad=0.2128p pd=1.5u as=0.3864p ps=2.93u w=1.12u l=0.13u
X14 Q a_2250_412# VDD VDD sg13_lv_pmos ad=0.3808p pd=2.92u as=0.2128p ps=1.5u w=1.12u l=0.13u
X15 a_132_114# D a_38_114# VSS sg13_lv_nmos ad=60.89999f pd=0.71u as=0.1428p ps=1.52u w=0.42u l=0.13u
X16 a_1785_429# a_843_236# a_1583_191# VDD sg13_lv_pmos ad=93.45f pd=0.865u as=0.2048p ps=1.63u w=0.42u l=0.13u
X17 VDD a_1583_191# a_1840_334# VDD sg13_lv_pmos ad=1.12285p pd=7.26u as=79.8f ps=0.8u w=0.42u l=0.13u
X18 a_1583_191# a_741_93# a_324_432# VDD sg13_lv_pmos ad=0.2048p pd=1.63u as=0.34p ps=2.68u w=1u l=0.13u
X19 a_1583_191# a_741_93# a_1489_191# VSS sg13_lv_nmos ad=0.12665p pd=1.145u as=0.1428p ps=1.52u w=0.42u l=0.13u
X20 VDD a_1840_334# a_1785_429# VDD sg13_lv_pmos ad=1.12285p pd=7.26u as=93.45f ps=0.865u w=0.42u l=0.13u
X21 a_1840_334# RESET_B VDD VDD sg13_lv_pmos ad=79.8f pd=0.8u as=1.12285p ps=7.26u w=0.42u l=0.13u
X22 a_324_432# a_843_236# a_1583_191# VSS sg13_lv_nmos ad=0.3473p pd=2.71u as=0.12665p ps=1.145u w=0.74u l=0.13u
X23 a_298_337# a_741_93# a_38_114# VSS sg13_lv_nmos ad=79.8f pd=0.8u as=0.1296p ps=1.52u w=0.42u l=0.13u
X24 a_612_127# a_324_432# a_550_127# VSS sg13_lv_nmos ad=0.1428p pd=1.52u as=37.8f ps=0.6u w=0.42u l=0.13u
X25 a_681_505# a_324_432# VDD VDD sg13_lv_pmos ad=63f pd=0.72u as=0.1563p ps=1.22u w=0.42u l=0.13u
X26 a_612_127# a_843_236# a_298_337# VSS sg13_lv_nmos ad=0.2373p pd=1.97u as=79.8f ps=0.8u w=0.42u l=0.13u
X27 VSS a_1583_191# a_2250_412# VSS sg13_lv_nmos ad=0.1406p pd=1.12u as=0.2516p ps=2.16u w=0.74u l=0.13u
X28 a_324_432# a_298_337# VDD VDD sg13_lv_pmos ad=0.34p pd=2.68u as=0.36237p ps=2.605u w=1u l=0.13u
X29 Q a_2250_412# VSS VSS sg13_lv_nmos ad=0.2516p pd=2.16u as=0.1406p ps=1.12u w=0.74u l=0.13u
X30 VDD RESET_B a_298_337# VDD sg13_lv_pmos ad=0.1563p pd=1.22u as=0.147p ps=1.54u w=0.42u l=0.13u
X31 VSS RESET_B a_132_114# VSS sg13_lv_nmos ad=0.1626p pd=1.415u as=60.89999f ps=0.71u w=0.42u l=0.13u
.ends

.subckt sg13cmos5l_nor4_2 Y A B C D VDD VSS
X0 a_140_412# A VDD VDD sg13_lv_pmos ad=0.2128p pd=1.5u as=0.3864p ps=2.93u w=1.12u l=0.13u
X1 VDD A a_140_412# VDD sg13_lv_pmos ad=0.3808p pd=2.92u as=0.2128p ps=1.5u w=1.12u l=0.13u
X2 a_140_412# B a_352_412# VDD sg13_lv_pmos ad=0.2128p pd=1.5u as=0.3808p ps=2.92u w=1.12u l=0.13u
X3 a_352_412# B a_140_412# VDD sg13_lv_pmos ad=0.2128p pd=1.5u as=0.2128p ps=1.5u w=1.12u l=0.13u
X4 a_650_412# C a_352_412# VDD sg13_lv_pmos ad=0.2128p pd=1.5u as=0.2128p ps=1.5u w=1.12u l=0.13u
X5 a_352_412# C a_650_412# VDD sg13_lv_pmos ad=0.3808p pd=2.92u as=0.2128p ps=1.5u w=1.12u l=0.13u
X6 Y A VSS VSS sg13_lv_nmos ad=0.1406p pd=1.12u as=0.2553p ps=2.17u w=0.74u l=0.13u
X7 VSS A Y VSS sg13_lv_nmos ad=0.3293p pd=1.63u as=0.1406p ps=1.12u w=0.74u l=0.13u
X8 Y D a_650_412# VDD sg13_lv_pmos ad=0.2128p pd=1.5u as=0.3808p ps=2.92u w=1.12u l=0.13u
X9 Y B VSS VSS sg13_lv_nmos ad=0.1406p pd=1.12u as=0.3293p ps=1.63u w=0.74u l=0.13u
X10 VSS B Y VSS sg13_lv_nmos ad=0.1406p pd=1.12u as=0.1406p ps=1.12u w=0.74u l=0.13u
X11 a_650_412# D Y VDD sg13_lv_pmos ad=0.3808p pd=2.92u as=0.2128p ps=1.5u w=1.12u l=0.13u
X12 Y C VSS VSS sg13_lv_nmos ad=0.1406p pd=1.12u as=0.1406p ps=1.12u w=0.74u l=0.13u
X13 VSS C Y VSS sg13_lv_nmos ad=0.3293p pd=1.63u as=0.1406p ps=1.12u w=0.74u l=0.13u
X14 Y D VSS VSS sg13_lv_nmos ad=0.1406p pd=1.12u as=0.3293p ps=1.63u w=0.74u l=0.13u
X15 VSS D Y VSS sg13_lv_nmos ad=0.2516p pd=2.16u as=0.1406p ps=1.12u w=0.74u l=0.13u
.ends

.subckt sg13cmos5l_nand4_1 Y A B C D VDD VSS
X0 Y D VDD VDD sg13_lv_pmos ad=0.2128p pd=1.5u as=0.3808p ps=2.92u w=1.12u l=0.13u
X1 VDD C Y VDD sg13_lv_pmos ad=0.2128p pd=1.5u as=0.2128p ps=1.5u w=1.12u l=0.13u
X2 Y B VDD VDD sg13_lv_pmos ad=0.2128p pd=1.5u as=0.2128p ps=1.5u w=1.12u l=0.13u
X3 VDD A Y VDD sg13_lv_pmos ad=0.3808p pd=2.92u as=0.2128p ps=1.5u w=1.12u l=0.13u
X4 a_146_122# D VSS VSS sg13_lv_nmos ad=0.1406p pd=1.12u as=0.2516p ps=2.16u w=0.74u l=0.13u
X5 a_248_122# C a_146_122# VSS sg13_lv_nmos ad=0.1406p pd=1.12u as=0.1406p ps=1.12u w=0.74u l=0.13u
X6 a_350_122# B a_248_122# VSS sg13_lv_nmos ad=0.1406p pd=1.12u as=0.1406p ps=1.12u w=0.74u l=0.13u
X7 Y A a_350_122# VSS sg13_lv_nmos ad=0.2516p pd=2.16u as=0.1406p ps=1.12u w=0.74u l=0.13u
.ends

.subckt sg13cmos5l_nand2b_2 Y A_N B VDD VSS
X0 a_116_149# A_N VDD VDD sg13_lv_pmos ad=0.2856p pd=2.36u as=0.2856p ps=2.36u w=0.84u l=0.13u
X1 Y B a_226_115# VSS sg13_lv_nmos ad=0.1368p pd=1.1u as=0.1404p ps=1.11u w=0.72u l=0.13u
X2 a_226_115# B Y VSS sg13_lv_nmos ad=0.2448p pd=2.12u as=0.1368p ps=1.1u w=0.72u l=0.13u
X3 Y B VDD VDD sg13_lv_pmos ad=0.2128p pd=1.5u as=0.2184p ps=1.51u w=1.12u l=0.13u
X4 VDD B Y VDD sg13_lv_pmos ad=0.392p pd=2.94u as=0.2128p ps=1.5u w=1.12u l=0.13u
X5 a_116_149# A_N VSS VSS sg13_lv_nmos ad=0.187p pd=1.78u as=0.187p ps=1.78u w=0.55u l=0.13u
X6 VSS a_116_149# a_226_115# VSS sg13_lv_nmos ad=0.1368p pd=1.1u as=0.2592p ps=2.16u w=0.72u l=0.13u
X7 Y a_116_149# VDD VDD sg13_lv_pmos ad=0.2128p pd=1.5u as=0.4032p ps=2.96u w=1.12u l=0.13u
X8 a_226_115# a_116_149# VSS VSS sg13_lv_nmos ad=0.1404p pd=1.11u as=0.1368p ps=1.1u w=0.72u l=0.13u
X9 VDD a_116_149# Y VDD sg13_lv_pmos ad=0.2184p pd=1.51u as=0.2128p ps=1.5u w=1.12u l=0.13u
.ends

.subckt sg13cmos5l_nor2_2 Y A B VDD VSS
X0 Y B a_52_412# VDD sg13_lv_pmos ad=0.2128p pd=1.5u as=0.2128p ps=1.5u w=1.12u l=0.13u
X1 a_52_412# B Y VDD sg13_lv_pmos ad=0.3808p pd=2.92u as=0.2128p ps=1.5u w=1.12u l=0.13u
X2 Y A VSS VSS sg13_lv_nmos ad=0.1406p pd=1.12u as=0.2516p ps=2.16u w=0.74u l=0.13u
X3 VDD A a_52_412# VDD sg13_lv_pmos ad=0.2128p pd=1.5u as=0.4032p ps=2.96u w=1.12u l=0.13u
X4 VSS A Y VSS sg13_lv_nmos ad=0.1406p pd=1.12u as=0.1406p ps=1.12u w=0.74u l=0.13u
X5 a_52_412# A VDD VDD sg13_lv_pmos ad=0.2128p pd=1.5u as=0.2128p ps=1.5u w=1.12u l=0.13u
X6 Y B VSS VSS sg13_lv_nmos ad=0.1406p pd=1.12u as=0.1406p ps=1.12u w=0.74u l=0.13u
X7 VSS B Y VSS sg13_lv_nmos ad=0.2516p pd=2.16u as=0.1406p ps=1.12u w=0.74u l=0.13u
.ends

.subckt sg13cmos5l_a21o_1 X A1 A2 B1 VDD VSS
X0 VDD A1 a_358_436# VDD sg13_lv_pmos ad=0.19p pd=1.38u as=0.2125p ps=1.425u w=1u l=0.13u
X1 VSS A2 a_494_160# VSS sg13_lv_nmos ad=0.2176p pd=1.96u as=81.6f ps=0.895u w=0.64u l=0.13u
X2 a_358_436# A2 VDD VDD sg13_lv_pmos ad=0.34p pd=2.68u as=0.19p ps=1.38u w=1u l=0.13u
X3 a_115_308# B1 VSS VSS sg13_lv_nmos ad=0.1216p pd=1.02u as=0.15745p ps=1.175u w=0.64u l=0.13u
X4 a_494_160# A1 a_115_308# VSS sg13_lv_nmos ad=81.6f pd=0.895u as=0.1216p ps=1.02u w=0.64u l=0.13u
X5 a_358_436# B1 a_115_308# VDD sg13_lv_pmos ad=0.2125p pd=1.425u as=0.35p ps=2.7u w=1u l=0.13u
X6 VDD a_115_308# X VDD sg13_lv_pmos ad=0.3808p pd=2.92u as=0.3808p ps=2.92u w=1.12u l=0.13u
X7 VSS a_115_308# X VSS sg13_lv_nmos ad=0.15745p pd=1.175u as=0.2351p ps=2.16u w=0.74u l=0.13u
.ends

.subckt sg13cmos5l_and2_1 X A B VDD VSS
X0 X a_45_160# VDD VDD sg13_lv_pmos ad=0.3808p pd=2.92u as=0.1918p ps=1.5u w=1.12u l=0.13u
X1 X a_45_160# VSS VSS sg13_lv_nmos ad=0.2516p pd=2.16u as=0.1331p ps=1.12u w=0.74u l=0.13u
X2 a_45_160# A VDD VDD sg13_lv_pmos ad=0.1596p pd=1.22u as=0.2856p ps=2.36u w=0.84u l=0.13u
X3 VDD B a_45_160# VDD sg13_lv_pmos ad=0.1918p pd=1.5u as=0.1596p ps=1.22u w=0.84u l=0.13u
X4 a_139_160# A a_45_160# VSS sg13_lv_nmos ad=0.1216p pd=1.02u as=0.2176p ps=1.96u w=0.64u l=0.13u
X5 VSS B a_139_160# VSS sg13_lv_nmos ad=0.1331p pd=1.12u as=0.1216p ps=1.02u w=0.64u l=0.13u
.ends

.subckt sg13cmos5l_xnor2_1 Y A B VDD VSS
X0 a_192_429# A VDD VDD sg13_lv_pmos ad=0.1596p pd=1.22u as=0.4536p ps=2.76u w=0.84u l=0.13u
X1 VSS A a_341_118# VSS sg13_lv_nmos ad=0.1898p pd=1.36u as=0.2516p ps=2.16u w=0.74u l=0.13u
X2 VDD B a_192_429# VDD sg13_lv_pmos ad=0.2891p pd=1.695u as=0.1596p ps=1.22u w=0.84u l=0.13u
X3 a_435_412# A VDD VDD sg13_lv_pmos ad=0.1428p pd=1.375u as=0.2891p ps=1.695u w=1.12u l=0.13u
X4 a_155_160# A VSS VSS sg13_lv_nmos ad=78.39999f pd=0.885u as=0.2272p ps=1.99u w=0.64u l=0.13u
X5 a_341_118# B VSS VSS sg13_lv_nmos ad=0.1406p pd=1.12u as=0.1898p ps=1.36u w=0.74u l=0.13u
X6 Y a_192_429# a_341_118# VSS sg13_lv_nmos ad=0.2516p pd=2.16u as=0.1406p ps=1.12u w=0.74u l=0.13u
X7 VDD a_192_429# Y VDD sg13_lv_pmos ad=0.3808p pd=2.92u as=0.2408p ps=1.55u w=1.12u l=0.13u
X8 Y B a_435_412# VDD sg13_lv_pmos ad=0.2408p pd=1.55u as=0.1428p ps=1.375u w=1.12u l=0.13u
X9 a_192_429# B a_155_160# VSS sg13_lv_nmos ad=0.2176p pd=1.96u as=78.39999f ps=0.885u w=0.64u l=0.13u
.ends

.subckt sg13cmos5l_a21o_2 X A1 A2 B1 VDD VSS
X0 a_453_436# B1 a_119_104# VDD sg13_lv_pmos ad=0.2125p pd=1.425u as=0.35p ps=2.7u w=1u l=0.13u
X1 X a_119_104# VSS VSS sg13_lv_nmos ad=0.1406p pd=1.12u as=0.2516p ps=2.16u w=0.74u l=0.13u
X2 VSS a_119_104# X VSS sg13_lv_nmos ad=0.2516p pd=2.16u as=0.1406p ps=1.12u w=0.74u l=0.13u
X3 VSS A2 a_589_140# VSS sg13_lv_nmos ad=0.2516p pd=2.16u as=94.35f ps=0.995u w=0.74u l=0.13u
X4 X a_119_104# VDD VDD sg13_lv_pmos ad=0.2128p pd=1.5u as=0.3808p ps=2.92u w=1.12u l=0.13u
X5 VDD a_119_104# X VDD sg13_lv_pmos ad=0.3808p pd=2.92u as=0.2128p ps=1.5u w=1.12u l=0.13u
X6 a_119_104# B1 VSS VSS sg13_lv_nmos ad=0.1406p pd=1.12u as=0.3811p ps=2.51u w=0.74u l=0.13u
X7 a_589_140# A1 a_119_104# VSS sg13_lv_nmos ad=94.35f pd=0.995u as=0.1406p ps=1.12u w=0.74u l=0.13u
X8 VDD A1 a_453_436# VDD sg13_lv_pmos ad=0.19p pd=1.38u as=0.2125p ps=1.425u w=1u l=0.13u
X9 a_453_436# A2 VDD VDD sg13_lv_pmos ad=0.34p pd=2.68u as=0.19p ps=1.38u w=1u l=0.13u
.ends

.subckt sg13cmos5l_buf_16 X A VDD VSS
X0 VDD a_116_82# X VDD sg13_lv_pmos ad=0.2128p pd=1.5u as=0.2128p ps=1.5u w=1.12u l=0.13u
X1 X a_116_82# VSS VSS sg13_lv_nmos ad=0.1406p pd=1.12u as=0.1406p ps=1.12u w=0.74u l=0.13u
X2 X a_116_82# VDD VDD sg13_lv_pmos ad=0.2128p pd=1.5u as=0.2128p ps=1.5u w=1.12u l=0.13u
X3 VSS a_116_82# X VSS sg13_lv_nmos ad=0.1406p pd=1.12u as=0.1406p ps=1.12u w=0.74u l=0.13u
X4 X a_116_82# VSS VSS sg13_lv_nmos ad=0.1406p pd=1.12u as=0.1406p ps=1.12u w=0.74u l=0.13u
X5 VDD a_116_82# X VDD sg13_lv_pmos ad=0.2128p pd=1.5u as=0.2128p ps=1.5u w=1.12u l=0.13u
X6 VSS a_116_82# X VSS sg13_lv_nmos ad=0.1406p pd=1.12u as=0.1406p ps=1.12u w=0.74u l=0.13u
X7 X a_116_82# VDD VDD sg13_lv_pmos ad=0.2128p pd=1.5u as=0.2128p ps=1.5u w=1.12u l=0.13u
X8 VDD a_116_82# X VDD sg13_lv_pmos ad=0.2128p pd=1.5u as=0.2128p ps=1.5u w=1.12u l=0.13u
X9 X a_116_82# VSS VSS sg13_lv_nmos ad=0.1406p pd=1.12u as=0.1406p ps=1.12u w=0.74u l=0.13u
X10 VSS A a_116_82# VSS sg13_lv_nmos ad=0.1406p pd=1.12u as=0.1406p ps=1.12u w=0.74u l=0.13u
X11 X a_116_82# VDD VDD sg13_lv_pmos ad=0.2128p pd=1.5u as=0.2128p ps=1.5u w=1.12u l=0.13u
X12 VDD A a_116_82# VDD sg13_lv_pmos ad=0.2128p pd=1.5u as=0.2128p ps=1.5u w=1.12u l=0.13u
X13 VSS a_116_82# X VSS sg13_lv_nmos ad=0.1406p pd=1.12u as=0.1406p ps=1.12u w=0.74u l=0.13u
X14 a_116_82# A VSS VSS sg13_lv_nmos ad=0.1406p pd=1.12u as=0.1406p ps=1.12u w=0.74u l=0.13u
X15 VDD a_116_82# X VDD sg13_lv_pmos ad=0.2128p pd=1.5u as=0.2128p ps=1.5u w=1.12u l=0.13u
X16 a_116_82# A VDD VDD sg13_lv_pmos ad=0.2128p pd=1.5u as=0.2128p ps=1.5u w=1.12u l=0.13u
X17 a_116_82# A VSS VSS sg13_lv_nmos ad=0.1406p pd=1.12u as=0.1406p ps=1.12u w=0.74u l=0.13u
X18 VSS A a_116_82# VSS sg13_lv_nmos ad=0.1406p pd=1.12u as=0.1406p ps=1.12u w=0.74u l=0.13u
X19 VSS A a_116_82# VSS sg13_lv_nmos ad=0.2516p pd=2.16u as=0.1406p ps=1.12u w=0.74u l=0.13u
X20 a_116_82# A VDD VDD sg13_lv_pmos ad=0.2128p pd=1.5u as=0.2128p ps=1.5u w=1.12u l=0.13u
X21 VDD A a_116_82# VDD sg13_lv_pmos ad=0.2128p pd=1.5u as=0.2128p ps=1.5u w=1.12u l=0.13u
X22 VDD A a_116_82# VDD sg13_lv_pmos ad=0.3808p pd=2.92u as=0.2128p ps=1.5u w=1.12u l=0.13u
X23 a_116_82# A VSS VSS sg13_lv_nmos ad=0.1406p pd=1.12u as=0.1406p ps=1.12u w=0.74u l=0.13u
X24 X a_116_82# VSS VSS sg13_lv_nmos ad=0.1406p pd=1.12u as=0.2516p ps=2.16u w=0.74u l=0.13u
X25 a_116_82# A VDD VDD sg13_lv_pmos ad=0.2128p pd=1.5u as=0.2128p ps=1.5u w=1.12u l=0.13u
X26 VSS a_116_82# X VSS sg13_lv_nmos ad=0.1406p pd=1.12u as=0.1406p ps=1.12u w=0.74u l=0.13u
X27 X a_116_82# VDD VDD sg13_lv_pmos ad=0.2128p pd=1.5u as=0.3976p ps=2.95u w=1.12u l=0.13u
X28 X a_116_82# VSS VSS sg13_lv_nmos ad=0.1406p pd=1.12u as=0.1406p ps=1.12u w=0.74u l=0.13u
X29 VDD a_116_82# X VDD sg13_lv_pmos ad=0.2128p pd=1.5u as=0.2128p ps=1.5u w=1.12u l=0.13u
X30 X a_116_82# VDD VDD sg13_lv_pmos ad=0.2128p pd=1.5u as=0.2128p ps=1.5u w=1.12u l=0.13u
X31 VSS a_116_82# X VSS sg13_lv_nmos ad=0.1406p pd=1.12u as=0.1406p ps=1.12u w=0.74u l=0.13u
X32 VDD a_116_82# X VDD sg13_lv_pmos ad=0.2128p pd=1.5u as=0.2128p ps=1.5u w=1.12u l=0.13u
X33 X a_116_82# VSS VSS sg13_lv_nmos ad=0.1406p pd=1.12u as=0.1406p ps=1.12u w=0.74u l=0.13u
X34 VSS a_116_82# X VSS sg13_lv_nmos ad=0.1406p pd=1.12u as=0.1406p ps=1.12u w=0.74u l=0.13u
X35 X a_116_82# VDD VDD sg13_lv_pmos ad=0.2128p pd=1.5u as=0.2128p ps=1.5u w=1.12u l=0.13u
X36 VDD a_116_82# X VDD sg13_lv_pmos ad=0.2128p pd=1.5u as=0.2128p ps=1.5u w=1.12u l=0.13u
X37 X a_116_82# VSS VSS sg13_lv_nmos ad=0.1406p pd=1.12u as=0.1406p ps=1.12u w=0.74u l=0.13u
X38 VSS a_116_82# X VSS sg13_lv_nmos ad=0.1406p pd=1.12u as=0.1406p ps=1.12u w=0.74u l=0.13u
X39 X a_116_82# VDD VDD sg13_lv_pmos ad=0.2128p pd=1.5u as=0.2128p ps=1.5u w=1.12u l=0.13u
X40 VDD a_116_82# X VDD sg13_lv_pmos ad=0.2128p pd=1.5u as=0.2128p ps=1.5u w=1.12u l=0.13u
X41 X a_116_82# VSS VSS sg13_lv_nmos ad=0.1406p pd=1.12u as=0.1406p ps=1.12u w=0.74u l=0.13u
X42 X a_116_82# VDD VDD sg13_lv_pmos ad=0.2128p pd=1.5u as=0.2128p ps=1.5u w=1.12u l=0.13u
X43 VSS a_116_82# X VSS sg13_lv_nmos ad=0.1406p pd=1.12u as=0.1406p ps=1.12u w=0.74u l=0.13u
.ends

.subckt sg13cmos5l_nand3b_1 Y A_N B C VDD VSS
X0 a_318_122# C VSS VSS sg13_lv_nmos ad=0.1406p pd=1.12u as=0.18575p ps=1.26u w=0.74u l=0.13u
X1 a_420_122# B a_318_122# VSS sg13_lv_nmos ad=0.1406p pd=1.12u as=0.1406p ps=1.12u w=0.74u l=0.13u
X2 Y a_94_160# a_420_122# VSS sg13_lv_nmos ad=0.3404p pd=2.4u as=0.1406p ps=1.12u w=0.74u l=0.13u
X3 VSS A_N a_94_160# VSS sg13_lv_nmos ad=0.18575p pd=1.26u as=0.187p ps=1.78u w=0.55u l=0.13u
X4 VDD A_N a_94_160# VDD sg13_lv_pmos ad=0.2198p pd=1.53u as=0.2856p ps=2.36u w=0.84u l=0.13u
X5 Y C VDD VDD sg13_lv_pmos ad=0.2128p pd=1.5u as=0.2198p ps=1.53u w=1.12u l=0.13u
X6 VDD B Y VDD sg13_lv_pmos ad=0.2128p pd=1.5u as=0.2128p ps=1.5u w=1.12u l=0.13u
X7 Y a_94_160# VDD VDD sg13_lv_pmos ad=0.3808p pd=2.92u as=0.2128p ps=1.5u w=1.12u l=0.13u
.ends

.subckt sg13cmos5l_a21oi_2 Y A1 A2 B1 VDD VSS
X0 VDD A2 a_47_412# VDD sg13_lv_pmos ad=0.2128p pd=1.5u as=0.3808p ps=2.92u w=1.12u l=0.13u
X1 a_47_412# A1 VDD VDD sg13_lv_pmos ad=0.2128p pd=1.5u as=0.2128p ps=1.5u w=1.12u l=0.13u
X2 VDD A1 a_47_412# VDD sg13_lv_pmos ad=0.2128p pd=1.5u as=0.2128p ps=1.5u w=1.12u l=0.13u
X3 a_47_412# A2 VDD VDD sg13_lv_pmos ad=0.2128p pd=1.5u as=0.2128p ps=1.5u w=1.12u l=0.13u
X4 Y B1 a_47_412# VDD sg13_lv_pmos ad=0.2128p pd=1.5u as=0.2128p ps=1.5u w=1.12u l=0.13u
X5 a_47_412# B1 Y VDD sg13_lv_pmos ad=0.3808p pd=2.92u as=0.2128p ps=1.5u w=1.12u l=0.13u
X6 a_141_140# A2 VSS VSS sg13_lv_nmos ad=0.1406p pd=1.12u as=0.2516p ps=2.16u w=0.74u l=0.13u
X7 Y A1 a_141_140# VSS sg13_lv_nmos ad=0.1406p pd=1.12u as=0.1406p ps=1.12u w=0.74u l=0.13u
X8 a_141_140# A1 Y VSS sg13_lv_nmos ad=0.1406p pd=1.12u as=0.1406p ps=1.12u w=0.74u l=0.13u
X9 VSS A2 a_141_140# VSS sg13_lv_nmos ad=0.1406p pd=1.12u as=0.1406p ps=1.12u w=0.74u l=0.13u
X10 Y B1 VSS VSS sg13_lv_nmos ad=0.1406p pd=1.12u as=0.1406p ps=1.12u w=0.74u l=0.13u
X11 VSS B1 Y VSS sg13_lv_nmos ad=0.2516p pd=2.16u as=0.1406p ps=1.12u w=0.74u l=0.13u
.ends

.subckt sg13cmos5l_buf_2 X A VDD VSS
X0 a_41_304# A VSS VSS sg13_lv_nmos ad=0.2176p pd=1.96u as=0.1371p ps=1.12u w=0.64u l=0.13u
X1 a_41_304# A VDD VDD sg13_lv_pmos ad=0.34p pd=2.68u as=0.2086p ps=1.5u w=1u l=0.13u
X2 X a_41_304# VSS VSS sg13_lv_nmos ad=0.1406p pd=1.12u as=0.2516p ps=2.16u w=0.74u l=0.13u
X3 X a_41_304# VDD VDD sg13_lv_pmos ad=0.2128p pd=1.5u as=0.7336p ps=3.55u w=1.12u l=0.13u
X4 VSS a_41_304# X VSS sg13_lv_nmos ad=0.1371p pd=1.12u as=0.1406p ps=1.12u w=0.74u l=0.13u
X5 VDD a_41_304# X VDD sg13_lv_pmos ad=0.2086p pd=1.5u as=0.2128p ps=1.5u w=1.12u l=0.13u
.ends

.subckt sg13cmos5l_buf_4 X A VDD VSS
X0 X a_111_82# VSS VSS sg13_lv_nmos ad=0.1406p pd=1.12u as=0.2516p ps=2.16u w=0.74u l=0.13u
X1 X a_111_82# VDD VDD sg13_lv_pmos ad=0.2128p pd=1.5u as=0.3808p ps=2.92u w=1.12u l=0.13u
X2 VSS a_111_82# X VSS sg13_lv_nmos ad=0.1406p pd=1.12u as=0.1406p ps=1.12u w=0.74u l=0.13u
X3 VDD a_111_82# X VDD sg13_lv_pmos ad=0.2128p pd=1.5u as=0.2128p ps=1.5u w=1.12u l=0.13u
X4 X a_111_82# VSS VSS sg13_lv_nmos ad=0.1406p pd=1.12u as=0.1406p ps=1.12u w=0.74u l=0.13u
X5 VSS a_111_82# X VSS sg13_lv_nmos ad=0.3293p pd=1.63u as=0.1406p ps=1.12u w=0.74u l=0.13u
X6 X a_111_82# VDD VDD sg13_lv_pmos ad=0.2128p pd=1.5u as=0.2128p ps=1.5u w=1.12u l=0.13u
X7 VDD a_111_82# X VDD sg13_lv_pmos ad=0.203p pd=1.5u as=0.2128p ps=1.5u w=1.12u l=0.13u
X8 a_111_82# A VSS VSS sg13_lv_nmos ad=0.2516p pd=2.16u as=0.3293p ps=1.63u w=0.74u l=0.13u
X9 a_111_82# A VDD VDD sg13_lv_pmos ad=0.1596p pd=1.22u as=0.203p ps=1.5u w=0.84u l=0.13u
X10 VDD A a_111_82# VDD sg13_lv_pmos ad=0.2856p pd=2.36u as=0.1596p ps=1.22u w=0.84u l=0.13u
.ends

.subckt sg13cmos5l_and3_1 X A B C VDD VSS
X0 a_170_160# A a_76_160# VSS sg13_lv_nmos ad=0.1216p pd=1.02u as=0.2176p ps=1.96u w=0.64u l=0.13u
X1 a_272_160# B a_170_160# VSS sg13_lv_nmos ad=0.1216p pd=1.02u as=0.1216p ps=1.02u w=0.64u l=0.13u
X2 VSS C a_272_160# VSS sg13_lv_nmos ad=0.1371p pd=1.12u as=0.1216p ps=1.02u w=0.64u l=0.13u
X3 VDD A a_76_160# VDD sg13_lv_pmos ad=0.1596p pd=1.22u as=0.2856p ps=2.36u w=0.84u l=0.13u
X4 a_76_160# B VDD VDD sg13_lv_pmos ad=0.1596p pd=1.22u as=0.1596p ps=1.22u w=0.84u l=0.13u
X5 VDD C a_76_160# VDD sg13_lv_pmos ad=0.36195p pd=1.84u as=0.1596p ps=1.22u w=0.84u l=0.13u
X6 X a_76_160# VDD VDD sg13_lv_pmos ad=0.3808p pd=2.92u as=0.36195p ps=1.84u w=1.12u l=0.13u
X7 X a_76_160# VSS VSS sg13_lv_nmos ad=0.2516p pd=2.16u as=0.1371p ps=1.12u w=0.74u l=0.13u
.ends

.subckt sg13cmos5l_or3_1 X A B C VDD VSS
X0 VSS A a_73_118# VSS sg13_lv_nmos ad=0.13395p pd=1.12u as=0.198p ps=1.27u w=0.55u l=0.13u
X1 X a_73_118# VSS VSS sg13_lv_nmos ad=0.2516p pd=2.16u as=0.13395p ps=1.12u w=0.74u l=0.13u
X2 VDD A a_269_412# VDD sg13_lv_pmos ad=0.3822p pd=1.84u as=0.1575p ps=1.315u w=1u l=0.13u
X3 VSS C a_73_118# VSS sg13_lv_nmos ad=0.1045p pd=0.93u as=0.187p ps=1.78u w=0.55u l=0.13u
X4 a_167_412# C a_73_118# VDD sg13_lv_pmos ad=0.19p pd=1.38u as=0.34p ps=2.68u w=1u l=0.13u
X5 a_73_118# B VSS VSS sg13_lv_nmos ad=0.198p pd=1.27u as=0.1045p ps=0.93u w=0.55u l=0.13u
X6 X a_73_118# VDD VDD sg13_lv_pmos ad=0.3808p pd=2.92u as=0.3822p ps=1.84u w=1.12u l=0.13u
X7 a_269_412# B a_167_412# VDD sg13_lv_pmos ad=0.1575p pd=1.315u as=0.19p ps=1.38u w=1u l=0.13u
.ends

.subckt sg13cmos5l_and4_1 X A B C D VDD VSS
X0 VDD D a_81_118# VDD sg13_lv_pmos ad=0.2044p pd=1.53u as=0.1848p ps=1.28u w=0.84u l=0.13u
X1 a_175_118# A a_81_118# VSS sg13_lv_nmos ad=0.1216p pd=1.02u as=0.2176p ps=1.96u w=0.64u l=0.13u
X2 a_277_118# B a_175_118# VSS sg13_lv_nmos ad=0.1216p pd=1.02u as=0.1216p ps=1.02u w=0.64u l=0.13u
X3 a_379_118# C a_277_118# VSS sg13_lv_nmos ad=0.1408p pd=1.08u as=0.1216p ps=1.02u w=0.64u l=0.13u
X4 VSS D a_379_118# VSS sg13_lv_nmos ad=0.1447p pd=1.15u as=0.1408p ps=1.08u w=0.64u l=0.13u
X5 X a_81_118# VSS VSS sg13_lv_nmos ad=0.3552p pd=2.44u as=0.1447p ps=1.15u w=0.74u l=0.13u
X6 X a_81_118# VDD VDD sg13_lv_pmos ad=0.5376p pd=3.2u as=0.2044p ps=1.53u w=1.12u l=0.13u
X7 a_81_118# A VDD VDD sg13_lv_pmos ad=0.1596p pd=1.22u as=0.2856p ps=2.36u w=0.84u l=0.13u
X8 VDD B a_81_118# VDD sg13_lv_pmos ad=0.1596p pd=1.22u as=0.1596p ps=1.22u w=0.84u l=0.13u
X9 a_81_118# C VDD VDD sg13_lv_pmos ad=0.1848p pd=1.28u as=0.1596p ps=1.22u w=0.84u l=0.13u
.ends

.subckt sg13cmos5l_nand2_2 Y A B VDD VSS
X0 VSS B a_57_115# VSS sg13_lv_nmos ad=0.1368p pd=1.1u as=0.27p ps=2.19u w=0.72u l=0.13u
X1 a_57_115# B VSS VSS sg13_lv_nmos ad=0.1404p pd=1.11u as=0.1368p ps=1.1u w=0.72u l=0.13u
X2 Y B VDD VDD sg13_lv_pmos ad=0.2128p pd=1.5u as=0.4032p ps=2.96u w=1.12u l=0.13u
X3 VDD B Y VDD sg13_lv_pmos ad=0.2184p pd=1.51u as=0.2128p ps=1.5u w=1.12u l=0.13u
X4 Y A a_57_115# VSS sg13_lv_nmos ad=0.1368p pd=1.1u as=0.1404p ps=1.11u w=0.72u l=0.13u
X5 a_57_115# A Y VSS sg13_lv_nmos ad=0.2448p pd=2.12u as=0.1368p ps=1.1u w=0.72u l=0.13u
X6 Y A VDD VDD sg13_lv_pmos ad=0.2128p pd=1.5u as=0.2184p ps=1.51u w=1.12u l=0.13u
X7 VDD A Y VDD sg13_lv_pmos ad=0.392p pd=2.94u as=0.2128p ps=1.5u w=1.12u l=0.13u
.ends

.subckt sg13cmos5l_and3_2 X A B C VDD VSS
X0 a_170_160# A a_76_160# VSS sg13_lv_nmos ad=0.1216p pd=1.02u as=0.2176p ps=1.96u w=0.64u l=0.13u
X1 a_272_160# B a_170_160# VSS sg13_lv_nmos ad=0.1216p pd=1.02u as=0.1216p ps=1.02u w=0.64u l=0.13u
X2 VSS C a_272_160# VSS sg13_lv_nmos ad=0.1371p pd=1.12u as=0.1216p ps=1.02u w=0.64u l=0.13u
X3 VDD A a_76_160# VDD sg13_lv_pmos ad=0.1596p pd=1.22u as=0.2856p ps=2.36u w=0.84u l=0.13u
X4 a_76_160# B VDD VDD sg13_lv_pmos ad=0.1596p pd=1.22u as=0.1596p ps=1.22u w=0.84u l=0.13u
X5 VDD C a_76_160# VDD sg13_lv_pmos ad=0.1956p pd=1.5u as=0.1596p ps=1.22u w=0.84u l=0.13u
X6 X a_76_160# VDD VDD sg13_lv_pmos ad=0.2128p pd=1.5u as=0.1956p ps=1.5u w=1.12u l=0.13u
X7 VDD a_76_160# X VDD sg13_lv_pmos ad=0.3808p pd=2.92u as=0.2128p ps=1.5u w=1.12u l=0.13u
X8 X a_76_160# VSS VSS sg13_lv_nmos ad=0.1406p pd=1.12u as=0.1371p ps=1.12u w=0.74u l=0.13u
X9 VSS a_76_160# X VSS sg13_lv_nmos ad=0.2516p pd=2.16u as=0.1406p ps=1.12u w=0.74u l=0.13u
.ends

.subckt sg13cmos5l_mux2_2 X A0 A1 S VDD VSS
X0 a_559_412# A1 a_382_118# VDD sg13_lv_pmos ad=0.2975p pd=1.595u as=0.2225p ps=1.445u w=1u l=0.13u
X1 VDD S a_59_156# VDD sg13_lv_pmos ad=0.253p pd=1.53u as=0.2856p ps=2.36u w=0.84u l=0.13u
X2 VSS S a_59_156# VSS sg13_lv_nmos ad=0.18945p pd=1.27u as=0.187p ps=1.78u w=0.55u l=0.13u
X3 X a_382_118# VSS VSS sg13_lv_nmos ad=0.2035p pd=1.29u as=0.148p ps=1.14u w=0.74u l=0.13u
X4 X a_382_118# VDD VDD sg13_lv_pmos ad=0.308p pd=1.67u as=0.2198p ps=1.52u w=1.12u l=0.13u
X5 a_285_118# S VSS VSS sg13_lv_nmos ad=0.13135p pd=1.095u as=0.18945p ps=1.27u w=0.74u l=0.13u
X6 a_285_412# S VDD VDD sg13_lv_pmos ad=0.3325p pd=1.665u as=0.253p ps=1.53u w=1u l=0.13u
X7 VSS a_382_118# X VSS sg13_lv_nmos ad=0.3145p pd=2.33u as=0.2035p ps=1.29u w=0.74u l=0.13u
X8 VDD a_382_118# X VDD sg13_lv_pmos ad=0.476p pd=3.09u as=0.308p ps=1.67u w=1.12u l=0.13u
X9 VSS a_59_156# a_496_118# VSS sg13_lv_nmos ad=0.148p pd=1.14u as=0.3367p ps=1.65u w=0.74u l=0.13u
X10 VDD a_59_156# a_559_412# VDD sg13_lv_pmos ad=0.2198p pd=1.52u as=0.2975p ps=1.595u w=1u l=0.13u
X11 a_382_118# A1 a_285_118# VSS sg13_lv_nmos ad=0.1628p pd=1.18u as=0.13135p ps=1.095u w=0.74u l=0.13u
X12 a_496_118# A0 a_382_118# VSS sg13_lv_nmos ad=0.3367p pd=1.65u as=0.1628p ps=1.18u w=0.74u l=0.13u
X13 a_382_118# A0 a_285_412# VDD sg13_lv_pmos ad=0.2225p pd=1.445u as=0.3325p ps=1.665u w=1u l=0.13u
.ends

.subckt sg13cmos5l_or3_2 X A B C VDD VSS
X0 VSS A a_73_118# VSS sg13_lv_nmos ad=0.13395p pd=1.12u as=0.198p ps=1.27u w=0.55u l=0.13u
X1 X a_73_118# VSS VSS sg13_lv_nmos ad=0.1443p pd=1.13u as=0.13395p ps=1.12u w=0.74u l=0.13u
X2 VSS a_73_118# X VSS sg13_lv_nmos ad=0.2516p pd=2.16u as=0.1443p ps=1.13u w=0.74u l=0.13u
X3 VDD A a_269_412# VDD sg13_lv_pmos ad=0.3822p pd=1.84u as=0.1575p ps=1.315u w=1u l=0.13u
X4 VSS C a_73_118# VSS sg13_lv_nmos ad=0.1045p pd=0.93u as=0.187p ps=1.78u w=0.55u l=0.13u
X5 a_167_412# C a_73_118# VDD sg13_lv_pmos ad=0.19p pd=1.38u as=0.34p ps=2.68u w=1u l=0.13u
X6 a_73_118# B VSS VSS sg13_lv_nmos ad=0.198p pd=1.27u as=0.1045p ps=0.93u w=0.55u l=0.13u
X7 X a_73_118# VDD VDD sg13_lv_pmos ad=0.2128p pd=1.5u as=0.3822p ps=1.84u w=1.12u l=0.13u
X8 a_269_412# B a_167_412# VDD sg13_lv_pmos ad=0.1575p pd=1.315u as=0.19p ps=1.38u w=1u l=0.13u
X9 VDD a_73_118# X VDD sg13_lv_pmos ad=0.4424p pd=3.03u as=0.2128p ps=1.5u w=1.12u l=0.13u
.ends

.subckt sg13cmos5l_xor2_1 X A B VDD VSS
X0 VSS a_209_168# X VSS sg13_lv_nmos ad=0.3108p pd=2.32u as=0.1628p ps=1.18u w=0.74u l=0.13u
X1 VDD A a_380_412# VDD sg13_lv_pmos ad=0.2128p pd=1.5u as=0.3808p ps=2.92u w=1.12u l=0.13u
X2 a_380_412# B VDD VDD sg13_lv_pmos ad=0.2128p pd=1.5u as=0.2128p ps=1.5u w=1.12u l=0.13u
X3 X a_209_168# a_380_412# VDD sg13_lv_pmos ad=0.3808p pd=2.92u as=0.2128p ps=1.5u w=1.12u l=0.13u
X4 a_177_436# A VDD VDD sg13_lv_pmos ad=0.1225p pd=1.245u as=0.36p ps=2.72u w=1u l=0.13u
X5 a_209_168# A VSS VSS sg13_lv_nmos ad=0.17462p pd=1.185u as=0.374p ps=2.46u w=0.55u l=0.13u
X6 a_209_168# B a_177_436# VDD sg13_lv_pmos ad=0.34p pd=2.68u as=0.1225p ps=1.245u w=1u l=0.13u
X7 VSS B a_209_168# VSS sg13_lv_nmos ad=0.15245p pd=1.17u as=0.17462p ps=1.185u w=0.55u l=0.13u
X8 a_474_130# A VSS VSS sg13_lv_nmos ad=88.8f pd=0.98u as=0.15245p ps=1.17u w=0.74u l=0.13u
X9 X B a_474_130# VSS sg13_lv_nmos ad=0.1628p pd=1.18u as=88.8f ps=0.98u w=0.74u l=0.13u
.ends

.subckt housekeeping_top CSB RSTB SCK SDI SDO control[0] control[100] control[101]
+ control[102] control[103] control[104] control[105] control[106] control[107] control[108]
+ control[109] control[10] control[110] control[111] control[112] control[113] control[114]
+ control[115] control[116] control[117] control[118] control[119] control[11] control[120]
+ control[121] control[122] control[123] control[124] control[125] control[126] control[127]
+ control[12] control[13] control[14] control[15] control[16] control[17] control[18]
+ control[19] control[1] control[20] control[21] control[22] control[23] control[24]
+ control[25] control[26] control[27] control[28] control[29] control[2] control[30]
+ control[31] control[32] control[33] control[34] control[35] control[36] control[37]
+ control[38] control[39] control[3] control[40] control[41] control[42] control[43]
+ control[44] control[45] control[46] control[47] control[48] control[49] control[4]
+ control[50] control[51] control[52] control[53] control[54] control[55] control[56]
+ control[57] control[58] control[59] control[5] control[60] control[61] control[62]
+ control[63] control[64] control[65] control[66] control[67] control[68] control[69]
+ control[6] control[70] control[71] control[72] control[73] control[74] control[75]
+ control[76] control[77] control[78] control[79] control[7] control[80] control[81]
+ control[82] control[83] control[84] control[85] control[86] control[87] control[88]
+ control[89] control[8] control[90] control[91] control[92] control[93] control[94]
+ control[95] control[96] control[97] control[98] control[99] control[9] mask_rev_in[0]
+ mask_rev_in[10] mask_rev_in[11] mask_rev_in[12] mask_rev_in[13] mask_rev_in[14]
+ mask_rev_in[15] mask_rev_in[16] mask_rev_in[17] mask_rev_in[18] mask_rev_in[19]
+ mask_rev_in[1] mask_rev_in[20] mask_rev_in[21] mask_rev_in[22] mask_rev_in[23] mask_rev_in[24]
+ mask_rev_in[25] mask_rev_in[26] mask_rev_in[27] mask_rev_in[28] mask_rev_in[29]
+ mask_rev_in[2] mask_rev_in[30] mask_rev_in[31] mask_rev_in[3] mask_rev_in[4] mask_rev_in[5]
+ mask_rev_in[6] mask_rev_in[7] mask_rev_in[8] mask_rev_in[9] reset sdo_ena status[0]
+ status[100] status[101] status[102] status[103] status[104] status[105] status[106]
+ status[107] status[108] status[109] status[10] status[110] status[111] status[112]
+ status[113] status[114] status[115] status[116] status[117] status[118] status[119]
+ status[11] status[120] status[121] status[122] status[123] status[124] status[125]
+ status[126] status[127] status[12] status[13] status[14] status[15] status[16] status[17]
+ status[18] status[19] status[1] status[20] status[21] status[22] status[23] status[24]
+ status[25] status[26] status[27] status[28] status[29] status[2] status[30] status[31]
+ status[32] status[33] status[34] status[35] status[36] status[37] status[38] status[39]
+ status[3] status[40] status[41] status[42] status[43] status[44] status[45] status[46]
+ status[47] status[48] status[49] status[4] status[50] status[51] status[52] status[53]
+ status[54] status[55] status[56] status[57] status[58] status[59] status[5] status[60]
+ status[61] status[62] status[63] status[64] status[65] status[66] status[67] status[68]
+ status[69] status[6] status[70] status[71] status[72] status[73] status[74] status[75]
+ status[76] status[77] status[78] status[79] status[7] status[80] status[81] status[82]
+ status[83] status[84] status[85] status[86] status[87] status[88] status[89] status[8]
+ status[90] status[91] status[92] status[93] status[94] status[95] status[96] status[97]
+ status[98] status[99] status[9] vccd vssd
XFILLER_41_1227 vccd vssd sg13cmos5l_decap_8
XFILLER_28_907 vccd vssd sg13cmos5l_decap_8
XFILLER_3_2401 vccd vssd sg13cmos5l_decap_8
XFILLER_7_2581 vccd vssd sg13cmos5l_decap_8
XFILLER_39_266 vccd vssd sg13cmos5l_decap_8
XFILLER_27_406 vccd vssd sg13cmos5l_decap_8
XFILLER_23_1650 vccd vssd sg13cmos5l_decap_8
XFILLER_3_1722 vccd vssd sg13cmos5l_decap_8
Xoutbuffers\[32\] control[32] _1700_/Q vccd vssd sg13cmos5l_buf_8
XFILLER_3_2478 vccd vssd sg13cmos5l_decap_8
XFILLER_3_1799 vccd vssd sg13cmos5l_decap_8
XFILLER_1_2191 vccd vssd sg13cmos5l_decap_8
XFILLER_36_995 vccd vssd sg13cmos5l_decap_8
XFILLER_23_623 vccd vssd sg13cmos5l_decap_8
XFILLER_19_1708 vccd vssd sg13cmos5l_decap_8
XFILLER_36_2756 vccd vssd sg13cmos5l_decap_8
XFILLER_35_1009 vccd vssd sg13cmos5l_decap_8
XFILLER_32_2609 vccd vssd sg13cmos5l_decap_8
XFILLER_22_133 vccd vssd sg13cmos5l_decap_8
XFILLER_17_2144 vccd vssd sg13cmos5l_decap_8
XFILLER_17_1421 vccd vssd sg13cmos5l_decap_8
XFILLER_30_2300 vccd vssd sg13cmos5l_decap_8
XFILLER_30_1610 vccd vssd sg13cmos5l_decap_8
XFILLER_17_1498 vccd vssd sg13cmos5l_decap_8
XFILLER_11_1064 vccd vssd sg13cmos5l_decap_8
Xhold351 _1706_/D _1471_/X vccd vssd sg13cmos5l_dlygate4sd3_1
Xhold340 hold340/X _1704_/Q vccd vssd sg13cmos5l_dlygate4sd3_1
Xhold362 _0970_/A _1803_/Q vccd vssd sg13cmos5l_dlygate4sd3_1
XFILLER_7_7 vccd vssd sg13cmos5l_decap_8
Xhold373 hold373/X _1769_/Q vccd vssd sg13cmos5l_dlygate4sd3_1
Xhold395 _1709_/D _1477_/X vccd vssd sg13cmos5l_dlygate4sd3_1
Xhold384 _0935_/A _0934_/Y vccd vssd sg13cmos5l_dlygate4sd3_1
XFILLER_8_2345 vccd vssd sg13cmos5l_decap_8
XFILLER_43_2749 vccd vssd sg13cmos5l_decap_8
XFILLER_24_2148 vccd vssd sg13cmos5l_decap_8
XFILLER_8_1666 vccd vssd sg13cmos5l_decap_8
XFILLER_41_2495 vccd vssd sg13cmos5l_decap_8
XFILLER_24_1458 vccd vssd sg13cmos5l_decap_8
XFILLER_18_406 vccd vssd sg13cmos5l_decap_8
XFILLER_4_1519 vccd vssd sg13cmos5l_decap_8
XFILLER_45_203 vccd vssd sg13cmos5l_decap_8
XFILLER_41_1761 vccd vssd sg13cmos5l_decap_8
XFILLER_2_1232 vccd vssd sg13cmos5l_decap_8
XFILLER_27_951 vccd vssd sg13cmos5l_decap_8
XFILLER_27_984 vccd vssd sg13cmos5l_decap_8
XFILLER_26_483 vccd vssd sg13cmos5l_decap_8
XFILLER_26_63 vccd vssd sg13cmos5l_decap_8
XFILLER_14_623 vccd vssd sg13cmos5l_decap_8
XFILLER_41_442 vccd vssd sg13cmos5l_decap_8
XFILLER_18_1218 vccd vssd sg13cmos5l_decap_8
XFILLER_13_133 vccd vssd sg13cmos5l_decap_8
XFILLER_42_987 vccd vssd sg13cmos5l_decap_8
XFILLER_35_1510 vccd vssd sg13cmos5l_decap_8
XFILLER_35_2299 vccd vssd sg13cmos5l_decap_8
XFILLER_35_1565 vccd vssd sg13cmos5l_decap_8
XFILLER_31_1407 vccd vssd sg13cmos5l_decap_8
XFILLER_9_126 vccd vssd sg13cmos5l_decap_8
XFILLER_13_2531 vccd vssd sg13cmos5l_decap_8
XFILLER_42_84 vccd vssd sg13cmos5l_decap_8
XFILLER_10_840 vccd vssd sg13cmos5l_decap_8
XFILLER_6_833 vccd vssd sg13cmos5l_decap_8
XFILLER_13_1841 vccd vssd sg13cmos5l_decap_8
XFILLER_5_343 vccd vssd sg13cmos5l_decap_8
XFILLER_29_1314 vccd vssd sg13cmos5l_decap_8
XFILLER_42_2226 vccd vssd sg13cmos5l_decap_8
XFILLER_3_56 vccd vssd sg13cmos5l_decap_8
XFILLER_1_560 vccd vssd sg13cmos5l_decap_8
X_1270_ _1270_/Y _1267_/Y _1268_/X _1269_/Y vccd vssd sg13cmos5l_o21ai_1
XFILLER_24_2671 vccd vssd sg13cmos5l_decap_8
XFILLER_42_1547 vccd vssd sg13cmos5l_decap_8
XFILLER_20_2513 vccd vssd sg13cmos5l_decap_8
XFILLER_4_2776 vccd vssd sg13cmos5l_decap_8
XFILLER_7_1176 vccd vssd sg13cmos5l_decap_8
XFILLER_37_726 vccd vssd sg13cmos5l_decap_8
XFILLER_36_203 vccd vssd sg13cmos5l_decap_8
XFILLER_3_1029 vccd vssd sg13cmos5l_decap_8
XFILLER_0_2618 vccd vssd sg13cmos5l_decap_8
XFILLER_18_973 vccd vssd sg13cmos5l_decap_8
XFILLER_45_770 vccd vssd sg13cmos5l_decap_8
Xoutbuffers\[122\] control[122] _1790_/Q vccd vssd sg13cmos5l_buf_8
XFILLER_18_2420 vccd vssd sg13cmos5l_decap_8
XFILLER_17_483 vccd vssd sg13cmos5l_decap_8
XFILLER_0_1939 vccd vssd sg13cmos5l_decap_8
XFILLER_44_280 vccd vssd sg13cmos5l_decap_8
XFILLER_32_420 vccd vssd sg13cmos5l_decap_8
Xclkbuf_3_0_0_SCK clkbuf_5_3_0_SCK/A clkbuf_0_SCK/X vccd vssd sg13cmos5l_buf_8
XFILLER_20_637 vccd vssd sg13cmos5l_decap_8
XFILLER_18_2497 vccd vssd sg13cmos5l_decap_8
XFILLER_18_1785 vccd vssd sg13cmos5l_decap_8
XFILLER_34_1053 vccd vssd sg13cmos5l_decap_8
X_0985_ _1014_/B _0985_/A _1074_/A vccd vssd sg13cmos5l_nor2b_1
XFILLER_12_2030 vccd vssd sg13cmos5l_decap_8
XFILLER_14_1638 vccd vssd sg13cmos5l_decap_8
XFILLER_31_2675 vccd vssd sg13cmos5l_decap_8
XFILLER_31_1963 vccd vssd sg13cmos5l_decap_8
XFILLER_9_693 vccd vssd sg13cmos5l_decap_8
XFILLER_12_1351 vccd vssd sg13cmos5l_decap_8
X_1606_ _1606_/Y _1644_/A _1617_/B_N vccd vssd sg13cmos5l_nor2b_1
XFILLER_25_2402 vccd vssd sg13cmos5l_decap_8
X_1537_ _1537_/Y _1562_/A _1541_/S vccd vssd sg13cmos5l_nor2_1
Xfanout116 fanout116/X fanout117/X vccd vssd sg13cmos5l_buf_1
XFILLER_25_1701 vccd vssd sg13cmos5l_decap_8
Xfanout127 fanout127/X fanout129/X vccd vssd sg13cmos5l_buf_1
Xfanout105 _1560_/A _1443_/A vccd vssd sg13cmos5l_buf_1
Xfanout138 _1644_/B_N fanout140/X vccd vssd sg13cmos5l_buf_1
XFILLER_9_2687 vccd vssd sg13cmos5l_decap_8
X_1468_ _1468_/X hold524/X hold369/X _1471_/S vccd vssd sg13cmos5l_mux2_1
Xfanout149 _1629_/A CSB vccd vssd sg13cmos5l_buf_1
XFILLER_5_1806 vccd vssd sg13cmos5l_decap_8
XFILLER_9_1953 vccd vssd sg13cmos5l_decap_8
X_1399_ _1650_/D _1478_/A _1445_/A _1401_/B vccd vssd sg13cmos5l_mux2_1
XFILLER_41_1057 vccd vssd sg13cmos5l_decap_8
XFILLER_28_748 vccd vssd sg13cmos5l_decap_8
XFILLER_27_203 vccd vssd sg13cmos5l_decap_8
XFILLER_3_2275 vccd vssd sg13cmos5l_decap_8
XFILLER_23_1491 vccd vssd sg13cmos5l_decap_8
XFILLER_24_910 vccd vssd sg13cmos5l_decap_8
XFILLER_3_1596 vccd vssd sg13cmos5l_decap_8
XFILLER_42_239 vccd vssd sg13cmos5l_decap_8
XFILLER_35_280 vccd vssd sg13cmos5l_decap_8
XFILLER_23_420 vccd vssd sg13cmos5l_decap_8
XFILLER_19_1505 vccd vssd sg13cmos5l_decap_8
XFILLER_36_2553 vccd vssd sg13cmos5l_decap_8
XFILLER_24_987 vccd vssd sg13cmos5l_decap_8
XFILLER_23_497 vccd vssd sg13cmos5l_decap_8
XFILLER_11_637 vccd vssd sg13cmos5l_decap_8
XFILLER_32_1727 vccd vssd sg13cmos5l_decap_8
XFILLER_10_147 vccd vssd sg13cmos5l_decap_8
XFILLER_12_21 vccd vssd sg13cmos5l_decap_8
XFILLER_30_2163 vccd vssd sg13cmos5l_decap_8
XFILLER_17_1295 vccd vssd sg13cmos5l_decap_8
XFILLER_13_1148 vccd vssd sg13cmos5l_decap_8
XFILLER_30_1440 vccd vssd sg13cmos5l_decap_8
XFILLER_10_2759 vccd vssd sg13cmos5l_decap_8
XFILLER_3_847 vccd vssd sg13cmos5l_decap_8
XFILLER_12_98 vccd vssd sg13cmos5l_decap_8
XFILLER_2_357 vccd vssd sg13cmos5l_decap_8
Xhold192 hold192/X _0827_/Y vccd vssd sg13cmos5l_dlygate4sd3_1
Xhold181 hold181/X _0828_/Y vccd vssd sg13cmos5l_dlygate4sd3_1
XFILLER_8_2142 vccd vssd sg13cmos5l_decap_8
XFILLER_4_1316 vccd vssd sg13cmos5l_decap_8
XFILLER_8_1463 vccd vssd sg13cmos5l_decap_8
XFILLER_18_203 vccd vssd sg13cmos5l_decap_8
XFILLER_37_84 vccd vssd sg13cmos5l_decap_8
XFILLER_33_217 vccd vssd sg13cmos5l_decap_8
XFILLER_27_770 vccd vssd sg13cmos5l_decap_8
XFILLER_15_910 vccd vssd sg13cmos5l_decap_8
XFILLER_26_280 vccd vssd sg13cmos5l_decap_8
XFILLER_14_420 vccd vssd sg13cmos5l_decap_8
XFILLER_37_1638 vccd vssd sg13cmos5l_decap_8
XFILLER_30_924 vccd vssd sg13cmos5l_decap_8
XFILLER_19_2762 vccd vssd sg13cmos5l_decap_8
XFILLER_18_1015 vccd vssd sg13cmos5l_decap_8
XFILLER_15_987 vccd vssd sg13cmos5l_decap_8
XFILLER_35_1340 vccd vssd sg13cmos5l_decap_8
XFILLER_14_497 vccd vssd sg13cmos5l_decap_8
XFILLER_15_1925 vccd vssd sg13cmos5l_decap_8
XFILLER_6_630 vccd vssd sg13cmos5l_decap_8
XFILLER_5_140 vccd vssd sg13cmos5l_decap_8
XFILLER_44_1609 vccd vssd sg13cmos5l_decap_8
XFILLER_42_2001 vccd vssd sg13cmos5l_decap_8
XFILLER_26_2733 vccd vssd sg13cmos5l_decap_8
X_1322_ _1322_/Y status[17] _1010_/Y _1324_/B vccd vssd sg13cmos5l_a21oi_1
XFILLER_29_1199 vccd vssd sg13cmos5l_decap_8
XFILLER_42_1344 vccd vssd sg13cmos5l_decap_8
X_1253_ _1253_/Y mask_rev_in[3] _1210_/B _1251_/Y _1252_/Y _1306_/B vccd vssd sg13cmos5l_a221oi_1
Xtiedowns\[112\] status[112] vccd vssd sg13cmos5l_antennanp
XFILLER_20_2332 vccd vssd sg13cmos5l_decap_8
XFILLER_0_2415 vccd vssd sg13cmos5l_decap_8
XFILLER_4_2562 vccd vssd sg13cmos5l_decap_8
X_1184_ _1184_/Y _0860_/Y _1361_/B _1142_/B vccd vssd sg13cmos5l_a21oi_1
XFILLER_37_545 vccd vssd sg13cmos5l_decap_8
XFILLER_20_2387 vccd vssd sg13cmos5l_decap_8
XFILLER_24_217 vccd vssd sg13cmos5l_decap_8
XFILLER_20_1675 vccd vssd sg13cmos5l_decap_8
XFILLER_18_770 vccd vssd sg13cmos5l_decap_8
XFILLER_0_1736 vccd vssd sg13cmos5l_decap_8
XFILLER_4_1883 vccd vssd sg13cmos5l_decap_8
XFILLER_17_280 vccd vssd sg13cmos5l_decap_8
XFILLER_18_2250 vccd vssd sg13cmos5l_decap_8
XFILLER_36_1137 vccd vssd sg13cmos5l_decap_4
XFILLER_33_2748 vccd vssd sg13cmos5l_decap_8
XFILLER_21_924 vccd vssd sg13cmos5l_decap_8
XFILLER_14_2114 vccd vssd sg13cmos5l_decap_8
XFILLER_32_294 vccd vssd sg13cmos5l_decap_8
XFILLER_20_434 vccd vssd sg13cmos5l_decap_8
XFILLER_18_1582 vccd vssd sg13cmos5l_decap_8
X_0968_ _0995_/B _0997_/A _0997_/B vccd vssd sg13cmos5l_or2_1
XFILLER_14_1435 vccd vssd sg13cmos5l_decap_8
XFILLER_9_490 vccd vssd sg13cmos5l_decap_8
X_0899_ _0904_/B _0899_/A _1403_/B vccd vssd sg13cmos5l_nor2_1
XFILLER_40_2708 vccd vssd sg13cmos5l_decap_8
XFILLER_9_1750 vccd vssd sg13cmos5l_decap_8
XFILLER_5_1603 vccd vssd sg13cmos5l_decap_8
XFILLER_5_2359 vccd vssd sg13cmos5l_decap_8
XFILLER_16_707 vccd vssd sg13cmos5l_decap_8
XFILLER_3_2072 vccd vssd sg13cmos5l_decap_8
XFILLER_38_2637 vccd vssd sg13cmos5l_decap_8
XFILLER_15_217 vccd vssd sg13cmos5l_decap_8
XFILLER_19_1302 vccd vssd sg13cmos5l_decap_8
X_1625__156 _1661_/CLK _1652_/CLK vccd vssd sg13cmos5l_inv_1
XFILLER_3_1393 vccd vssd sg13cmos5l_decap_8
XFILLER_38_1947 vccd vssd sg13cmos5l_decap_8
XFILLER_19_2058 vccd vssd sg13cmos5l_decap_8
XFILLER_24_784 vccd vssd sg13cmos5l_decap_8
XFILLER_19_1379 vccd vssd sg13cmos5l_decap_8
XFILLER_12_924 vccd vssd sg13cmos5l_decap_8
XFILLER_32_2247 vccd vssd sg13cmos5l_decap_8
XFILLER_23_294 vccd vssd sg13cmos5l_decap_8
XFILLER_23_42 vccd vssd sg13cmos5l_decap_8
XFILLER_8_917 vccd vssd sg13cmos5l_decap_8
XFILLER_11_434 vccd vssd sg13cmos5l_decap_8
XFILLER_32_1557 vccd vssd sg13cmos5l_decap_4
XFILLER_17_1092 vccd vssd sg13cmos5l_decap_8
XFILLER_7_427 vccd vssd sg13cmos5l_decap_8
XFILLER_14_2692 vccd vssd sg13cmos5l_decap_8
XFILLER_3_644 vccd vssd sg13cmos5l_decap_8
XFILLER_10_1855 vccd vssd sg13cmos5l_decap_8
XFILLER_45_1918 vccd vssd sg13cmos5l_decap_8
XFILLER_26_1306 vccd vssd sg13cmos5l_decap_4
XFILLER_2_154 vccd vssd sg13cmos5l_decap_8
Xtiedowns\[31\] status[31] vccd vssd sg13cmos5l_antennanp
XFILLER_43_2365 vccd vssd sg13cmos5l_decap_8
XFILLER_8_1260 vccd vssd sg13cmos5l_decap_8
XFILLER_1_2702 vccd vssd sg13cmos5l_decap_8
XFILLER_4_1113 vccd vssd sg13cmos5l_decap_8
XFILLER_24_1074 vccd vssd sg13cmos5l_decap_8
XFILLER_21_2685 vccd vssd sg13cmos5l_decap_8
XFILLER_0_35 vccd vssd sg13cmos5l_decap_8
XFILLER_19_567 vccd vssd sg13cmos5l_decap_8
XFILLER_1_2779 vccd vssd sg13cmos5l_decap_8
XFILLER_15_2423 vccd vssd sg13cmos5l_decap_8
XFILLER_15_784 vccd vssd sg13cmos5l_decap_8
XFILLER_30_743 vccd vssd sg13cmos5l_decap_8
XFILLER_15_1722 vccd vssd sg13cmos5l_decap_8
XFILLER_9_77 vccd vssd sg13cmos5l_decap_8
XFILLER_14_294 vccd vssd sg13cmos5l_decap_8
XFILLER_32_2770 vccd vssd sg13cmos5l_decap_8
XFILLER_31_1023 vccd vssd sg13cmos5l_decap_8
XFILLER_15_1799 vccd vssd sg13cmos5l_decap_8
XFILLER_31_1089 vccd vssd sg13cmos5l_decap_8
XFILLER_7_994 vccd vssd sg13cmos5l_decap_8
XFILLER_44_1406 vccd vssd sg13cmos5l_decap_8
XFILLER_26_2541 vccd vssd sg13cmos5l_decap_8
XFILLER_29_0 vccd vssd sg13cmos5l_decap_8
XFILLER_22_2438 vccd vssd sg13cmos5l_decap_8
XFILLER_6_2657 vccd vssd sg13cmos5l_decap_8
XFILLER_9_1057 vccd vssd sg13cmos5l_decap_8
X_1305_ _1658_/D hold188/X _1391_/A2 _1303_/Y _1304_/Y vccd vssd sg13cmos5l_a22oi_1
XFILLER_38_821 vccd vssd sg13cmos5l_decap_8
XFILLER_22_1704 vccd vssd sg13cmos5l_decap_8
XFILLER_6_1967 vccd vssd sg13cmos5l_decap_8
X_1236_ _1236_/Y _1783_/Q _1578_/B vccd vssd sg13cmos5l_nand2b_1
XFILLER_0_2212 vccd vssd sg13cmos5l_decap_8
XFILLER_37_364 vccd vssd sg13cmos5l_decap_8
X_1167_ _1167_/Y _1673_/Q _1382_/A vccd vssd sg13cmos5l_nor2_1
XFILLER_25_504 vccd vssd sg13cmos5l_decap_8
XFILLER_4_1680 vccd vssd sg13cmos5l_decap_8
XFILLER_20_1472 vccd vssd sg13cmos5l_decap_8
XFILLER_0_2289 vccd vssd sg13cmos5l_decap_8
XFILLER_0_1533 vccd vssd sg13cmos5l_decap_8
X_1098_ _1098_/Y status[30] _1321_/B _1011_/X vccd vssd sg13cmos5l_o21ai_1
XFILLER_40_518 vccd vssd sg13cmos5l_decap_8
XFILLER_16_2209 vccd vssd sg13cmos5l_decap_8
XFILLER_37_2681 vccd vssd sg13cmos5l_decap_8
XFILLER_33_570 vccd vssd sg13cmos5l_decap_8
XFILLER_21_721 vccd vssd sg13cmos5l_decap_8
XFILLER_16_1519 vccd vssd sg13cmos5l_decap_8
XFILLER_33_2545 vccd vssd sg13cmos5l_decap_8
XFILLER_33_1800 vccd vssd sg13cmos5l_decap_8
XFILLER_20_231 vccd vssd sg13cmos5l_decap_8
XFILLER_21_798 vccd vssd sg13cmos5l_decap_8
XFILLER_14_1232 vccd vssd sg13cmos5l_decap_8
XFILLER_44_2674 vccd vssd sg13cmos5l_decap_8
XFILLER_44_1940 vccd vssd sg13cmos5l_decap_4
XFILLER_40_2505 vccd vssd sg13cmos5l_decap_8
XFILLER_0_658 vccd vssd sg13cmos5l_decap_8
XFILLER_5_1400 vccd vssd sg13cmos5l_decap_8
XFILLER_44_1984 vccd vssd sg13cmos5l_decap_8
XFILLER_29_821 vccd vssd sg13cmos5l_decap_8
XFILLER_1_2009 vccd vssd sg13cmos5l_decap_8
XFILLER_5_2156 vccd vssd sg13cmos5l_decap_8
XFILLER_40_1848 vccd vssd sg13cmos5l_decap_8
XFILLER_25_1383 vccd vssd sg13cmos5l_decap_8
XFILLER_18_42 vccd vssd sg13cmos5l_decap_8
XFILLER_28_364 vccd vssd sg13cmos5l_decap_8
XFILLER_16_504 vccd vssd sg13cmos5l_decap_8
XFILLER_5_1477 vccd vssd sg13cmos5l_decap_8
XFILLER_44_835 vccd vssd sg13cmos5l_decap_8
XFILLER_3_1190 vccd vssd sg13cmos5l_decap_8
XFILLER_38_1733 vccd vssd sg13cmos5l_decap_8
XFILLER_34_63 vccd vssd sg13cmos5l_decap_8
XFILLER_24_581 vccd vssd sg13cmos5l_decap_8
XFILLER_16_2743 vccd vssd sg13cmos5l_decap_8
XFILLER_12_721 vccd vssd sg13cmos5l_decap_8
XFILLER_19_1176 vccd vssd sg13cmos5l_decap_8
XFILLER_16_2776 vccd vssd sg13cmos5l_decap_8
XFILLER_11_231 vccd vssd sg13cmos5l_decap_8
XFILLER_32_1321 vccd vssd sg13cmos5l_decap_8
XFILLER_15_1029 vccd vssd sg13cmos5l_decap_8
XFILLER_8_714 vccd vssd sg13cmos5l_decap_8
XFILLER_12_798 vccd vssd sg13cmos5l_decap_8
XFILLER_7_224 vccd vssd sg13cmos5l_decap_8
XFILLER_10_2331 vccd vssd sg13cmos5l_decap_8
XFILLER_12_1939 vccd vssd sg13cmos5l_decap_8
Xtiedowns\[79\] status[79] vccd vssd sg13cmos5l_antennanp
XFILLER_4_931 vccd vssd sg13cmos5l_decap_8
XFILLER_10_1652 vccd vssd sg13cmos5l_decap_8
XFILLER_3_441 vccd vssd sg13cmos5l_decap_8
XFILLER_45_1715 vccd vssd sg13cmos5l_decap_8
XFILLER_26_1114 vccd vssd sg13cmos5l_decap_4
XFILLER_26_1103 vccd vssd sg13cmos5l_decap_4
XFILLER_23_2725 vccd vssd sg13cmos5l_decap_8
XFILLER_22_7 vccd vssd sg13cmos5l_decap_8
X_1021_ _1021_/Y _1029_/A _1021_/B _1058_/B vccd vssd sg13cmos5l_nor3_1
XFILLER_21_2482 vccd vssd sg13cmos5l_decap_8
XFILLER_19_364 vccd vssd sg13cmos5l_decap_8
XFILLER_1_1820 vccd vssd sg13cmos5l_decap_8
XFILLER_34_301 vccd vssd sg13cmos5l_decap_8
XFILLER_1_2576 vccd vssd sg13cmos5l_decap_8
XFILLER_1_1897 vccd vssd sg13cmos5l_decap_8
XFILLER_22_518 vccd vssd sg13cmos5l_decap_8
XFILLER_15_581 vccd vssd sg13cmos5l_decap_8
XFILLER_37_1276 vccd vssd sg13cmos5l_decap_8
XFILLER_15_2231 vccd vssd sg13cmos5l_decap_8
XFILLER_30_2729 vccd vssd sg13cmos5l_decap_8
XFILLER_30_573 vccd vssd sg13cmos5l_decap_8
XFILLER_11_2128 vccd vssd sg13cmos5l_decap_8
X_1785_ _1785_/Q _1795_/CLK _1785_/D fanout117/X vccd vssd sg13cmos5l_dfrbpq_1
XFILLER_15_1596 vccd vssd sg13cmos5l_decap_8
XFILLER_11_1449 vccd vssd sg13cmos5l_decap_8
Xfanout7 _1542_/B _1531_/Y vccd vssd sg13cmos5l_buf_1
XFILLER_7_791 vccd vssd sg13cmos5l_decap_8
XFILLER_28_2658 vccd vssd sg13cmos5l_decap_8
XFILLER_44_1203 vccd vssd sg13cmos5l_decap_8
Xoutbuffers\[62\] control[62] _1730_/Q vccd vssd sg13cmos5l_buf_8
XFILLER_28_1924 vccd vssd sg13cmos5l_decap_8
XFILLER_6_2443 vccd vssd sg13cmos5l_decap_8
XFILLER_22_2235 vccd vssd sg13cmos5l_decap_8
XFILLER_6_1764 vccd vssd sg13cmos5l_decap_8
XFILLER_39_2710 vccd vssd sg13cmos5l_decap_8
XFILLER_22_1578 vccd vssd sg13cmos5l_decap_8
X_1219_ _1660_/D hold194/X _1391_/A2 _1218_/Y _1217_/Y vccd vssd sg13cmos5l_a22oi_1
XFILLER_2_1617 vccd vssd sg13cmos5l_decap_8
XFILLER_37_161 vccd vssd sg13cmos5l_decap_8
XFILLER_25_301 vccd vssd sg13cmos5l_decap_8
XFILLER_0_1330 vccd vssd sg13cmos5l_decap_8
XFILLER_39_2787 vccd vssd sg13cmos5l_decap_4
XFILLER_26_868 vccd vssd sg13cmos5l_decap_8
XFILLER_0_2086 vccd vssd sg13cmos5l_decap_8
XFILLER_41_838 vccd vssd sg13cmos5l_decap_8
XFILLER_40_315 vccd vssd sg13cmos5l_decap_8
XFILLER_34_890 vccd vssd sg13cmos5l_decap_8
XFILLER_25_378 vccd vssd sg13cmos5l_decap_8
XFILLER_16_2028 vccd vssd sg13cmos5l_decap_8
XFILLER_13_518 vccd vssd sg13cmos5l_decap_8
XFILLER_16_1316 vccd vssd sg13cmos5l_decap_8
XFILLER_33_2397 vccd vssd sg13cmos5l_decap_8
XFILLER_33_1663 vccd vssd sg13cmos5l_decap_8
XFILLER_21_595 vccd vssd sg13cmos5l_decap_8
XFILLER_5_728 vccd vssd sg13cmos5l_decap_8
XFILLER_11_2662 vccd vssd sg13cmos5l_decap_8
XFILLER_20_21 vccd vssd sg13cmos5l_decap_8
XFILLER_4_238 vccd vssd sg13cmos5l_decap_8
XFILLER_20_98 vccd vssd sg13cmos5l_decap_8
XFILLER_1_945 vccd vssd sg13cmos5l_decap_8
XFILLER_44_2471 vccd vssd sg13cmos5l_decap_8
XFILLER_27_2168 vccd vssd sg13cmos5l_decap_8
XFILLER_0_455 vccd vssd sg13cmos5l_decap_8
XFILLER_40_2324 vccd vssd sg13cmos5l_decap_8
XFILLER_29_63 vccd vssd sg13cmos5l_decap_8
XFILLER_21_1022 vccd vssd sg13cmos5l_decap_8
XFILLER_5_1274 vccd vssd sg13cmos5l_decap_8
XFILLER_28_161 vccd vssd sg13cmos5l_decap_8
XFILLER_16_301 vccd vssd sg13cmos5l_decap_8
XFILLER_1_1127 vccd vssd sg13cmos5l_decap_8
XFILLER_21_1099 vccd vssd sg13cmos5l_decap_8
XFILLER_17_868 vccd vssd sg13cmos5l_decap_8
XFILLER_45_84 vccd vssd sg13cmos5l_decap_8
XFILLER_44_698 vccd vssd sg13cmos5l_decap_8
XFILLER_34_2128 vccd vssd sg13cmos5l_decap_8
XFILLER_31_315 vccd vssd sg13cmos5l_decap_8
XFILLER_16_378 vccd vssd sg13cmos5l_decap_8
XFILLER_43_197 vccd vssd sg13cmos5l_decap_4
XFILLER_34_1427 vccd vssd sg13cmos5l_decap_8
XFILLER_8_511 vccd vssd sg13cmos5l_decap_8
XFILLER_16_1883 vccd vssd sg13cmos5l_decap_8
XFILLER_12_595 vccd vssd sg13cmos5l_decap_8
XFILLER_8_588 vccd vssd sg13cmos5l_decap_8
XFILLER_12_1736 vccd vssd sg13cmos5l_decap_8
XANTENNA_5 RSTB vccd vssd sg13cmos5l_antennanp
X_1570_ _1772_/D _1590_/A1 _1577_/S hold465/X vccd vssd sg13cmos5l_o21ai_1
XFILLER_6_56 vccd vssd sg13cmos5l_decap_8
XFILLER_45_1512 vccd vssd sg13cmos5l_decap_8
XFILLER_45_2268 vccd vssd sg13cmos5l_decap_8
XFILLER_39_415 vccd vssd sg13cmos5l_decap_4
XFILLER_23_2522 vccd vssd sg13cmos5l_decap_8
XFILLER_45_1589 vccd vssd sg13cmos5l_decap_8
XFILLER_39_448 vccd vssd sg13cmos5l_decap_8
XFILLER_3_1904 vccd vssd sg13cmos5l_decap_8
XFILLER_23_2599 vccd vssd sg13cmos5l_decap_8
XFILLER_23_1876 vccd vssd sg13cmos5l_decap_8
XFILLER_19_161 vccd vssd sg13cmos5l_decap_8
XFILLER_1_2373 vccd vssd sg13cmos5l_decap_8
X_1004_ _1004_/Y status[47] _1317_/B1 _1000_/Y _1002_/Y _1142_/B vccd vssd sg13cmos5l_a221oi_1
XFILLER_39_1327 vccd vssd sg13cmos5l_decap_8
XFILLER_23_805 vccd vssd sg13cmos5l_decap_8
XFILLER_34_175 vccd vssd sg13cmos5l_decap_8
XFILLER_22_315 vccd vssd sg13cmos5l_decap_8
XFILLER_1_1694 vccd vssd sg13cmos5l_decap_8
XFILLER_17_1603 vccd vssd sg13cmos5l_decap_8
Xoutbuffers\[6\] control[6] _1674_/Q vccd vssd sg13cmos5l_buf_8
XFILLER_37_1084 vccd vssd sg13cmos5l_decap_8
XFILLER_34_2651 vccd vssd sg13cmos5l_decap_8
XFILLER_34_1961 vccd vssd sg13cmos5l_decap_8
XFILLER_30_392 vccd vssd sg13cmos5l_decap_8
XFILLER_15_2072 vccd vssd sg13cmos5l_decap_8
Xhold500 hold500/X _1783_/Q vccd vssd sg13cmos5l_dlygate4sd3_1
XFILLER_30_1869 vccd vssd sg13cmos5l_decap_8
XFILLER_30_1847 vccd vssd sg13cmos5l_decap_8
Xhold511 hold511/X _1599_/Y vccd vssd sg13cmos5l_dlygate4sd3_1
XFILLER_15_1393 vccd vssd sg13cmos5l_decap_8
XFILLER_11_1246 vccd vssd sg13cmos5l_decap_8
X_1768_ _1768_/Q clkload8/A _1768_/D fanout118/X vccd vssd sg13cmos5l_dfrbpq_1
XFILLER_28_2422 vccd vssd sg13cmos5l_decap_8
Xhold522 hold522/X _1652_/Q vccd vssd sg13cmos5l_dlygate4sd3_1
Xhold533 hold533/X _1658_/Q vccd vssd sg13cmos5l_dlygate4sd3_1
X_1699_ _1699_/Q _1699_/CLK _1699_/D fanout135/X vccd vssd sg13cmos5l_dfrbpq_1
XFILLER_28_1721 vccd vssd sg13cmos5l_decap_8
XFILLER_8_2527 vccd vssd sg13cmos5l_decap_8
XFILLER_44_1000 vccd vssd sg13cmos5l_decap_8
XFILLER_41_2600 vccd vssd sg13cmos5l_decap_8
XFILLER_28_2499 vccd vssd sg13cmos5l_decap_8
XFILLER_28_1798 vccd vssd sg13cmos5l_decap_8
XFILLER_22_2010 vccd vssd sg13cmos5l_decap_8
XFILLER_6_2240 vccd vssd sg13cmos5l_decap_8
XFILLER_8_1848 vccd vssd sg13cmos5l_decap_8
XFILLER_44_1077 vccd vssd sg13cmos5l_decap_8
XFILLER_41_2677 vccd vssd sg13cmos5l_decap_8
XFILLER_41_1943 vccd vssd sg13cmos5l_decap_8
XFILLER_2_1414 vccd vssd sg13cmos5l_decap_8
XFILLER_6_1561 vccd vssd sg13cmos5l_decap_8
XFILLER_14_805 vccd vssd sg13cmos5l_decap_8
XFILLER_39_2584 vccd vssd sg13cmos5l_decap_8
XFILLER_25_175 vccd vssd sg13cmos5l_decap_8
XFILLER_13_315 vccd vssd sg13cmos5l_decap_8
XFILLER_15_21 vccd vssd sg13cmos5l_decap_8
XFILLER_41_635 vccd vssd sg13cmos5l_decap_8
XFILLER_40_112 vccd vssd sg13cmos5l_decap_8
XFILLER_39_1894 vccd vssd sg13cmos5l_decap_8
XFILLER_16_1113 vccd vssd sg13cmos5l_decap_8
XFILLER_9_308 vccd vssd sg13cmos5l_decap_8
XFILLER_13_2702 vccd vssd sg13cmos5l_decap_8
XFILLER_15_98 vccd vssd sg13cmos5l_decap_8
XFILLER_40_189 vccd vssd sg13cmos5l_decap_8
XFILLER_33_2183 vccd vssd sg13cmos5l_decap_8
XFILLER_22_882 vccd vssd sg13cmos5l_decap_8
XFILLER_31_42 vccd vssd sg13cmos5l_decap_8
XFILLER_21_392 vccd vssd sg13cmos5l_decap_8
XFILLER_13_2779 vccd vssd sg13cmos5l_decap_8
XFILLER_29_2219 vccd vssd sg13cmos5l_decap_8
XFILLER_5_525 vccd vssd sg13cmos5l_decap_8
XFILLER_42_2419 vccd vssd sg13cmos5l_decap_8
XFILLER_27_1220 vccd vssd sg13cmos5l_decap_8
XFILLER_1_742 vccd vssd sg13cmos5l_decap_8
XFILLER_7_2037 vccd vssd sg13cmos5l_decap_8
XFILLER_0_252 vccd vssd sg13cmos5l_decap_8
XFILLER_37_908 vccd vssd sg13cmos5l_decap_8
XFILLER_7_1358 vccd vssd sg13cmos5l_decap_8
XFILLER_40_2165 vccd vssd sg13cmos5l_decap_8
XFILLER_2_2660 vccd vssd sg13cmos5l_decap_8
XFILLER_5_1071 vccd vssd sg13cmos5l_decap_8
XFILLER_45_952 vccd vssd sg13cmos5l_decap_8
XFILLER_44_440 vccd vssd sg13cmos5l_decap_8
XFILLER_17_665 vccd vssd sg13cmos5l_decap_8
XFILLER_32_602 vccd vssd sg13cmos5l_decap_8
XFILLER_16_175 vccd vssd sg13cmos5l_decap_8
XFILLER_2_1981 vccd vssd sg13cmos5l_decap_8
XFILLER_38_2072 vccd vssd sg13cmos5l_decap_8
XFILLER_31_112 vccd vssd sg13cmos5l_decap_8
XFILLER_34_1213 vccd vssd sg13cmos5l_decap_8
XFILLER_32_679 vccd vssd sg13cmos5l_decap_8
XFILLER_20_819 vccd vssd sg13cmos5l_decap_8
XFILLER_40_690 vccd vssd sg13cmos5l_decap_8
XFILLER_34_1268 vccd vssd sg13cmos5l_decap_8
XFILLER_31_189 vccd vssd sg13cmos5l_decap_8
XFILLER_18_1978 vccd vssd sg13cmos5l_decap_8
XFILLER_16_2381 vccd vssd sg13cmos5l_decap_8
XFILLER_12_2201 vccd vssd sg13cmos5l_decap_8
XFILLER_13_882 vccd vssd sg13cmos5l_decap_8
XFILLER_16_1680 vccd vssd sg13cmos5l_decap_8
XFILLER_9_875 vccd vssd sg13cmos5l_decap_8
XFILLER_12_392 vccd vssd sg13cmos5l_decap_8
XFILLER_8_385 vccd vssd sg13cmos5l_decap_8
XFILLER_12_1533 vccd vssd sg13cmos5l_decap_8
XFILLER_12_2278 vccd vssd sg13cmos5l_decap_8
XFILLER_29_2720 vccd vssd sg13cmos5l_decap_8
X_1553_ _1553_/Y _1553_/A _1555_/S vccd vssd sg13cmos5l_nor2_1
XFILLER_45_2065 vccd vssd sg13cmos5l_decap_8
X_1484_ _1484_/X _1495_/A hold443/X _1485_/S vccd vssd sg13cmos5l_mux2_1
XFILLER_25_1905 vccd vssd sg13cmos5l_decap_8
XFILLER_45_1386 vccd vssd sg13cmos5l_decap_8
XFILLER_23_2352 vccd vssd sg13cmos5l_decap_8
XFILLER_23_2330 vccd vssd sg13cmos5l_decap_8
XFILLER_39_245 vccd vssd sg13cmos5l_decap_8
XFILLER_3_1701 vccd vssd sg13cmos5l_decap_8
XFILLER_3_2457 vccd vssd sg13cmos5l_decap_8
XFILLER_11_0 vccd vssd sg13cmos5l_decap_8
Xoutbuffers\[25\] control[25] _1693_/Q vccd vssd sg13cmos5l_buf_8
XFILLER_36_974 vccd vssd sg13cmos5l_decap_8
XFILLER_36_963 vccd vssd sg13cmos5l_decap_4
XFILLER_36_941 vccd vssd sg13cmos5l_decap_8
XFILLER_3_1778 vccd vssd sg13cmos5l_decap_8
XFILLER_1_2170 vccd vssd sg13cmos5l_decap_8
XFILLER_36_2735 vccd vssd sg13cmos5l_decap_8
XFILLER_23_602 vccd vssd sg13cmos5l_decap_8
XFILLER_22_112 vccd vssd sg13cmos5l_decap_8
XFILLER_17_2123 vccd vssd sg13cmos5l_decap_8
XFILLER_17_1400 vccd vssd sg13cmos5l_decap_8
XFILLER_1_1491 vccd vssd sg13cmos5l_decap_8
XFILLER_23_679 vccd vssd sg13cmos5l_decap_8
XFILLER_11_819 vccd vssd sg13cmos5l_decap_8
XFILLER_13_2009 vccd vssd sg13cmos5l_decap_8
XFILLER_31_690 vccd vssd sg13cmos5l_decap_8
XFILLER_22_189 vccd vssd sg13cmos5l_decap_8
XFILLER_17_1477 vccd vssd sg13cmos5l_decap_8
XFILLER_10_329 vccd vssd sg13cmos5l_decap_8
XFILLER_15_1190 vccd vssd sg13cmos5l_decap_8
XFILLER_11_1043 vccd vssd sg13cmos5l_decap_8
Xhold330 hold330/X _1743_/Q vccd vssd sg13cmos5l_dlygate4sd3_1
Xhold352 hold352/X _1715_/Q vccd vssd sg13cmos5l_dlygate4sd3_1
Xhold341 _1704_/D _1469_/X vccd vssd sg13cmos5l_dlygate4sd3_1
XFILLER_2_539 vccd vssd sg13cmos5l_decap_8
XFILLER_43_2728 vccd vssd sg13cmos5l_decap_8
Xhold374 _1769_/D _1565_/X vccd vssd sg13cmos5l_dlygate4sd3_1
Xhold385 hold385/X _1674_/Q vccd vssd sg13cmos5l_dlygate4sd3_1
XFILLER_28_2252 vccd vssd sg13cmos5l_decap_8
Xhold396 hold396/X _1688_/Q vccd vssd sg13cmos5l_dlygate4sd3_1
Xhold363 _0918_/A _0917_/Y vccd vssd sg13cmos5l_dlygate4sd3_1
XFILLER_8_2324 vccd vssd sg13cmos5l_decap_8
XFILLER_24_2127 vccd vssd sg13cmos5l_decap_8
XFILLER_28_1595 vccd vssd sg13cmos5l_decap_8
XFILLER_8_1645 vccd vssd sg13cmos5l_decap_8
XFILLER_41_1740 vccd vssd sg13cmos5l_decap_8
XFILLER_27_930 vccd vssd sg13cmos5l_decap_8
XFILLER_2_1211 vccd vssd sg13cmos5l_decap_8
XFILLER_45_259 vccd vssd sg13cmos5l_decap_8
XFILLER_26_42 vccd vssd sg13cmos5l_decap_8
XFILLER_22_1183 vccd vssd sg13cmos5l_decap_8
XFILLER_26_462 vccd vssd sg13cmos5l_decap_8
XFILLER_2_1288 vccd vssd sg13cmos5l_decap_8
XFILLER_14_602 vccd vssd sg13cmos5l_decap_8
XFILLER_42_966 vccd vssd sg13cmos5l_decap_8
XFILLER_42_933 vccd vssd sg13cmos5l_decap_8
XFILLER_41_421 vccd vssd sg13cmos5l_decap_8
XFILLER_39_2392 vccd vssd sg13cmos5l_decap_8
XFILLER_13_112 vccd vssd sg13cmos5l_decap_8
XFILLER_35_2256 vccd vssd sg13cmos5l_decap_8
XFILLER_9_105 vccd vssd sg13cmos5l_decap_8
XFILLER_14_679 vccd vssd sg13cmos5l_decap_8
XFILLER_41_498 vccd vssd sg13cmos5l_decap_8
XFILLER_13_189 vccd vssd sg13cmos5l_decap_8
XFILLER_13_2510 vccd vssd sg13cmos5l_decap_8
XFILLER_42_63 vccd vssd sg13cmos5l_decap_8
XFILLER_6_812 vccd vssd sg13cmos5l_decap_8
XFILLER_13_2565 vccd vssd sg13cmos5l_decap_8
XFILLER_33_1290 vccd vssd sg13cmos5l_decap_8
XFILLER_5_322 vccd vssd sg13cmos5l_decap_8
XFILLER_10_896 vccd vssd sg13cmos5l_decap_8
XFILLER_13_2598 vccd vssd sg13cmos5l_decap_8
Xtiedowns\[61\] status[61] vccd vssd sg13cmos5l_antennanp
XFILLER_29_2016 vccd vssd sg13cmos5l_decap_4
XFILLER_13_1897 vccd vssd sg13cmos5l_decap_8
XFILLER_6_889 vccd vssd sg13cmos5l_decap_8
XFILLER_42_2205 vccd vssd sg13cmos5l_decap_8
XFILLER_5_399 vccd vssd sg13cmos5l_decap_8
XFILLER_3_35 vccd vssd sg13cmos5l_decap_8
XFILLER_42_1526 vccd vssd sg13cmos5l_decap_8
XFILLER_27_1061 vccd vssd sg13cmos5l_decap_4
XFILLER_24_2650 vccd vssd sg13cmos5l_decap_8
XFILLER_37_705 vccd vssd sg13cmos5l_decap_8
XFILLER_3_1008 vccd vssd sg13cmos5l_decap_8
XFILLER_7_1155 vccd vssd sg13cmos5l_decap_8
XFILLER_24_1971 vccd vssd sg13cmos5l_decap_8
XFILLER_20_2569 vccd vssd sg13cmos5l_decap_8
XFILLER_36_259 vccd vssd sg13cmos5l_decap_8
XFILLER_18_952 vccd vssd sg13cmos5l_decap_8
XFILLER_0_1918 vccd vssd sg13cmos5l_decap_8
XFILLER_20_1868 vccd vssd sg13cmos5l_decap_4
XFILLER_17_462 vccd vssd sg13cmos5l_decap_8
Xoutbuffers\[115\] control[115] _1783_/Q vccd vssd sg13cmos5l_buf_8
XFILLER_33_944 vccd vssd sg13cmos5l_decap_8
XFILLER_20_616 vccd vssd sg13cmos5l_decap_8
XFILLER_18_2476 vccd vssd sg13cmos5l_decap_8
XFILLER_34_1032 vccd vssd sg13cmos5l_decap_8
XFILLER_18_1764 vccd vssd sg13cmos5l_decap_8
X_0984_ wire74/A _1070_/B _1009_/A _0988_/B _0988_/C vccd vssd sg13cmos5l_nor4_2
XFILLER_31_2654 vccd vssd sg13cmos5l_decap_8
XFILLER_14_1617 vccd vssd sg13cmos5l_decap_8
XFILLER_9_672 vccd vssd sg13cmos5l_decap_8
XFILLER_12_1330 vccd vssd sg13cmos5l_decap_8
XFILLER_8_182 vccd vssd sg13cmos5l_decap_8
XFILLER_12_2086 vccd vssd sg13cmos5l_decap_8
X_1605_ _1605_/Y _1605_/A _1617_/B_N vccd vssd sg13cmos5l_nor2b_1
X_1536_ _1536_/Y hold217/X _1541_/S _1535_/Y vccd vssd sg13cmos5l_a21oi_1
XFILLER_29_2594 vccd vssd sg13cmos5l_decap_8
Xfanout117 fanout117/X fanout120/X vccd vssd sg13cmos5l_buf_1
Xfanout106 _1478_/A _1443_/A vccd vssd sg13cmos5l_buf_1
Xfanout128 fanout128/X fanout129/X vccd vssd sg13cmos5l_buf_1
XFILLER_9_1932 vccd vssd sg13cmos5l_decap_8
XFILLER_9_2666 vccd vssd sg13cmos5l_decap_8
Xfanout139 fanout139/X fanout140/X vccd vssd sg13cmos5l_buf_1
X_1467_ _1467_/X _1478_/A hold419/X _1471_/S vccd vssd sg13cmos5l_mux2_1
XFILLER_29_1882 vccd vssd sg13cmos5l_decap_8
XFILLER_45_1183 vccd vssd sg13cmos5l_decap_8
XFILLER_42_2783 vccd vssd sg13cmos5l_decap_8
XFILLER_41_1036 vccd vssd sg13cmos5l_decap_8
XFILLER_28_716 vccd vssd sg13cmos5l_decap_8
X_1398_ _1651_/D _1445_/A _1504_/A _1401_/B vccd vssd sg13cmos5l_mux2_1
XFILLER_3_2254 vccd vssd sg13cmos5l_decap_8
XFILLER_27_259 vccd vssd sg13cmos5l_decap_8
XFILLER_3_1575 vccd vssd sg13cmos5l_decap_8
XFILLER_36_2532 vccd vssd sg13cmos5l_decap_8
XFILLER_24_966 vccd vssd sg13cmos5l_decap_8
XFILLER_36_1842 vccd vssd sg13cmos5l_decap_8
XFILLER_32_1706 vccd vssd sg13cmos5l_decap_8
XFILLER_23_476 vccd vssd sg13cmos5l_decap_8
XFILLER_11_616 vccd vssd sg13cmos5l_decap_8
XFILLER_36_1897 vccd vssd sg13cmos5l_decap_8
XFILLER_17_1274 vccd vssd sg13cmos5l_decap_8
XFILLER_7_609 vccd vssd sg13cmos5l_decap_8
XFILLER_10_126 vccd vssd sg13cmos5l_decap_8
XFILLER_10_2705 vccd vssd sg13cmos5l_decap_8
XFILLER_6_119 vccd vssd sg13cmos5l_decap_8
XFILLER_13_1127 vccd vssd sg13cmos5l_decap_8
XFILLER_12_77 vccd vssd sg13cmos5l_decap_8
XFILLER_30_1496 vccd vssd sg13cmos5l_decap_8
XFILLER_3_826 vccd vssd sg13cmos5l_decap_8
XFILLER_2_336 vccd vssd sg13cmos5l_decap_8
XFILLER_8_2121 vccd vssd sg13cmos5l_decap_8
XFILLER_43_2525 vccd vssd sg13cmos5l_decap_4
Xhold193 _0829_/A hold536/X vccd vssd sg13cmos5l_dlygate4sd3_1
Xhold182 _0830_/A hold534/X vccd vssd sg13cmos5l_dlygate4sd3_1
XFILLER_24_1201 vccd vssd sg13cmos5l_decap_8
XFILLER_8_1442 vccd vssd sg13cmos5l_decap_8
XFILLER_8_2198 vccd vssd sg13cmos5l_decap_8
XFILLER_41_2293 vccd vssd sg13cmos5l_decap_8
XFILLER_19_749 vccd vssd sg13cmos5l_decap_8
XFILLER_41_1581 vccd vssd sg13cmos5l_decap_8
XFILLER_37_63 vccd vssd sg13cmos5l_decap_8
XFILLER_18_259 vccd vssd sg13cmos5l_decap_8
XFILLER_37_1617 vccd vssd sg13cmos5l_decap_8
XFILLER_19_2741 vccd vssd sg13cmos5l_decap_8
XFILLER_2_1085 vccd vssd sg13cmos5l_decap_8
XFILLER_42_774 vccd vssd sg13cmos5l_decap_8
XFILLER_30_903 vccd vssd sg13cmos5l_decap_8
XFILLER_15_966 vccd vssd sg13cmos5l_decap_8
XFILLER_41_284 vccd vssd sg13cmos5l_decap_8
XFILLER_15_2627 vccd vssd sg13cmos5l_decap_8
XFILLER_15_1904 vccd vssd sg13cmos5l_decap_8
XFILLER_14_476 vccd vssd sg13cmos5l_decap_8
XFILLER_35_1396 vccd vssd sg13cmos5l_decap_8
XFILLER_13_2384 vccd vssd sg13cmos5l_decap_8
XFILLER_10_693 vccd vssd sg13cmos5l_decap_8
XFILLER_6_686 vccd vssd sg13cmos5l_decap_8
XFILLER_13_1694 vccd vssd sg13cmos5l_decap_8
XFILLER_26_2712 vccd vssd sg13cmos5l_decap_8
XFILLER_5_196 vccd vssd sg13cmos5l_decap_8
X_1321_ _1321_/Y status[25] _1321_/B vccd vssd sg13cmos5l_nor2_1
XFILLER_42_2046 vccd vssd sg13cmos5l_decap_8
XFILLER_9_1239 vccd vssd sg13cmos5l_decap_8
XFILLER_42_1323 vccd vssd sg13cmos5l_decap_8
X_1252_ _1252_/Y _1671_/Q _1419_/B vccd vssd sg13cmos5l_nand2b_1
XFILLER_4_2541 vccd vssd sg13cmos5l_decap_8
XFILLER_37_524 vccd vssd sg13cmos5l_decap_8
X_1183_ _1183_/Y _1183_/A _1183_/B _1183_/C _1183_/D vccd vssd sg13cmos5l_nand4_1
XFILLER_20_2366 vccd vssd sg13cmos5l_decap_8
XFILLER_4_1862 vccd vssd sg13cmos5l_decap_8
Xtiedowns\[105\] status[105] vccd vssd sg13cmos5l_antennanp
XFILLER_40_1080 vccd vssd sg13cmos5l_decap_8
XFILLER_37_579 vccd vssd sg13cmos5l_decap_8
XFILLER_20_1654 vccd vssd sg13cmos5l_decap_8
XFILLER_0_1715 vccd vssd sg13cmos5l_decap_8
XFILLER_36_1116 vccd vssd sg13cmos5l_decap_8
XFILLER_21_903 vccd vssd sg13cmos5l_decap_8
XFILLER_33_2727 vccd vssd sg13cmos5l_decap_8
XFILLER_32_273 vccd vssd sg13cmos5l_decap_8
XFILLER_20_413 vccd vssd sg13cmos5l_decap_8
XFILLER_18_1561 vccd vssd sg13cmos5l_decap_8
XFILLER_14_1414 vccd vssd sg13cmos5l_decap_8
X_0967_ _1074_/B _0997_/A _0997_/B vccd vssd sg13cmos5l_nor2_1
Xoutbuffers\[92\] control[92] _1760_/Q vccd vssd sg13cmos5l_buf_8
XFILLER_31_2495 vccd vssd sg13cmos5l_decap_4
XFILLER_31_1783 vccd vssd sg13cmos5l_decap_8
X_0898_ _1403_/B _0898_/A _0898_/B _0898_/C vccd vssd sg13cmos5l_nand3_1
XFILLER_27_2509 vccd vssd sg13cmos5l_decap_8
XFILLER_29_2391 vccd vssd sg13cmos5l_decap_8
X_1519_ _1519_/X _1542_/A hold415/X _1519_/S vccd vssd sg13cmos5l_mux2_1
XFILLER_9_2485 vccd vssd sg13cmos5l_decap_8
XFILLER_21_2119 vccd vssd sg13cmos5l_decap_8
XFILLER_5_2338 vccd vssd sg13cmos5l_decap_8
XFILLER_21_1407 vccd vssd sg13cmos5l_decap_8
XFILLER_3_2051 vccd vssd sg13cmos5l_decap_8
XFILLER_5_1659 vccd vssd sg13cmos5l_decap_8
XFILLER_42_1890 vccd vssd sg13cmos5l_decap_8
XFILLER_28_546 vccd vssd sg13cmos5l_decap_8
XFILLER_38_2616 vccd vssd sg13cmos5l_decap_8
XFILLER_3_1372 vccd vssd sg13cmos5l_decap_8
XFILLER_38_1915 vccd vssd sg13cmos5l_decap_8
XFILLER_24_763 vccd vssd sg13cmos5l_decap_8
XFILLER_12_903 vccd vssd sg13cmos5l_decap_8
XFILLER_36_2384 vccd vssd sg13cmos5l_decap_8
XFILLER_32_2215 vccd vssd sg13cmos5l_decap_4
XFILLER_23_273 vccd vssd sg13cmos5l_decap_8
XFILLER_23_21 vccd vssd sg13cmos5l_decap_8
XFILLER_19_1358 vccd vssd sg13cmos5l_decap_8
XFILLER_11_413 vccd vssd sg13cmos5l_decap_8
XFILLER_7_406 vccd vssd sg13cmos5l_decap_8
XFILLER_32_1547 vccd vssd sg13cmos5l_decap_4
XFILLER_20_980 vccd vssd sg13cmos5l_decap_8
XFILLER_17_1071 vccd vssd sg13cmos5l_decap_8
XFILLER_23_98 vccd vssd sg13cmos5l_decap_8
XFILLER_10_2535 vccd vssd sg13cmos5l_decap_8
XFILLER_10_1834 vccd vssd sg13cmos5l_decap_8
XFILLER_10_2579 vccd vssd sg13cmos5l_decap_8
XFILLER_14_1981 vccd vssd sg13cmos5l_decap_8
XFILLER_3_623 vccd vssd sg13cmos5l_decap_8
XFILLER_2_133 vccd vssd sg13cmos5l_decap_8
Xtiedowns\[24\] status[24] vccd vssd sg13cmos5l_antennanp
XFILLER_24_1053 vccd vssd sg13cmos5l_decap_8
XFILLER_41_2090 vccd vssd sg13cmos5l_decap_8
XFILLER_21_2664 vccd vssd sg13cmos5l_decap_8
XFILLER_19_546 vccd vssd sg13cmos5l_decap_8
XFILLER_0_14 vccd vssd sg13cmos5l_decap_8
XFILLER_1_2758 vccd vssd sg13cmos5l_decap_8
XFILLER_4_1169 vccd vssd sg13cmos5l_decap_8
XFILLER_34_549 vccd vssd sg13cmos5l_decap_8
XFILLER_37_2159 vccd vssd sg13cmos5l_decap_8
XFILLER_15_763 vccd vssd sg13cmos5l_decap_8
XFILLER_42_571 vccd vssd sg13cmos5l_decap_8
XFILLER_37_1447 vccd vssd sg13cmos5l_decap_8
XFILLER_15_2402 vccd vssd sg13cmos5l_decap_8
XFILLER_14_273 vccd vssd sg13cmos5l_decap_8
XFILLER_19_1881 vccd vssd sg13cmos5l_decap_8
XFILLER_15_1701 vccd vssd sg13cmos5l_decap_8
XFILLER_9_56 vccd vssd sg13cmos5l_decap_8
XFILLER_35_1160 vccd vssd sg13cmos5l_decap_8
XFILLER_31_1002 vccd vssd sg13cmos5l_decap_8
XFILLER_15_2479 vccd vssd sg13cmos5l_decap_8
XFILLER_15_1778 vccd vssd sg13cmos5l_decap_8
XFILLER_11_980 vccd vssd sg13cmos5l_decap_8
XFILLER_31_1068 vccd vssd sg13cmos5l_decap_8
XFILLER_7_973 vccd vssd sg13cmos5l_decap_8
XFILLER_10_490 vccd vssd sg13cmos5l_decap_8
XFILLER_6_483 vccd vssd sg13cmos5l_decap_8
XFILLER_13_1491 vccd vssd sg13cmos5l_decap_8
XFILLER_26_2520 vccd vssd sg13cmos5l_decap_8
XFILLER_9_1036 vccd vssd sg13cmos5l_decap_8
XFILLER_22_2417 vccd vssd sg13cmos5l_decap_8
XFILLER_6_2636 vccd vssd sg13cmos5l_decap_8
X_1304_ _1304_/Y _0832_/A _0885_/X _1391_/A2 vccd vssd sg13cmos5l_a21oi_1
XFILLER_38_800 vccd vssd sg13cmos5l_decap_8
XFILLER_6_1946 vccd vssd sg13cmos5l_decap_8
X_1235_ _1235_/Y _1235_/A _1235_/B _1235_/C _1235_/D vccd vssd sg13cmos5l_nand4_1
XFILLER_38_877 vccd vssd sg13cmos5l_decap_4
XFILLER_37_343 vccd vssd sg13cmos5l_decap_8
X_1166_ _1166_/Y _1689_/Q _1342_/B _1164_/Y _1163_/X _1165_/X vccd vssd sg13cmos5l_a221oi_1
XFILLER_0_1512 vccd vssd sg13cmos5l_decap_8
XFILLER_20_1451 vccd vssd sg13cmos5l_decap_8
XFILLER_0_2268 vccd vssd sg13cmos5l_decap_8
X_1097_ _1097_/Y status[38] _1142_/B _1095_/Y _1096_/Y _1144_/B vccd vssd sg13cmos5l_a221oi_1
XFILLER_37_2660 vccd vssd sg13cmos5l_decap_8
XFILLER_0_1589 vccd vssd sg13cmos5l_decap_8
XFILLER_21_700 vccd vssd sg13cmos5l_decap_8
Xtiedowns\[8\] status[8] vccd vssd sg13cmos5l_antennanp
XFILLER_20_210 vccd vssd sg13cmos5l_decap_8
XFILLER_18_2081 vccd vssd sg13cmos5l_decap_8
XFILLER_33_1856 vccd vssd sg13cmos5l_decap_8
XFILLER_21_777 vccd vssd sg13cmos5l_decap_8
XFILLER_14_1211 vccd vssd sg13cmos5l_decap_8
XFILLER_20_287 vccd vssd sg13cmos5l_decap_8
XFILLER_31_2292 vccd vssd sg13cmos5l_decap_8
XFILLER_14_1288 vccd vssd sg13cmos5l_decap_8
XFILLER_27_2339 vccd vssd sg13cmos5l_decap_8
XFILLER_27_1605 vccd vssd sg13cmos5l_decap_8
XFILLER_44_2653 vccd vssd sg13cmos5l_decap_8
XFILLER_0_637 vccd vssd sg13cmos5l_decap_8
XFILLER_5_2135 vccd vssd sg13cmos5l_decap_8
XFILLER_9_2282 vccd vssd sg13cmos5l_decap_8
XFILLER_44_1963 vccd vssd sg13cmos5l_decap_8
XFILLER_25_2074 vccd vssd sg13cmos5l_decap_8
XFILLER_25_1362 vccd vssd sg13cmos5l_decap_8
XFILLER_40_1827 vccd vssd sg13cmos5l_decap_8
XFILLER_21_1204 vccd vssd sg13cmos5l_decap_8
XFILLER_18_21 vccd vssd sg13cmos5l_decap_8
XFILLER_5_1456 vccd vssd sg13cmos5l_decap_8
XFILLER_44_814 vccd vssd sg13cmos5l_decap_8
XFILLER_29_866 vccd vssd sg13cmos5l_decap_8
XFILLER_28_343 vccd vssd sg13cmos5l_decap_8
XFILLER_1_1309 vccd vssd sg13cmos5l_decap_8
XFILLER_18_98 vccd vssd sg13cmos5l_decap_8
XFILLER_38_1712 vccd vssd sg13cmos5l_decap_8
XFILLER_31_508 vccd vssd sg13cmos5l_decap_8
XFILLER_34_42 vccd vssd sg13cmos5l_decap_8
XFILLER_24_560 vccd vssd sg13cmos5l_decap_8
XFILLER_12_700 vccd vssd sg13cmos5l_decap_8
XFILLER_38_1789 vccd vssd sg13cmos5l_decap_8
XFILLER_19_1155 vccd vssd sg13cmos5l_decap_8
XFILLER_15_1008 vccd vssd sg13cmos5l_decap_8
XFILLER_11_210 vccd vssd sg13cmos5l_decap_8
XFILLER_32_1300 vccd vssd sg13cmos5l_decap_8
XFILLER_7_203 vccd vssd sg13cmos5l_decap_8
XFILLER_12_777 vccd vssd sg13cmos5l_decap_8
XFILLER_10_2310 vccd vssd sg13cmos5l_decap_8
XFILLER_11_287 vccd vssd sg13cmos5l_decap_8
XFILLER_12_1918 vccd vssd sg13cmos5l_decap_8
XFILLER_4_910 vccd vssd sg13cmos5l_decap_8
XFILLER_3_420 vccd vssd sg13cmos5l_decap_8
XFILLER_10_1631 vccd vssd sg13cmos5l_decap_8
XFILLER_10_2387 vccd vssd sg13cmos5l_decap_8
XFILLER_4_987 vccd vssd sg13cmos5l_decap_8
XFILLER_3_497 vccd vssd sg13cmos5l_decap_8
XFILLER_43_2163 vccd vssd sg13cmos5l_decap_8
XFILLER_23_2704 vccd vssd sg13cmos5l_decap_8
XFILLER_15_7 vccd vssd sg13cmos5l_decap_8
X_1020_ _1020_/Y status[7] _1029_/A _1055_/A vccd vssd sg13cmos5l_nor3_1
XFILLER_21_2461 vccd vssd sg13cmos5l_decap_8
XFILLER_19_343 vccd vssd sg13cmos5l_decap_8
XFILLER_1_2555 vccd vssd sg13cmos5l_decap_8
XFILLER_21_1782 vccd vssd sg13cmos5l_decap_8
XFILLER_34_357 vccd vssd sg13cmos5l_decap_8
XFILLER_1_1876 vccd vssd sg13cmos5l_decap_8
XFILLER_37_1244 vccd vssd sg13cmos5l_decap_8
XFILLER_15_2210 vccd vssd sg13cmos5l_decap_8
XFILLER_15_560 vccd vssd sg13cmos5l_decap_8
XFILLER_42_390 vccd vssd sg13cmos5l_decap_8
XFILLER_30_2708 vccd vssd sg13cmos5l_decap_8
XFILLER_15_2276 vccd vssd sg13cmos5l_decap_8
XFILLER_11_2107 vccd vssd sg13cmos5l_decap_8
XFILLER_15_1575 vccd vssd sg13cmos5l_decap_8
X_1784_ _1784_/Q _1793_/CLK _1784_/D fanout119/X vccd vssd sg13cmos5l_dfrbpq_1
XFILLER_7_770 vccd vssd sg13cmos5l_decap_8
XFILLER_11_1428 vccd vssd sg13cmos5l_decap_8
Xfanout8 _1528_/B _1530_/S vccd vssd sg13cmos5l_buf_1
XFILLER_6_280 vccd vssd sg13cmos5l_decap_8
XFILLER_28_2637 vccd vssd sg13cmos5l_decap_8
XFILLER_28_1903 vccd vssd sg13cmos5l_decap_8
XFILLER_41_0 vccd vssd sg13cmos5l_decap_8
XFILLER_26_2350 vccd vssd sg13cmos5l_decap_8
XFILLER_6_2422 vccd vssd sg13cmos5l_decap_8
XFILLER_44_1259 vccd vssd sg13cmos5l_decap_8
Xoutbuffers\[55\] control[55] _1723_/Q vccd vssd sg13cmos5l_buf_8
XFILLER_26_2394 vccd vssd sg13cmos5l_decap_8
XFILLER_22_2214 vccd vssd sg13cmos5l_decap_8
XFILLER_22_1513 vccd vssd sg13cmos5l_decap_8
XFILLER_6_1743 vccd vssd sg13cmos5l_decap_8
XFILLER_6_2499 vccd vssd sg13cmos5l_decap_8
XFILLER_37_140 vccd vssd sg13cmos5l_decap_8
XFILLER_22_1557 vccd vssd sg13cmos5l_decap_8
X_1218_ _1218_/Y _0830_/A _0888_/C _1391_/A2 vccd vssd sg13cmos5l_a21oi_1
XFILLER_26_847 vccd vssd sg13cmos5l_decap_8
XFILLER_0_2065 vccd vssd sg13cmos5l_decap_8
X_1149_ _1153_/B _1793_/Q _1588_/B _1147_/Y _1146_/Y _1148_/X vccd vssd sg13cmos5l_a221oi_1
XFILLER_39_2766 vccd vssd sg13cmos5l_decap_8
XFILLER_25_357 vccd vssd sg13cmos5l_decap_8
XFILLER_20_1281 vccd vssd sg13cmos5l_decap_8
XFILLER_41_817 vccd vssd sg13cmos5l_decap_8
XFILLER_16_2007 vccd vssd sg13cmos5l_decap_8
XFILLER_0_1386 vccd vssd sg13cmos5l_decap_8
XFILLER_37_2490 vccd vssd sg13cmos5l_decap_8
XFILLER_21_574 vccd vssd sg13cmos5l_decap_8
XFILLER_33_2376 vccd vssd sg13cmos5l_decap_8
XFILLER_5_707 vccd vssd sg13cmos5l_decap_8
XFILLER_4_217 vccd vssd sg13cmos5l_decap_8
XFILLER_14_1085 vccd vssd sg13cmos5l_decap_8
XFILLER_20_77 vccd vssd sg13cmos5l_decap_8
XFILLER_11_1995 vccd vssd sg13cmos5l_decap_8
XFILLER_1_924 vccd vssd sg13cmos5l_decap_8
XFILLER_7_2219 vccd vssd sg13cmos5l_decap_8
XFILLER_44_2450 vccd vssd sg13cmos5l_decap_8
XFILLER_27_1424 vccd vssd sg13cmos5l_decap_8
XFILLER_0_434 vccd vssd sg13cmos5l_decap_8
XFILLER_44_1760 vccd vssd sg13cmos5l_decap_8
XFILLER_40_2303 vccd vssd sg13cmos5l_decap_8
XFILLER_29_42 vccd vssd sg13cmos5l_decap_8
XFILLER_44_1793 vccd vssd sg13cmos5l_decap_8
XFILLER_40_1613 vccd vssd sg13cmos5l_decap_8
XFILLER_21_1001 vccd vssd sg13cmos5l_decap_8
XFILLER_40_1635 vccd vssd sg13cmos5l_decap_8
XFILLER_29_674 vccd vssd sg13cmos5l_decap_8
XFILLER_28_140 vccd vssd sg13cmos5l_decap_8
XFILLER_22_2781 vccd vssd sg13cmos5l_decap_8
XFILLER_1_1106 vccd vssd sg13cmos5l_decap_8
XFILLER_5_1253 vccd vssd sg13cmos5l_decap_8
XFILLER_21_1078 vccd vssd sg13cmos5l_decap_8
XFILLER_17_847 vccd vssd sg13cmos5l_decap_8
XFILLER_45_63 vccd vssd sg13cmos5l_decap_8
XFILLER_38_2232 vccd vssd sg13cmos5l_decap_4
XFILLER_16_357 vccd vssd sg13cmos5l_decap_8
XFILLER_44_677 vccd vssd sg13cmos5l_decap_8
XFILLER_32_839 vccd vssd sg13cmos5l_decap_8
Xtiedowns\[91\] status[91] vccd vssd sg13cmos5l_antennanp
XFILLER_16_2552 vccd vssd sg13cmos5l_decap_8
XFILLER_16_1862 vccd vssd sg13cmos5l_decap_8
XFILLER_12_574 vccd vssd sg13cmos5l_decap_8
XFILLER_32_1141 vccd vssd sg13cmos5l_decap_8
XFILLER_8_567 vccd vssd sg13cmos5l_decap_8
XFILLER_12_1715 vccd vssd sg13cmos5l_decap_8
XFILLER_32_1185 vccd vssd sg13cmos5l_decap_8
XANTENNA_6 RSTB vccd vssd sg13cmos5l_antennanp
XFILLER_6_35 vccd vssd sg13cmos5l_decap_8
XFILLER_10_2184 vccd vssd sg13cmos5l_decap_8
XFILLER_45_2247 vccd vssd sg13cmos5l_decap_8
XFILLER_4_784 vccd vssd sg13cmos5l_decap_8
XFILLER_23_2501 vccd vssd sg13cmos5l_decap_8
XFILLER_3_294 vccd vssd sg13cmos5l_decap_8
XFILLER_45_1568 vccd vssd sg13cmos5l_decap_8
XFILLER_23_2578 vccd vssd sg13cmos5l_decap_8
XFILLER_23_1811 vccd vssd sg13cmos5l_decap_8
XFILLER_3_2639 vccd vssd sg13cmos5l_decap_8
XFILLER_23_1855 vccd vssd sg13cmos5l_decap_8
XFILLER_19_140 vccd vssd sg13cmos5l_decap_8
X_1003_ _1003_/Y _1029_/A _1046_/A _1046_/B vccd vssd sg13cmos5l_nor3_1
XFILLER_1_2352 vccd vssd sg13cmos5l_decap_8
XFILLER_39_1306 vccd vssd sg13cmos5l_decap_8
XFILLER_35_677 vccd vssd sg13cmos5l_decap_4
XFILLER_34_154 vccd vssd sg13cmos5l_decap_8
XFILLER_17_2327 vccd vssd sg13cmos5l_decap_8
XFILLER_1_1673 vccd vssd sg13cmos5l_decap_8
XFILLER_34_2630 vccd vssd sg13cmos5l_decap_8
XFILLER_37_1063 vccd vssd sg13cmos5l_decap_8
XFILLER_31_872 vccd vssd sg13cmos5l_decap_8
XFILLER_17_1659 vccd vssd sg13cmos5l_decap_8
XFILLER_15_2051 vccd vssd sg13cmos5l_decap_8
XFILLER_34_1940 vccd vssd sg13cmos5l_decap_8
XFILLER_30_371 vccd vssd sg13cmos5l_decap_8
XFILLER_15_1372 vccd vssd sg13cmos5l_decap_8
Xhold501 _1783_/D _1583_/X vccd vssd sg13cmos5l_dlygate4sd3_1
X_1767_ _1767_/Q _1793_/CLK _1767_/D fanout116/X vccd vssd sg13cmos5l_dfrbpq_1
XFILLER_11_1225 vccd vssd sg13cmos5l_decap_8
Xhold523 _1653_/D _1396_/X vccd vssd sg13cmos5l_dlygate4sd3_1
Xhold512 _1796_/D _1600_/Y vccd vssd sg13cmos5l_dlygate4sd3_1
Xhold534 hold534/X _1659_/Q vccd vssd sg13cmos5l_dlygate4sd3_1
X_1698_ _1698_/Q _1707_/CLK _1698_/D _1638_/B_N vccd vssd sg13cmos5l_dfrbpq_1
XFILLER_28_1700 vccd vssd sg13cmos5l_decap_8
XFILLER_8_2506 vccd vssd sg13cmos5l_decap_8
XFILLER_28_2478 vccd vssd sg13cmos5l_decap_8
XFILLER_24_2309 vccd vssd sg13cmos5l_decap_8
XFILLER_8_1827 vccd vssd sg13cmos5l_decap_8
XFILLER_28_1777 vccd vssd sg13cmos5l_decap_8
XFILLER_44_1056 vccd vssd sg13cmos5l_decap_8
XFILLER_41_2656 vccd vssd sg13cmos5l_decap_8
XFILLER_41_1922 vccd vssd sg13cmos5l_decap_8
XFILLER_6_1540 vccd vssd sg13cmos5l_decap_8
XFILLER_22_2088 vccd vssd sg13cmos5l_decap_8
XFILLER_22_1343 vccd vssd sg13cmos5l_decap_4
XFILLER_2_2149 vccd vssd sg13cmos5l_decap_8
XFILLER_6_2296 vccd vssd sg13cmos5l_decap_8
XFILLER_41_1999 vccd vssd sg13cmos5l_decap_8
XFILLER_26_611 vccd vssd sg13cmos5l_decap_8
XFILLER_41_614 vccd vssd sg13cmos5l_decap_8
XFILLER_39_2563 vccd vssd sg13cmos5l_decap_8
XFILLER_26_699 vccd vssd sg13cmos5l_decap_8
XFILLER_25_154 vccd vssd sg13cmos5l_decap_8
XFILLER_0_1183 vccd vssd sg13cmos5l_decap_8
XFILLER_40_168 vccd vssd sg13cmos5l_decap_8
XFILLER_22_861 vccd vssd sg13cmos5l_decap_8
XFILLER_15_77 vccd vssd sg13cmos5l_decap_8
XFILLER_33_2162 vccd vssd sg13cmos5l_decap_8
XFILLER_21_371 vccd vssd sg13cmos5l_decap_8
XFILLER_16_1169 vccd vssd sg13cmos5l_decap_8
XFILLER_13_2758 vccd vssd sg13cmos5l_decap_8
XFILLER_31_21 vccd vssd sg13cmos5l_decap_8
XFILLER_5_504 vccd vssd sg13cmos5l_decap_8
XFILLER_31_98 vccd vssd sg13cmos5l_decap_8
XFILLER_11_1792 vccd vssd sg13cmos5l_decap_8
XFILLER_1_721 vccd vssd sg13cmos5l_decap_8
XFILLER_7_2016 vccd vssd sg13cmos5l_decap_8
XFILLER_0_231 vccd vssd sg13cmos5l_decap_8
XFILLER_40_2144 vccd vssd sg13cmos5l_decap_8
XFILLER_27_1287 vccd vssd sg13cmos5l_decap_8
XFILLER_1_798 vccd vssd sg13cmos5l_decap_8
XFILLER_7_1337 vccd vssd sg13cmos5l_decap_8
XFILLER_5_1050 vccd vssd sg13cmos5l_decap_8
XFILLER_45_931 vccd vssd sg13cmos5l_decap_8
XFILLER_40_1487 vccd vssd sg13cmos5l_decap_8
XFILLER_17_644 vccd vssd sg13cmos5l_decap_8
XFILLER_2_1960 vccd vssd sg13cmos5l_decap_8
XFILLER_16_154 vccd vssd sg13cmos5l_decap_8
XFILLER_32_658 vccd vssd sg13cmos5l_decap_8
XFILLER_31_168 vccd vssd sg13cmos5l_decap_8
XFILLER_18_1957 vccd vssd sg13cmos5l_decap_8
XFILLER_16_2360 vccd vssd sg13cmos5l_decap_8
XFILLER_13_861 vccd vssd sg13cmos5l_decap_8
XFILLER_9_854 vccd vssd sg13cmos5l_decap_8
XFILLER_12_371 vccd vssd sg13cmos5l_decap_8
XFILLER_8_364 vccd vssd sg13cmos5l_decap_8
XFILLER_12_1512 vccd vssd sg13cmos5l_decap_8
XFILLER_12_2257 vccd vssd sg13cmos5l_decap_8
XFILLER_12_1589 vccd vssd sg13cmos5l_decap_8
X_1552_ _1552_/X _1595_/A0 hold304/X _1555_/S vccd vssd sg13cmos5l_mux2_1
XFILLER_45_2044 vccd vssd sg13cmos5l_decap_8
XFILLER_29_2776 vccd vssd sg13cmos5l_decap_8
X_1483_ _1483_/X _1595_/A0 hold429/X _1485_/S vccd vssd sg13cmos5l_mux2_1
XFILLER_4_581 vccd vssd sg13cmos5l_decap_8
XFILLER_45_1365 vccd vssd sg13cmos5l_decap_8
XFILLER_39_224 vccd vssd sg13cmos5l_decap_8
XFILLER_3_2436 vccd vssd sg13cmos5l_decap_8
XFILLER_23_1685 vccd vssd sg13cmos5l_decap_8
XFILLER_3_1757 vccd vssd sg13cmos5l_decap_8
Xoutbuffers\[18\] control[18] _1686_/Q vccd vssd sg13cmos5l_buf_8
XFILLER_36_2714 vccd vssd sg13cmos5l_decap_8
XFILLER_17_2102 vccd vssd sg13cmos5l_decap_8
XFILLER_1_1470 vccd vssd sg13cmos5l_decap_8
XFILLER_39_1147 vccd vssd sg13cmos5l_decap_8
XFILLER_23_658 vccd vssd sg13cmos5l_decap_8
XFILLER_10_308 vccd vssd sg13cmos5l_decap_8
XFILLER_34_2482 vccd vssd sg13cmos5l_decap_8
XFILLER_22_168 vccd vssd sg13cmos5l_decap_8
XFILLER_17_1456 vccd vssd sg13cmos5l_decap_8
XFILLER_30_2335 vccd vssd sg13cmos5l_decap_8
XFILLER_13_1309 vccd vssd sg13cmos5l_decap_8
XFILLER_34_1792 vccd vssd sg13cmos5l_decap_8
XFILLER_30_1645 vccd vssd sg13cmos5l_decap_8
XFILLER_11_1022 vccd vssd sg13cmos5l_decap_8
Xhold320 hold320/X _1731_/Q vccd vssd sg13cmos5l_dlygate4sd3_1
Xhold331 _1743_/D _1525_/X vccd vssd sg13cmos5l_dlygate4sd3_1
Xhold353 _1715_/D _1485_/X vccd vssd sg13cmos5l_dlygate4sd3_1
Xhold342 _1557_/A _1764_/Q vccd vssd sg13cmos5l_dlygate4sd3_1
XFILLER_28_2231 vccd vssd sg13cmos5l_decap_8
XFILLER_2_518 vccd vssd sg13cmos5l_decap_8
XFILLER_8_2303 vccd vssd sg13cmos5l_decap_8
XFILLER_11_1099 vccd vssd sg13cmos5l_decap_8
XFILLER_43_2707 vccd vssd sg13cmos5l_decap_8
Xhold375 hold375/X _1681_/Q vccd vssd sg13cmos5l_dlygate4sd3_1
Xhold386 _1674_/D _1427_/X vccd vssd sg13cmos5l_dlygate4sd3_1
XFILLER_24_2106 vccd vssd sg13cmos5l_decap_8
Xhold364 _1803_/D _0918_/Y vccd vssd sg13cmos5l_dlygate4sd3_1
Xhold397 _1688_/D _1447_/X vccd vssd sg13cmos5l_dlygate4sd3_1
XFILLER_8_1624 vccd vssd sg13cmos5l_decap_8
XFILLER_24_1405 vccd vssd sg13cmos5l_decap_8
XFILLER_6_2093 vccd vssd sg13cmos5l_decap_8
XFILLER_45_238 vccd vssd sg13cmos5l_decap_8
XFILLER_41_1796 vccd vssd sg13cmos5l_decap_8
XFILLER_26_21 vccd vssd sg13cmos5l_decap_8
XFILLER_22_1162 vccd vssd sg13cmos5l_decap_8
XFILLER_42_912 vccd vssd sg13cmos5l_decap_8
XFILLER_41_400 vccd vssd sg13cmos5l_decap_8
XFILLER_35_2202 vccd vssd sg13cmos5l_decap_8
XFILLER_26_441 vccd vssd sg13cmos5l_decap_8
XFILLER_2_1267 vccd vssd sg13cmos5l_decap_8
XFILLER_42_945 vccd vssd sg13cmos5l_decap_8
XFILLER_39_2371 vccd vssd sg13cmos5l_decap_8
XFILLER_26_98 vccd vssd sg13cmos5l_decap_8
XFILLER_14_658 vccd vssd sg13cmos5l_decap_8
XFILLER_42_42 vccd vssd sg13cmos5l_decap_8
XFILLER_41_477 vccd vssd sg13cmos5l_decap_8
XFILLER_13_168 vccd vssd sg13cmos5l_decap_8
Xclkbuf_5_31_0_SCK _1802_/CLK clkbuf_3_7_0_SCK/X vccd vssd sg13cmos5l_buf_8
XFILLER_5_301 vccd vssd sg13cmos5l_decap_8
XFILLER_10_875 vccd vssd sg13cmos5l_decap_8
XFILLER_6_868 vccd vssd sg13cmos5l_decap_8
XFILLER_13_1876 vccd vssd sg13cmos5l_decap_8
XFILLER_5_378 vccd vssd sg13cmos5l_decap_8
Xtiedowns\[54\] status[54] vccd vssd sg13cmos5l_antennanp
XFILLER_3_14 vccd vssd sg13cmos5l_decap_8
XFILLER_42_1505 vccd vssd sg13cmos5l_decap_8
XFILLER_1_595 vccd vssd sg13cmos5l_decap_8
XFILLER_4_2723 vccd vssd sg13cmos5l_decap_8
XFILLER_7_1134 vccd vssd sg13cmos5l_decap_8
XFILLER_24_1950 vccd vssd sg13cmos5l_decap_8
XFILLER_4_2745 vccd vssd sg13cmos5l_decap_8
XFILLER_40_1240 vccd vssd sg13cmos5l_decap_8
XFILLER_20_2548 vccd vssd sg13cmos5l_decap_8
XFILLER_36_238 vccd vssd sg13cmos5l_decap_8
XFILLER_18_931 vccd vssd sg13cmos5l_decap_8
XFILLER_33_923 vccd vssd sg13cmos5l_decap_8
XFILLER_17_441 vccd vssd sg13cmos5l_decap_8
XFILLER_33_989 vccd vssd sg13cmos5l_decap_4
XFILLER_18_2455 vccd vssd sg13cmos5l_decap_8
X_0983_ _0990_/B status[103] _1357_/A2 _1357_/C1 status[95] vccd vssd sg13cmos5l_a22oi_1
XFILLER_32_488 vccd vssd sg13cmos5l_decap_8
Xoutbuffers\[108\] control[108] _1776_/Q vccd vssd sg13cmos5l_buf_8
XFILLER_18_1743 vccd vssd sg13cmos5l_decap_8
XFILLER_31_2633 vccd vssd sg13cmos5l_decap_8
XFILLER_9_651 vccd vssd sg13cmos5l_decap_8
XFILLER_31_1932 vccd vssd sg13cmos5l_decap_8
XFILLER_8_161 vccd vssd sg13cmos5l_decap_8
XFILLER_12_2065 vccd vssd sg13cmos5l_decap_8
X_1604_ _1604_/Y _1605_/A _1617_/B_N vccd vssd sg13cmos5l_nor2b_1
XFILLER_12_1386 vccd vssd sg13cmos5l_decap_8
X_1535_ _1535_/Y _1560_/A _1541_/S vccd vssd sg13cmos5l_nor2_1
XFILLER_29_2573 vccd vssd sg13cmos5l_decap_8
XFILLER_9_2645 vccd vssd sg13cmos5l_decap_8
Xfanout118 fanout118/X fanout119/X vccd vssd sg13cmos5l_buf_1
XFILLER_29_1861 vccd vssd sg13cmos5l_decap_8
Xfanout129 fanout129/X RSTB vccd vssd sg13cmos5l_buf_1
Xfanout107 _1443_/A hold525/X vccd vssd sg13cmos5l_buf_1
XFILLER_9_1911 vccd vssd sg13cmos5l_decap_8
XFILLER_45_1162 vccd vssd sg13cmos5l_decap_8
X_1466_ _1466_/X _1401_/A hold379/X _1471_/S vccd vssd sg13cmos5l_mux2_1
XFILLER_42_2762 vccd vssd sg13cmos5l_decap_8
X_1397_ _1397_/X _1504_/A _1506_/A _1401_/B vccd vssd sg13cmos5l_mux2_1
XFILLER_25_1769 vccd vssd sg13cmos5l_decap_8
XFILLER_3_2233 vccd vssd sg13cmos5l_decap_8
XFILLER_7_2380 vccd vssd sg13cmos5l_decap_8
XFILLER_9_1988 vccd vssd sg13cmos5l_decap_8
XFILLER_23_2183 vccd vssd sg13cmos5l_decap_8
XFILLER_27_238 vccd vssd sg13cmos5l_decap_8
XFILLER_3_1554 vccd vssd sg13cmos5l_decap_8
XFILLER_42_219 vccd vssd sg13cmos5l_decap_8
XFILLER_24_945 vccd vssd sg13cmos5l_decap_8
XFILLER_23_455 vccd vssd sg13cmos5l_decap_8
XFILLER_36_2588 vccd vssd sg13cmos5l_decap_8
XFILLER_10_105 vccd vssd sg13cmos5l_decap_8
XFILLER_36_1876 vccd vssd sg13cmos5l_decap_8
XFILLER_17_1253 vccd vssd sg13cmos5l_decap_8
XFILLER_13_1106 vccd vssd sg13cmos5l_decap_8
XFILLER_30_2198 vccd vssd sg13cmos5l_decap_8
XFILLER_12_56 vccd vssd sg13cmos5l_decap_8
XFILLER_3_805 vccd vssd sg13cmos5l_decap_8
XFILLER_2_315 vccd vssd sg13cmos5l_decap_8
XFILLER_8_2100 vccd vssd sg13cmos5l_decap_8
XFILLER_43_2515 vccd vssd sg13cmos5l_decap_8
Xhold194 hold194/X _0829_/Y vccd vssd sg13cmos5l_dlygate4sd3_1
Xhold183 hold183/X _0830_/Y vccd vssd sg13cmos5l_dlygate4sd3_1
XFILLER_28_2094 vccd vssd sg13cmos5l_decap_8
XFILLER_8_1421 vccd vssd sg13cmos5l_decap_8
XFILLER_8_2177 vccd vssd sg13cmos5l_decap_8
XFILLER_41_2272 vccd vssd sg13cmos5l_decap_8
XFILLER_37_42 vccd vssd sg13cmos5l_decap_8
XFILLER_24_1257 vccd vssd sg13cmos5l_decap_8
XFILLER_19_728 vccd vssd sg13cmos5l_decap_8
XFILLER_8_1498 vccd vssd sg13cmos5l_decap_8
XFILLER_41_1560 vccd vssd sg13cmos5l_decap_8
XFILLER_18_238 vccd vssd sg13cmos5l_decap_8
XFILLER_2_1064 vccd vssd sg13cmos5l_decap_8
XFILLER_19_2720 vccd vssd sg13cmos5l_decap_8
XFILLER_15_945 vccd vssd sg13cmos5l_decap_8
XFILLER_42_753 vccd vssd sg13cmos5l_decap_8
XFILLER_15_2606 vccd vssd sg13cmos5l_decap_8
XFILLER_14_455 vccd vssd sg13cmos5l_decap_8
XFILLER_42_786 vccd vssd sg13cmos5l_decap_8
XFILLER_41_263 vccd vssd sg13cmos5l_decap_8
XFILLER_35_2076 vccd vssd sg13cmos5l_decap_8
XFILLER_35_1375 vccd vssd sg13cmos5l_decap_8
XFILLER_31_1206 vccd vssd sg13cmos5l_decap_8
XFILLER_10_672 vccd vssd sg13cmos5l_decap_8
XFILLER_13_2363 vccd vssd sg13cmos5l_decap_8
XFILLER_6_665 vccd vssd sg13cmos5l_decap_8
XFILLER_13_1673 vccd vssd sg13cmos5l_decap_8
XFILLER_45_7 vccd vssd sg13cmos5l_decap_8
XFILLER_29_1102 vccd vssd sg13cmos5l_decap_8
XFILLER_5_175 vccd vssd sg13cmos5l_decap_8
X_1320_ _1320_/Y status[33] _1363_/A2 _1319_/Y _1318_/Y _1144_/B vccd vssd sg13cmos5l_a221oi_1
XFILLER_29_1157 vccd vssd sg13cmos5l_decap_8
XFILLER_9_1218 vccd vssd sg13cmos5l_decap_8
XFILLER_26_2768 vccd vssd sg13cmos5l_decap_8
XFILLER_2_882 vccd vssd sg13cmos5l_decap_8
X_1251_ _1251_/Y _1249_/Y _1251_/B vccd vssd sg13cmos5l_nand2b_2
XFILLER_22_1909 vccd vssd sg13cmos5l_decap_8
XFILLER_1_392 vccd vssd sg13cmos5l_decap_8
XFILLER_4_2520 vccd vssd sg13cmos5l_decap_8
X_1182_ _1183_/A status[68] _0974_/Y _1360_/B1 status[60] vccd vssd sg13cmos5l_a22oi_1
XFILLER_37_503 vccd vssd sg13cmos5l_decap_8
XFILLER_42_1379 vccd vssd sg13cmos5l_decap_8
XFILLER_24_1791 vccd vssd sg13cmos5l_decap_8
XFILLER_20_1633 vccd vssd sg13cmos5l_decap_8
XFILLER_4_1841 vccd vssd sg13cmos5l_decap_8
XFILLER_4_2597 vccd vssd sg13cmos5l_decap_8
XFILLER_33_2706 vccd vssd sg13cmos5l_decap_8
XFILLER_32_252 vccd vssd sg13cmos5l_decap_8
XFILLER_18_2285 vccd vssd sg13cmos5l_decap_8
XFILLER_18_1540 vccd vssd sg13cmos5l_decap_8
XFILLER_21_959 vccd vssd sg13cmos5l_decap_8
X_0966_ _0966_/Y _1197_/B _1102_/C vccd vssd sg13cmos5l_nor2_2
XFILLER_20_469 vccd vssd sg13cmos5l_decap_8
XFILLER_31_2474 vccd vssd sg13cmos5l_decap_8
XFILLER_31_1762 vccd vssd sg13cmos5l_decap_8
Xoutbuffers\[85\] control[85] _1753_/Q vccd vssd sg13cmos5l_buf_8
X_0897_ _0938_/B _1394_/A _0948_/A vccd vssd sg13cmos5l_nand2_1
XFILLER_12_1183 vccd vssd sg13cmos5l_decap_8
XFILLER_27_1809 vccd vssd sg13cmos5l_decap_8
XFILLER_0_819 vccd vssd sg13cmos5l_decap_8
XFILLER_25_2234 vccd vssd sg13cmos5l_decap_8
X_1518_ _1518_/X _1528_/A hold427/X _1518_/S vccd vssd sg13cmos5l_mux2_1
XFILLER_5_2317 vccd vssd sg13cmos5l_decap_8
XFILLER_9_2464 vccd vssd sg13cmos5l_decap_8
X_1449_ _1449_/Y _1495_/A _1449_/B vccd vssd sg13cmos5l_nor2_1
XFILLER_25_1533 vccd vssd sg13cmos5l_decap_8
XFILLER_9_1785 vccd vssd sg13cmos5l_decap_8
XFILLER_42_2581 vccd vssd sg13cmos5l_decap_8
XFILLER_3_2030 vccd vssd sg13cmos5l_decap_8
XFILLER_5_1638 vccd vssd sg13cmos5l_decap_8
XFILLER_3_1351 vccd vssd sg13cmos5l_decap_8
XFILLER_24_742 vccd vssd sg13cmos5l_decap_8
XFILLER_19_1337 vccd vssd sg13cmos5l_decap_8
XFILLER_36_2363 vccd vssd sg13cmos5l_decap_8
XFILLER_36_1640 vccd vssd sg13cmos5l_decap_8
XFILLER_23_252 vccd vssd sg13cmos5l_decap_8
XFILLER_17_1050 vccd vssd sg13cmos5l_decap_8
XFILLER_12_959 vccd vssd sg13cmos5l_decap_8
XFILLER_32_1526 vccd vssd sg13cmos5l_decap_8
XFILLER_23_77 vccd vssd sg13cmos5l_decap_8
XFILLER_11_469 vccd vssd sg13cmos5l_decap_8
XFILLER_14_1960 vccd vssd sg13cmos5l_decap_8
XFILLER_3_602 vccd vssd sg13cmos5l_decap_8
XFILLER_10_1813 vccd vssd sg13cmos5l_decap_8
XFILLER_30_1283 vccd vssd sg13cmos5l_decap_8
XFILLER_2_112 vccd vssd sg13cmos5l_decap_8
XFILLER_3_679 vccd vssd sg13cmos5l_decap_8
XFILLER_43_2345 vccd vssd sg13cmos5l_decap_4
XFILLER_2_189 vccd vssd sg13cmos5l_decap_8
XFILLER_43_2378 vccd vssd sg13cmos5l_decap_4
XFILLER_21_2643 vccd vssd sg13cmos5l_decap_8
XFILLER_19_525 vccd vssd sg13cmos5l_decap_8
XFILLER_1_2737 vccd vssd sg13cmos5l_decap_8
XFILLER_4_1148 vccd vssd sg13cmos5l_decap_8
XFILLER_8_1295 vccd vssd sg13cmos5l_decap_8
Xtiedowns\[17\] status[17] vccd vssd sg13cmos5l_antennanp
XFILLER_34_528 vccd vssd sg13cmos5l_decap_8
XFILLER_15_742 vccd vssd sg13cmos5l_decap_8
XFILLER_42_550 vccd vssd sg13cmos5l_decap_8
XFILLER_19_2594 vccd vssd sg13cmos5l_decap_8
XFILLER_9_35 vccd vssd sg13cmos5l_decap_8
XFILLER_14_252 vccd vssd sg13cmos5l_decap_8
XFILLER_19_1871 vccd vssd sg13cmos5l_decap_8
XFILLER_15_2458 vccd vssd sg13cmos5l_decap_8
XFILLER_35_1183 vccd vssd sg13cmos5l_decap_4
XFILLER_15_1757 vccd vssd sg13cmos5l_decap_8
XFILLER_7_952 vccd vssd sg13cmos5l_decap_8
XFILLER_31_1058 vccd vssd sg13cmos5l_decap_4
XFILLER_6_462 vccd vssd sg13cmos5l_decap_8
XFILLER_13_1470 vccd vssd sg13cmos5l_decap_8
XFILLER_6_2615 vccd vssd sg13cmos5l_decap_8
XFILLER_9_1015 vccd vssd sg13cmos5l_decap_8
XFILLER_26_2576 vccd vssd sg13cmos5l_decap_8
X_1303_ _1303_/Y _1301_/Y _1302_/X _1076_/A vccd vssd sg13cmos5l_o21ai_1
X_1234_ _1235_/D _1791_/Q _0966_/Y _1324_/B status[11] vccd vssd sg13cmos5l_a22oi_1
XFILLER_6_1925 vccd vssd sg13cmos5l_decap_8
XFILLER_42_1176 vccd vssd sg13cmos5l_decap_4
XFILLER_38_856 vccd vssd sg13cmos5l_decap_8
XFILLER_37_322 vccd vssd sg13cmos5l_decap_8
XFILLER_26_1897 vccd vssd sg13cmos5l_decap_8
XFILLER_22_1739 vccd vssd sg13cmos5l_decap_8
X_1165_ _1165_/X _1681_/Q _1429_/B _1419_/B vccd vssd sg13cmos5l_a21o_1
XFILLER_0_2247 vccd vssd sg13cmos5l_decap_8
XFILLER_4_2394 vccd vssd sg13cmos5l_decap_8
X_1096_ _1096_/Y _0871_/Y _1361_/B _1142_/B vccd vssd sg13cmos5l_a21oi_1
XFILLER_37_399 vccd vssd sg13cmos5l_decap_8
XFILLER_25_539 vccd vssd sg13cmos5l_decap_8
XFILLER_0_1568 vccd vssd sg13cmos5l_decap_8
XFILLER_18_2060 vccd vssd sg13cmos5l_decap_8
XFILLER_37_1982 vccd vssd sg13cmos5l_decap_8
XFILLER_21_756 vccd vssd sg13cmos5l_decap_8
XFILLER_33_1835 vccd vssd sg13cmos5l_decap_8
XFILLER_20_266 vccd vssd sg13cmos5l_decap_8
XFILLER_31_2271 vccd vssd sg13cmos5l_decap_8
XFILLER_14_1267 vccd vssd sg13cmos5l_decap_8
X_0949_ _0952_/B _1803_/Q _0971_/C vccd vssd sg13cmos5l_nor2_1
XFILLER_27_2318 vccd vssd sg13cmos5l_decap_8
XFILLER_44_2632 vccd vssd sg13cmos5l_decap_8
XFILLER_0_616 vccd vssd sg13cmos5l_decap_8
XFILLER_9_2261 vccd vssd sg13cmos5l_decap_8
XFILLER_25_2053 vccd vssd sg13cmos5l_decap_8
XFILLER_5_2114 vccd vssd sg13cmos5l_decap_8
XFILLER_40_1806 vccd vssd sg13cmos5l_decap_8
XFILLER_25_1341 vccd vssd sg13cmos5l_decap_8
XFILLER_9_1582 vccd vssd sg13cmos5l_decap_8
XFILLER_28_322 vccd vssd sg13cmos5l_decap_8
XFILLER_5_1435 vccd vssd sg13cmos5l_decap_8
XFILLER_38_2403 vccd vssd sg13cmos5l_decap_8
XFILLER_18_77 vccd vssd sg13cmos5l_decap_8
XFILLER_43_314 vccd vssd sg13cmos5l_decap_8
XFILLER_38_2436 vccd vssd sg13cmos5l_decap_4
XFILLER_28_399 vccd vssd sg13cmos5l_decap_8
XFILLER_16_539 vccd vssd sg13cmos5l_decap_8
XFILLER_38_2469 vccd vssd sg13cmos5l_decap_8
XFILLER_34_21 vccd vssd sg13cmos5l_decap_8
XFILLER_38_1768 vccd vssd sg13cmos5l_decap_8
XFILLER_19_1134 vccd vssd sg13cmos5l_decap_8
XFILLER_34_98 vccd vssd sg13cmos5l_decap_8
XFILLER_32_2002 vccd vssd sg13cmos5l_decap_8
XFILLER_12_756 vccd vssd sg13cmos5l_decap_8
XFILLER_32_2035 vccd vssd sg13cmos5l_decap_8
XFILLER_11_266 vccd vssd sg13cmos5l_decap_8
XFILLER_36_1492 vccd vssd sg13cmos5l_decap_8
XFILLER_8_749 vccd vssd sg13cmos5l_decap_8
XFILLER_14_2491 vccd vssd sg13cmos5l_decap_8
XFILLER_32_1378 vccd vssd sg13cmos5l_decap_8
XFILLER_7_259 vccd vssd sg13cmos5l_decap_8
XFILLER_10_1610 vccd vssd sg13cmos5l_decap_8
XFILLER_10_2366 vccd vssd sg13cmos5l_decap_8
XFILLER_45_2429 vccd vssd sg13cmos5l_decap_8
XFILLER_4_966 vccd vssd sg13cmos5l_decap_8
XFILLER_10_1687 vccd vssd sg13cmos5l_decap_8
XFILLER_3_476 vccd vssd sg13cmos5l_decap_8
XFILLER_1_0 vccd vssd sg13cmos5l_decap_8
XFILLER_43_2197 vccd vssd sg13cmos5l_decap_8
XFILLER_38_119 vccd vssd sg13cmos5l_decap_8
XFILLER_21_2440 vccd vssd sg13cmos5l_decap_8
XFILLER_19_322 vccd vssd sg13cmos5l_decap_8
XFILLER_8_1092 vccd vssd sg13cmos5l_decap_8
XFILLER_1_2534 vccd vssd sg13cmos5l_decap_8
XFILLER_19_399 vccd vssd sg13cmos5l_decap_8
XFILLER_34_336 vccd vssd sg13cmos5l_decap_8
XFILLER_1_1855 vccd vssd sg13cmos5l_decap_8
XFILLER_37_1223 vccd vssd sg13cmos5l_decap_8
XFILLER_15_2255 vccd vssd sg13cmos5l_decap_4
XFILLER_15_1554 vccd vssd sg13cmos5l_decap_8
X_1783_ _1783_/Q _1793_/CLK _1783_/D fanout118/X vccd vssd sg13cmos5l_dfrbpq_1
XFILLER_11_1407 vccd vssd sg13cmos5l_decap_8
Xfanout9 _1518_/S _1519_/S vccd vssd sg13cmos5l_buf_1
XFILLER_28_2616 vccd vssd sg13cmos5l_decap_8
XFILLER_6_2401 vccd vssd sg13cmos5l_decap_8
XFILLER_44_1238 vccd vssd sg13cmos5l_decap_8
XFILLER_34_0 vccd vssd sg13cmos5l_decap_8
XFILLER_28_1959 vccd vssd sg13cmos5l_decap_8
XFILLER_26_2373 vccd vssd sg13cmos5l_decap_8
XFILLER_6_1722 vccd vssd sg13cmos5l_decap_8
Xoutbuffers\[48\] control[48] _1716_/Q vccd vssd sg13cmos5l_buf_8
XFILLER_38_631 vccd vssd sg13cmos5l_decap_8
XFILLER_29_119 vccd vssd sg13cmos5l_decap_8
XFILLER_26_1672 vccd vssd sg13cmos5l_decap_8
XFILLER_6_2478 vccd vssd sg13cmos5l_decap_8
XFILLER_4_2191 vccd vssd sg13cmos5l_decap_8
XFILLER_6_1799 vccd vssd sg13cmos5l_decap_8
X_1217_ _1217_/Y _1217_/A _1217_/B _1217_/C vccd vssd sg13cmos5l_nand3_1
XFILLER_26_826 vccd vssd sg13cmos5l_decap_8
XFILLER_0_2044 vccd vssd sg13cmos5l_decap_8
XFILLER_1_91 vccd vssd sg13cmos5l_decap_8
X_1148_ _1148_/X status[5] _1148_/B vccd vssd sg13cmos5l_and2_1
XFILLER_39_2745 vccd vssd sg13cmos5l_decap_8
XFILLER_38_1009 vccd vssd sg13cmos5l_decap_4
XFILLER_37_196 vccd vssd sg13cmos5l_decap_8
XFILLER_35_2609 vccd vssd sg13cmos5l_decap_8
XFILLER_25_336 vccd vssd sg13cmos5l_decap_8
XFILLER_20_1260 vccd vssd sg13cmos5l_decap_8
XFILLER_0_1365 vccd vssd sg13cmos5l_decap_8
X_1079_ _1258_/B _1077_/A _1077_/B _1351_/A vccd vssd sg13cmos5l_o21ai_1
XFILLER_35_1908 vccd vssd sg13cmos5l_decap_8
XFILLER_21_553 vccd vssd sg13cmos5l_decap_8
XFILLER_33_1698 vccd vssd sg13cmos5l_decap_8
XFILLER_14_1064 vccd vssd sg13cmos5l_decap_8
XFILLER_11_2697 vccd vssd sg13cmos5l_decap_8
XFILLER_27_2115 vccd vssd sg13cmos5l_decap_8
XFILLER_20_56 vccd vssd sg13cmos5l_decap_8
XFILLER_1_903 vccd vssd sg13cmos5l_decap_8
XFILLER_11_1974 vccd vssd sg13cmos5l_decap_8
XFILLER_27_1403 vccd vssd sg13cmos5l_decap_8
XFILLER_0_413 vccd vssd sg13cmos5l_decap_8
XFILLER_7_1519 vccd vssd sg13cmos5l_decap_8
XFILLER_29_21 vccd vssd sg13cmos5l_decap_8
XFILLER_27_1469 vccd vssd sg13cmos5l_decap_8
XFILLER_40_2359 vccd vssd sg13cmos5l_decap_8
XFILLER_5_1232 vccd vssd sg13cmos5l_decap_8
XFILLER_29_653 vccd vssd sg13cmos5l_decap_8
XFILLER_29_98 vccd vssd sg13cmos5l_decap_8
XFILLER_25_1182 vccd vssd sg13cmos5l_decap_8
XFILLER_22_2760 vccd vssd sg13cmos5l_decap_8
XFILLER_40_1669 vccd vssd sg13cmos5l_decap_8
XFILLER_38_2211 vccd vssd sg13cmos5l_decap_8
XFILLER_21_1057 vccd vssd sg13cmos5l_decap_8
XFILLER_17_826 vccd vssd sg13cmos5l_decap_8
XFILLER_45_42 vccd vssd sg13cmos5l_decap_8
XFILLER_44_656 vccd vssd sg13cmos5l_decap_8
XFILLER_44_634 vccd vssd sg13cmos5l_decap_8
XFILLER_28_196 vccd vssd sg13cmos5l_decap_8
XFILLER_16_336 vccd vssd sg13cmos5l_decap_8
XFILLER_43_144 vccd vssd sg13cmos5l_decap_4
XFILLER_32_818 vccd vssd sg13cmos5l_decap_8
XFILLER_38_2288 vccd vssd sg13cmos5l_decap_8
XFILLER_25_892 vccd vssd sg13cmos5l_decap_8
XFILLER_40_873 vccd vssd sg13cmos5l_decap_8
XFILLER_38_1587 vccd vssd sg13cmos5l_decap_8
XFILLER_12_553 vccd vssd sg13cmos5l_decap_8
Xtiedowns\[84\] status[84] vccd vssd sg13cmos5l_antennanp
XFILLER_32_1120 vccd vssd sg13cmos5l_decap_8
XFILLER_16_2597 vccd vssd sg13cmos5l_decap_8
XFILLER_16_1841 vccd vssd sg13cmos5l_decap_8
XFILLER_8_546 vccd vssd sg13cmos5l_decap_8
XFILLER_6_14 vccd vssd sg13cmos5l_decap_8
XANTENNA_7 RSTB vccd vssd sg13cmos5l_antennanp
XFILLER_10_2163 vccd vssd sg13cmos5l_decap_8
XFILLER_45_2226 vccd vssd sg13cmos5l_decap_8
XFILLER_4_763 vccd vssd sg13cmos5l_decap_8
XFILLER_10_1484 vccd vssd sg13cmos5l_decap_8
XFILLER_3_273 vccd vssd sg13cmos5l_decap_8
XFILLER_7_2710 vccd vssd sg13cmos5l_decap_8
XFILLER_7_2743 vccd vssd sg13cmos5l_decap_8
XFILLER_45_1547 vccd vssd sg13cmos5l_decap_8
XFILLER_27_2693 vccd vssd sg13cmos5l_decap_8
XFILLER_7_2776 vccd vssd sg13cmos5l_decap_8
XFILLER_27_1981 vccd vssd sg13cmos5l_decap_8
XFILLER_23_2557 vccd vssd sg13cmos5l_decap_8
XFILLER_0_980 vccd vssd sg13cmos5l_decap_8
XFILLER_3_2618 vccd vssd sg13cmos5l_decap_8
XFILLER_6_1029 vccd vssd sg13cmos5l_decap_8
XFILLER_3_1939 vccd vssd sg13cmos5l_decap_8
XFILLER_1_2331 vccd vssd sg13cmos5l_decap_8
X_1002_ _1002_/Y _0878_/Y _1268_/B1 _1317_/B1 vccd vssd sg13cmos5l_a21oi_1
XFILLER_39_2019 vccd vssd sg13cmos5l_decap_4
XFILLER_35_656 vccd vssd sg13cmos5l_decap_8
XFILLER_34_133 vccd vssd sg13cmos5l_decap_8
XFILLER_19_196 vccd vssd sg13cmos5l_decap_8
XFILLER_1_1652 vccd vssd sg13cmos5l_decap_8
XFILLER_17_2306 vccd vssd sg13cmos5l_decap_8
XFILLER_31_851 vccd vssd sg13cmos5l_decap_8
XFILLER_17_1638 vccd vssd sg13cmos5l_decap_8
XFILLER_15_2030 vccd vssd sg13cmos5l_decap_8
XFILLER_34_2686 vccd vssd sg13cmos5l_decap_8
XFILLER_30_350 vccd vssd sg13cmos5l_decap_8
XFILLER_15_1351 vccd vssd sg13cmos5l_decap_8
XFILLER_11_1204 vccd vssd sg13cmos5l_decap_8
X_1766_ _1766_/Q clkload7/A _1766_/D fanout116/X vccd vssd sg13cmos5l_dfrbpq_1
XFILLER_30_1838 vccd vssd sg13cmos5l_decap_4
Xhold502 hold502/X _1773_/Q vccd vssd sg13cmos5l_dlygate4sd3_1
Xhold513 hold513/X _1792_/Q vccd vssd sg13cmos5l_dlygate4sd3_1
Xhold524 hold524/X _1650_/Q vccd vssd sg13cmos5l_dlygate4sd3_1
Xhold535 hold535/X _1662_/Q vccd vssd sg13cmos5l_dlygate4sd3_1
XFILLER_28_2457 vccd vssd sg13cmos5l_decap_8
X_1697_ _1697_/Q _1697_/CLK _1697_/D fanout134/X vccd vssd sg13cmos5l_dfrbpq_1
XFILLER_8_1806 vccd vssd sg13cmos5l_decap_8
XFILLER_44_1035 vccd vssd sg13cmos5l_decap_8
XFILLER_41_2635 vccd vssd sg13cmos5l_decap_8
XFILLER_28_1756 vccd vssd sg13cmos5l_decap_8
XFILLER_41_1901 vccd vssd sg13cmos5l_decap_8
XFILLER_22_2034 vccd vssd sg13cmos5l_decap_8
XFILLER_6_2275 vccd vssd sg13cmos5l_decap_8
XFILLER_22_2067 vccd vssd sg13cmos5l_decap_8
XFILLER_22_1322 vccd vssd sg13cmos5l_decap_8
XFILLER_2_2128 vccd vssd sg13cmos5l_decap_8
XFILLER_41_1978 vccd vssd sg13cmos5l_decap_8
XFILLER_39_995 vccd vssd sg13cmos5l_decap_8
XFILLER_2_1449 vccd vssd sg13cmos5l_decap_8
XFILLER_6_1596 vccd vssd sg13cmos5l_decap_8
XFILLER_39_2542 vccd vssd sg13cmos5l_decap_8
XFILLER_25_133 vccd vssd sg13cmos5l_decap_8
XFILLER_35_2406 vccd vssd sg13cmos5l_decap_8
XFILLER_26_678 vccd vssd sg13cmos5l_decap_8
XFILLER_0_1162 vccd vssd sg13cmos5l_decap_8
XFILLER_39_1874 vccd vssd sg13cmos5l_decap_8
XFILLER_15_56 vccd vssd sg13cmos5l_decap_8
XFILLER_40_147 vccd vssd sg13cmos5l_decap_8
XFILLER_35_1727 vccd vssd sg13cmos5l_decap_8
XFILLER_22_840 vccd vssd sg13cmos5l_decap_8
XFILLER_21_350 vccd vssd sg13cmos5l_decap_8
XFILLER_16_1148 vccd vssd sg13cmos5l_decap_8
XFILLER_31_77 vccd vssd sg13cmos5l_decap_8
XFILLER_11_2450 vccd vssd sg13cmos5l_decap_8
XFILLER_11_2472 vccd vssd sg13cmos5l_decap_8
XFILLER_1_700 vccd vssd sg13cmos5l_decap_8
XFILLER_11_1771 vccd vssd sg13cmos5l_decap_8
XFILLER_0_210 vccd vssd sg13cmos5l_decap_8
XFILLER_27_1255 vccd vssd sg13cmos5l_decap_8
XFILLER_1_777 vccd vssd sg13cmos5l_decap_8
XFILLER_7_1316 vccd vssd sg13cmos5l_decap_8
XFILLER_44_2292 vccd vssd sg13cmos5l_decap_8
XFILLER_40_2123 vccd vssd sg13cmos5l_decap_8
XFILLER_0_287 vccd vssd sg13cmos5l_decap_8
XFILLER_45_910 vccd vssd sg13cmos5l_decap_8
XFILLER_40_1466 vccd vssd sg13cmos5l_decap_8
XFILLER_40_1444 vccd vssd sg13cmos5l_decap_4
XFILLER_29_494 vccd vssd sg13cmos5l_decap_8
XFILLER_17_623 vccd vssd sg13cmos5l_decap_8
XFILLER_2_2695 vccd vssd sg13cmos5l_decap_8
XFILLER_45_987 vccd vssd sg13cmos5l_decap_8
XFILLER_44_475 vccd vssd sg13cmos5l_decap_8
XFILLER_18_2604 vccd vssd sg13cmos5l_decap_8
XFILLER_16_133 vccd vssd sg13cmos5l_decap_8
XFILLER_38_2063 vccd vssd sg13cmos5l_decap_4
XFILLER_18_2659 vccd vssd sg13cmos5l_decap_8
XFILLER_31_147 vccd vssd sg13cmos5l_decap_8
XFILLER_13_840 vccd vssd sg13cmos5l_decap_8
XFILLER_38_1395 vccd vssd sg13cmos5l_decap_8
XFILLER_9_833 vccd vssd sg13cmos5l_decap_8
XFILLER_12_350 vccd vssd sg13cmos5l_decap_8
XFILLER_8_343 vccd vssd sg13cmos5l_decap_8
XFILLER_12_2236 vccd vssd sg13cmos5l_decap_8
XFILLER_12_1568 vccd vssd sg13cmos5l_decap_8
XFILLER_45_2023 vccd vssd sg13cmos5l_decap_8
XFILLER_29_2755 vccd vssd sg13cmos5l_decap_8
XFILLER_28_1008 vccd vssd sg13cmos5l_decap_8
X_1551_ _1551_/X _1481_/A hold437/X _1555_/S vccd vssd sg13cmos5l_mux2_1
XFILLER_4_560 vccd vssd sg13cmos5l_decap_8
X_1482_ _1712_/D hold265/X _1485_/S _1481_/Y vccd vssd sg13cmos5l_a21oi_1
XFILLER_25_2608 vccd vssd sg13cmos5l_decap_4
XFILLER_10_1281 vccd vssd sg13cmos5l_decap_8
XFILLER_45_1344 vccd vssd sg13cmos5l_decap_8
XFILLER_39_203 vccd vssd sg13cmos5l_decap_8
XFILLER_3_2415 vccd vssd sg13cmos5l_decap_8
XFILLER_7_1883 vccd vssd sg13cmos5l_decap_8
XFILLER_7_2595 vccd vssd sg13cmos5l_decap_8
XFILLER_23_1664 vccd vssd sg13cmos5l_decap_8
XFILLER_3_1736 vccd vssd sg13cmos5l_decap_8
XFILLER_35_420 vccd vssd sg13cmos5l_decap_8
XFILLER_35_486 vccd vssd sg13cmos5l_decap_8
XFILLER_23_637 vccd vssd sg13cmos5l_decap_8
XFILLER_22_147 vccd vssd sg13cmos5l_decap_8
XFILLER_17_2158 vccd vssd sg13cmos5l_decap_8
XFILLER_34_2461 vccd vssd sg13cmos5l_decap_8
XFILLER_30_2314 vccd vssd sg13cmos5l_decap_8
XFILLER_17_1435 vccd vssd sg13cmos5l_decap_8
XFILLER_30_1624 vccd vssd sg13cmos5l_decap_8
XFILLER_11_1001 vccd vssd sg13cmos5l_decap_8
Xhold310 hold310/X _1696_/Q vccd vssd sg13cmos5l_dlygate4sd3_1
Xhold321 _1731_/D _1509_/X vccd vssd sg13cmos5l_dlygate4sd3_1
Xhold332 hold332/X _1695_/Q vccd vssd sg13cmos5l_dlygate4sd3_1
Xhold343 hold343/X _1557_/Y vccd vssd sg13cmos5l_dlygate4sd3_1
X_1749_ _1749_/Q clkload2/A _1749_/D fanout121/X vccd vssd sg13cmos5l_dfrbpq_1
XFILLER_11_1078 vccd vssd sg13cmos5l_decap_8
Xhold376 _1681_/D _1436_/X vccd vssd sg13cmos5l_dlygate4sd3_1
Xhold354 hold354/X _1717_/Q vccd vssd sg13cmos5l_dlygate4sd3_1
Xhold387 _0854_/A _1767_/Q vccd vssd sg13cmos5l_dlygate4sd3_1
Xhold365 hold365/X _1682_/Q vccd vssd sg13cmos5l_dlygate4sd3_1
Xhold398 _0924_/A _1801_/Q vccd vssd sg13cmos5l_dlygate4sd3_1
XFILLER_8_1603 vccd vssd sg13cmos5l_decap_8
XFILLER_8_2359 vccd vssd sg13cmos5l_decap_8
XFILLER_45_2590 vccd vssd sg13cmos5l_decap_8
XFILLER_41_2443 vccd vssd sg13cmos5l_decap_8
XFILLER_6_2072 vccd vssd sg13cmos5l_decap_8
XFILLER_45_217 vccd vssd sg13cmos5l_decap_8
XFILLER_41_1775 vccd vssd sg13cmos5l_decap_8
XFILLER_22_1141 vccd vssd sg13cmos5l_decap_8
XFILLER_38_280 vccd vssd sg13cmos5l_decap_8
XFILLER_26_420 vccd vssd sg13cmos5l_decap_8
XFILLER_2_1246 vccd vssd sg13cmos5l_decap_8
XFILLER_6_1393 vccd vssd sg13cmos5l_decap_8
XFILLER_27_998 vccd vssd sg13cmos5l_decap_8
XFILLER_35_2225 vccd vssd sg13cmos5l_decap_8
XFILLER_26_497 vccd vssd sg13cmos5l_decap_8
XFILLER_26_77 vccd vssd sg13cmos5l_decap_8
XFILLER_14_637 vccd vssd sg13cmos5l_decap_8
XFILLER_41_456 vccd vssd sg13cmos5l_decap_8
XFILLER_39_1693 vccd vssd sg13cmos5l_decap_8
XFILLER_35_1524 vccd vssd sg13cmos5l_decap_8
XFILLER_13_147 vccd vssd sg13cmos5l_decap_8
XFILLER_42_21 vccd vssd sg13cmos5l_decap_8
XFILLER_17_2692 vccd vssd sg13cmos5l_decap_8
XFILLER_35_1579 vccd vssd sg13cmos5l_decap_8
XFILLER_10_854 vccd vssd sg13cmos5l_decap_8
XFILLER_13_2545 vccd vssd sg13cmos5l_decap_8
XFILLER_42_98 vccd vssd sg13cmos5l_decap_8
XFILLER_13_1855 vccd vssd sg13cmos5l_decap_8
XFILLER_6_847 vccd vssd sg13cmos5l_decap_8
XFILLER_5_357 vccd vssd sg13cmos5l_decap_8
XFILLER_11_2291 vccd vssd sg13cmos5l_decap_8
XFILLER_29_1328 vccd vssd sg13cmos5l_decap_8
Xtiedowns\[47\] status[47] vccd vssd sg13cmos5l_antennanp
XFILLER_1_574 vccd vssd sg13cmos5l_decap_8
XFILLER_4_2702 vccd vssd sg13cmos5l_decap_8
XFILLER_7_1113 vccd vssd sg13cmos5l_decap_8
XFILLER_27_1085 vccd vssd sg13cmos5l_decap_8
XFILLER_24_2685 vccd vssd sg13cmos5l_decap_8
XFILLER_20_2527 vccd vssd sg13cmos5l_decap_8
XFILLER_36_217 vccd vssd sg13cmos5l_decap_8
XFILLER_18_910 vccd vssd sg13cmos5l_decap_8
XFILLER_29_280 vccd vssd sg13cmos5l_decap_8
XFILLER_20_1848 vccd vssd sg13cmos5l_decap_4
XFILLER_17_420 vccd vssd sg13cmos5l_decap_8
XFILLER_18_987 vccd vssd sg13cmos5l_decap_8
XFILLER_2_2492 vccd vssd sg13cmos5l_decap_8
XFILLER_45_784 vccd vssd sg13cmos5l_decap_8
XFILLER_18_2434 vccd vssd sg13cmos5l_decap_8
XFILLER_17_497 vccd vssd sg13cmos5l_decap_8
XFILLER_44_294 vccd vssd sg13cmos5l_decap_8
XFILLER_33_968 vccd vssd sg13cmos5l_decap_8
XFILLER_32_434 vccd vssd sg13cmos5l_decap_8
XFILLER_18_1722 vccd vssd sg13cmos5l_decap_8
X_0982_ _0982_/Y _1070_/B _1070_/A _0982_/C _0988_/C vccd vssd sg13cmos5l_nor4_2
XFILLER_35_2770 vccd vssd sg13cmos5l_decap_8
XFILLER_31_2612 vccd vssd sg13cmos5l_decap_8
XFILLER_34_1067 vccd vssd sg13cmos5l_decap_8
XFILLER_18_1799 vccd vssd sg13cmos5l_decap_8
XFILLER_9_630 vccd vssd sg13cmos5l_decap_8
XFILLER_31_2689 vccd vssd sg13cmos5l_decap_8
XFILLER_8_140 vccd vssd sg13cmos5l_decap_8
XFILLER_12_2044 vccd vssd sg13cmos5l_decap_8
X_1603_ _1603_/Y _1605_/A _1603_/B_N vccd vssd sg13cmos5l_nor2b_1
XFILLER_12_1365 vccd vssd sg13cmos5l_decap_8
XFILLER_29_2552 vccd vssd sg13cmos5l_decap_8
X_1534_ _1534_/X _1591_/A0 hold431/X _1541_/S vccd vssd sg13cmos5l_mux2_1
XFILLER_9_2624 vccd vssd sg13cmos5l_decap_8
Xfanout108 _1591_/A0 _1547_/A vccd vssd sg13cmos5l_buf_1
Xfanout119 fanout119/X fanout120/X vccd vssd sg13cmos5l_buf_1
XFILLER_25_2416 vccd vssd sg13cmos5l_decap_8
XFILLER_45_1141 vccd vssd sg13cmos5l_decap_8
XFILLER_42_2741 vccd vssd sg13cmos5l_decap_8
XFILLER_25_1715 vccd vssd sg13cmos5l_decap_8
X_1465_ _1700_/D _1488_/A1 _1471_/S hold206/X vccd vssd sg13cmos5l_o21ai_1
XFILLER_9_1967 vccd vssd sg13cmos5l_decap_8
X_1396_ _1396_/X _1506_/A _1495_/A _1401_/B vccd vssd sg13cmos5l_mux2_1
XFILLER_23_2162 vccd vssd sg13cmos5l_decap_8
XFILLER_3_2212 vccd vssd sg13cmos5l_decap_8
XFILLER_27_217 vccd vssd sg13cmos5l_decap_8
XFILLER_23_1450 vccd vssd sg13cmos5l_decap_8
XFILLER_7_1680 vccd vssd sg13cmos5l_decap_8
Xoutbuffers\[30\] control[30] _1698_/Q vccd vssd sg13cmos5l_buf_8
XFILLER_3_2289 vccd vssd sg13cmos5l_decap_8
XFILLER_3_1533 vccd vssd sg13cmos5l_decap_8
XFILLER_36_773 vccd vssd sg13cmos5l_decap_8
XFILLER_19_2209 vccd vssd sg13cmos5l_decap_8
XFILLER_24_924 vccd vssd sg13cmos5l_decap_8
XFILLER_19_1519 vccd vssd sg13cmos5l_decap_8
XFILLER_36_2567 vccd vssd sg13cmos5l_decap_8
XFILLER_35_294 vccd vssd sg13cmos5l_decap_8
XFILLER_23_434 vccd vssd sg13cmos5l_decap_8
XFILLER_32_2409 vccd vssd sg13cmos5l_decap_8
XFILLER_17_1232 vccd vssd sg13cmos5l_decap_8
XFILLER_30_2111 vccd vssd sg13cmos5l_decap_8
XFILLER_12_35 vccd vssd sg13cmos5l_decap_8
XFILLER_34_1590 vccd vssd sg13cmos5l_decap_8
XFILLER_30_2177 vccd vssd sg13cmos5l_decap_8
XFILLER_5_7 vccd vssd sg13cmos5l_decap_8
XFILLER_28_2073 vccd vssd sg13cmos5l_decap_8
Xhold184 _0913_/A _1804_/Q vccd vssd sg13cmos5l_dlygate4sd3_1
XFILLER_8_1400 vccd vssd sg13cmos5l_decap_8
Xhold195 hold195/X hold530/X vccd vssd sg13cmos5l_dlygate4sd3_1
XFILLER_4_2009 vccd vssd sg13cmos5l_decap_8
XFILLER_8_2156 vccd vssd sg13cmos5l_decap_8
XFILLER_41_2251 vccd vssd sg13cmos5l_decap_8
XFILLER_8_1477 vccd vssd sg13cmos5l_decap_8
XFILLER_37_21 vccd vssd sg13cmos5l_decap_8
XFILLER_19_707 vccd vssd sg13cmos5l_decap_8
XFILLER_18_217 vccd vssd sg13cmos5l_decap_8
XFILLER_6_1190 vccd vssd sg13cmos5l_decap_8
XFILLER_37_98 vccd vssd sg13cmos5l_decap_8
XFILLER_2_1043 vccd vssd sg13cmos5l_decap_8
XFILLER_42_732 vccd vssd sg13cmos5l_decap_8
XFILLER_35_2000 vccd vssd sg13cmos5l_decap_8
XFILLER_15_924 vccd vssd sg13cmos5l_decap_8
XFILLER_41_231 vccd vssd sg13cmos5l_decap_8
XFILLER_26_294 vccd vssd sg13cmos5l_decap_8
XFILLER_19_2776 vccd vssd sg13cmos5l_decap_8
XFILLER_18_1029 vccd vssd sg13cmos5l_decap_8
XFILLER_14_434 vccd vssd sg13cmos5l_decap_8
XFILLER_30_938 vccd vssd sg13cmos5l_decap_8
XFILLER_35_1354 vccd vssd sg13cmos5l_decap_8
XFILLER_30_949 vccd vssd sg13cmos5l_decap_8
XFILLER_15_1939 vccd vssd sg13cmos5l_decap_8
XFILLER_31_1229 vccd vssd sg13cmos5l_decap_8
XFILLER_10_651 vccd vssd sg13cmos5l_decap_8
XFILLER_13_2342 vccd vssd sg13cmos5l_decap_8
XFILLER_6_644 vccd vssd sg13cmos5l_decap_8
XFILLER_13_1652 vccd vssd sg13cmos5l_decap_8
XFILLER_5_154 vccd vssd sg13cmos5l_decap_8
XFILLER_29_1136 vccd vssd sg13cmos5l_decap_4
XFILLER_26_2747 vccd vssd sg13cmos5l_decap_8
XFILLER_2_861 vccd vssd sg13cmos5l_decap_8
XFILLER_42_2015 vccd vssd sg13cmos5l_decap_8
XFILLER_38_7 vccd vssd sg13cmos5l_decap_8
XFILLER_1_371 vccd vssd sg13cmos5l_decap_8
X_1250_ _1251_/B _1679_/Q _1052_/Y _1419_/B vccd vssd sg13cmos5l_a21oi_1
XFILLER_8_2690 vccd vssd sg13cmos5l_decap_8
X_1181_ _1183_/C status[52] _1268_/B1 _1317_/B1 vccd vssd sg13cmos5l_a21oi_1
XFILLER_42_1358 vccd vssd sg13cmos5l_decap_8
XFILLER_24_2471 vccd vssd sg13cmos5l_decap_4
XFILLER_4_1820 vccd vssd sg13cmos5l_decap_8
XFILLER_24_1770 vccd vssd sg13cmos5l_decap_8
XFILLER_20_2346 vccd vssd sg13cmos5l_decap_8
XFILLER_20_1612 vccd vssd sg13cmos5l_decap_8
XFILLER_0_2429 vccd vssd sg13cmos5l_decap_8
XFILLER_4_2576 vccd vssd sg13cmos5l_decap_8
XFILLER_4_1897 vccd vssd sg13cmos5l_decap_8
XFILLER_45_581 vccd vssd sg13cmos5l_decap_8
Xoutbuffers\[120\] control[120] _1788_/Q vccd vssd sg13cmos5l_buf_8
XFILLER_20_1689 vccd vssd sg13cmos5l_decap_8
XFILLER_18_784 vccd vssd sg13cmos5l_decap_8
XFILLER_33_743 vccd vssd sg13cmos5l_decap_8
XFILLER_32_231 vccd vssd sg13cmos5l_decap_8
XFILLER_18_2220 vccd vssd sg13cmos5l_decap_8
XFILLER_17_294 vccd vssd sg13cmos5l_decap_8
XFILLER_21_938 vccd vssd sg13cmos5l_decap_8
XFILLER_18_2264 vccd vssd sg13cmos5l_decap_8
XFILLER_20_448 vccd vssd sg13cmos5l_decap_8
XFILLER_14_2128 vccd vssd sg13cmos5l_decap_8
XFILLER_31_2453 vccd vssd sg13cmos5l_decap_8
X_0965_ _1102_/C _1070_/B _1017_/B vccd vssd sg13cmos5l_nand2b_1
XFILLER_18_1596 vccd vssd sg13cmos5l_decap_8
XFILLER_14_1449 vccd vssd sg13cmos5l_decap_8
XFILLER_31_1741 vccd vssd sg13cmos5l_decap_8
X_0896_ _0896_/Y _0898_/C _0896_/B vccd vssd sg13cmos5l_xnor2_1
XFILLER_12_1162 vccd vssd sg13cmos5l_decap_8
Xoutbuffers\[78\] control[78] _1746_/Q vccd vssd sg13cmos5l_buf_8
XFILLER_25_2213 vccd vssd sg13cmos5l_decap_8
XFILLER_9_2443 vccd vssd sg13cmos5l_decap_8
X_1517_ _1517_/X _1506_/A hold314/X _1518_/S vccd vssd sg13cmos5l_mux2_1
X_1448_ _1448_/X hold522/X hold405/X _1449_/B vccd vssd sg13cmos5l_mux2_1
XFILLER_25_1512 vccd vssd sg13cmos5l_decap_8
XFILLER_4_91 vccd vssd sg13cmos5l_decap_8
XFILLER_9_1764 vccd vssd sg13cmos5l_decap_8
XFILLER_28_504 vccd vssd sg13cmos5l_decap_4
Xclkbuf_5_30_0_SCK _1713_/CLK clkbuf_3_7_0_SCK/X vccd vssd sg13cmos5l_buf_8
XFILLER_5_1617 vccd vssd sg13cmos5l_decap_8
X_1379_ _1380_/B _1376_/Y _1377_/Y _1378_/Y vccd vssd sg13cmos5l_o21ai_1
XFILLER_25_1589 vccd vssd sg13cmos5l_decap_8
XFILLER_3_1330 vccd vssd sg13cmos5l_decap_8
XFILLER_3_2086 vccd vssd sg13cmos5l_decap_8
XFILLER_24_721 vccd vssd sg13cmos5l_decap_8
XFILLER_36_2342 vccd vssd sg13cmos5l_decap_8
XFILLER_23_231 vccd vssd sg13cmos5l_decap_8
XFILLER_19_1316 vccd vssd sg13cmos5l_decap_8
XFILLER_24_798 vccd vssd sg13cmos5l_decap_8
XFILLER_12_938 vccd vssd sg13cmos5l_decap_8
XFILLER_32_1505 vccd vssd sg13cmos5l_decap_8
XFILLER_11_448 vccd vssd sg13cmos5l_decap_8
XFILLER_23_56 vccd vssd sg13cmos5l_decap_8
XFILLER_10_1869 vccd vssd sg13cmos5l_decap_8
XFILLER_3_658 vccd vssd sg13cmos5l_decap_8
XFILLER_2_168 vccd vssd sg13cmos5l_decap_8
XFILLER_21_2622 vccd vssd sg13cmos5l_decap_8
XFILLER_19_504 vccd vssd sg13cmos5l_decap_8
XFILLER_8_1274 vccd vssd sg13cmos5l_decap_8
XFILLER_24_1088 vccd vssd sg13cmos5l_decap_8
XFILLER_1_2716 vccd vssd sg13cmos5l_decap_8
XFILLER_4_1127 vccd vssd sg13cmos5l_decap_8
XFILLER_41_1391 vccd vssd sg13cmos5l_decap_8
XFILLER_21_2699 vccd vssd sg13cmos5l_decap_8
XFILLER_0_49 vccd vssd sg13cmos5l_decap_8
XFILLER_21_1987 vccd vssd sg13cmos5l_decap_8
XFILLER_15_721 vccd vssd sg13cmos5l_decap_8
XFILLER_14_231 vccd vssd sg13cmos5l_decap_8
XFILLER_19_2573 vccd vssd sg13cmos5l_decap_8
XFILLER_9_14 vccd vssd sg13cmos5l_decap_8
XFILLER_30_757 vccd vssd sg13cmos5l_decap_8
XFILLER_19_1861 vccd vssd sg13cmos5l_decap_4
XFILLER_15_2437 vccd vssd sg13cmos5l_decap_8
XFILLER_15_798 vccd vssd sg13cmos5l_decap_8
XFILLER_15_1736 vccd vssd sg13cmos5l_decap_8
Xfanout90 _0888_/C _0885_/X vccd vssd sg13cmos5l_buf_1
XFILLER_32_2784 vccd vssd sg13cmos5l_decap_8
XFILLER_31_1037 vccd vssd sg13cmos5l_decap_8
XFILLER_7_931 vccd vssd sg13cmos5l_decap_8
XFILLER_6_441 vccd vssd sg13cmos5l_decap_8
XFILLER_26_2555 vccd vssd sg13cmos5l_decap_8
XFILLER_26_1810 vccd vssd sg13cmos5l_decap_8
XFILLER_6_1904 vccd vssd sg13cmos5l_decap_8
X_1302_ _1302_/X mask_rev_in[26] _1350_/B _1258_/B vccd vssd sg13cmos5l_a21o_1
X_1233_ _1235_/C status[3] _1366_/B1 _1021_/Y vccd vssd sg13cmos5l_a21oi_1
XFILLER_42_1111 vccd vssd sg13cmos5l_decap_8
XFILLER_26_1876 vccd vssd sg13cmos5l_decap_8
XFILLER_22_1718 vccd vssd sg13cmos5l_decap_8
XFILLER_42_1155 vccd vssd sg13cmos5l_decap_8
XFILLER_38_835 vccd vssd sg13cmos5l_decap_8
XFILLER_37_301 vccd vssd sg13cmos5l_decap_8
XFILLER_4_2373 vccd vssd sg13cmos5l_decap_8
Xtiedowns\[110\] status[110] vccd vssd sg13cmos5l_antennanp
X_1164_ _1164_/Y _1697_/Q _1164_/B vccd vssd sg13cmos5l_nand2b_1
XFILLER_0_2226 vccd vssd sg13cmos5l_decap_8
X_1095_ _1095_/Y _1092_/Y _1093_/X _1094_/Y vccd vssd sg13cmos5l_o21ai_1
XFILLER_37_378 vccd vssd sg13cmos5l_decap_8
XFILLER_25_518 vccd vssd sg13cmos5l_decap_8
XFILLER_4_1694 vccd vssd sg13cmos5l_decap_8
XFILLER_20_1486 vccd vssd sg13cmos5l_decap_8
XFILLER_18_581 vccd vssd sg13cmos5l_decap_8
XFILLER_0_1547 vccd vssd sg13cmos5l_decap_8
XFILLER_37_2695 vccd vssd sg13cmos5l_decap_8
XFILLER_37_1961 vccd vssd sg13cmos5l_decap_8
XFILLER_33_584 vccd vssd sg13cmos5l_decap_8
XFILLER_21_735 vccd vssd sg13cmos5l_decap_8
XFILLER_33_2559 vccd vssd sg13cmos5l_decap_8
XFILLER_33_1814 vccd vssd sg13cmos5l_decap_8
XFILLER_20_245 vccd vssd sg13cmos5l_decap_8
XFILLER_18_1393 vccd vssd sg13cmos5l_decap_8
X_0948_ _0971_/C _0948_/A _1804_/Q vccd vssd sg13cmos5l_nor2b_1
XFILLER_14_1246 vccd vssd sg13cmos5l_decap_8
X_0879_ _0879_/Y status[87] vccd vssd sg13cmos5l_inv_1
XFILLER_44_2611 vccd vssd sg13cmos5l_decap_8
XFILLER_25_2021 vccd vssd sg13cmos5l_decap_8
XFILLER_9_2240 vccd vssd sg13cmos5l_decap_8
XFILLER_40_2519 vccd vssd sg13cmos5l_decap_8
XFILLER_44_2688 vccd vssd sg13cmos5l_decap_8
XFILLER_5_1414 vccd vssd sg13cmos5l_decap_8
XFILLER_9_1561 vccd vssd sg13cmos5l_decap_8
XFILLER_44_1998 vccd vssd sg13cmos5l_decap_8
XFILLER_29_835 vccd vssd sg13cmos5l_decap_8
XFILLER_28_301 vccd vssd sg13cmos5l_decap_8
XFILLER_25_1397 vccd vssd sg13cmos5l_decap_8
XFILLER_18_56 vccd vssd sg13cmos5l_decap_8
XFILLER_44_849 vccd vssd sg13cmos5l_decap_8
XFILLER_28_378 vccd vssd sg13cmos5l_decap_8
XFILLER_16_518 vccd vssd sg13cmos5l_decap_8
XFILLER_19_1113 vccd vssd sg13cmos5l_decap_8
XFILLER_16_2713 vccd vssd sg13cmos5l_decap_8
XFILLER_34_77 vccd vssd sg13cmos5l_decap_8
XFILLER_24_595 vccd vssd sg13cmos5l_decap_8
XFILLER_12_735 vccd vssd sg13cmos5l_decap_8
XFILLER_36_1471 vccd vssd sg13cmos5l_decap_8
XFILLER_8_728 vccd vssd sg13cmos5l_decap_8
XFILLER_11_245 vccd vssd sg13cmos5l_decap_8
XFILLER_7_238 vccd vssd sg13cmos5l_decap_8
XFILLER_14_2470 vccd vssd sg13cmos5l_decap_8
XFILLER_32_1357 vccd vssd sg13cmos5l_decap_8
XFILLER_10_2345 vccd vssd sg13cmos5l_decap_8
XFILLER_45_2408 vccd vssd sg13cmos5l_decap_8
XFILLER_4_945 vccd vssd sg13cmos5l_decap_8
XFILLER_10_1666 vccd vssd sg13cmos5l_decap_8
XFILLER_3_455 vccd vssd sg13cmos5l_decap_8
XFILLER_45_1729 vccd vssd sg13cmos5l_decap_8
XFILLER_26_1139 vccd vssd sg13cmos5l_decap_8
XFILLER_23_2739 vccd vssd sg13cmos5l_decap_8
XFILLER_19_301 vccd vssd sg13cmos5l_decap_8
XFILLER_1_2513 vccd vssd sg13cmos5l_decap_8
XFILLER_5_2682 vccd vssd sg13cmos5l_decap_8
XFILLER_8_1071 vccd vssd sg13cmos5l_decap_8
XFILLER_34_315 vccd vssd sg13cmos5l_decap_8
XFILLER_21_2496 vccd vssd sg13cmos5l_decap_8
XFILLER_19_378 vccd vssd sg13cmos5l_decap_8
XFILLER_1_1834 vccd vssd sg13cmos5l_decap_8
XFILLER_5_1981 vccd vssd sg13cmos5l_decap_8
XFILLER_37_1202 vccd vssd sg13cmos5l_decap_8
XFILLER_19_2392 vccd vssd sg13cmos5l_decap_8
XFILLER_15_595 vccd vssd sg13cmos5l_decap_8
XFILLER_30_543 vccd vssd sg13cmos5l_decap_8
XFILLER_19_1680 vccd vssd sg13cmos5l_decap_8
XFILLER_32_2581 vccd vssd sg13cmos5l_decap_8
XFILLER_30_587 vccd vssd sg13cmos5l_decap_8
XFILLER_15_1533 vccd vssd sg13cmos5l_decap_8
X_1782_ _1782_/Q _1790_/CLK _1782_/D fanout114/X vccd vssd sg13cmos5l_dfrbpq_1
XFILLER_28_1938 vccd vssd sg13cmos5l_decap_8
XFILLER_44_1217 vccd vssd sg13cmos5l_decap_8
XFILLER_26_1651 vccd vssd sg13cmos5l_decap_8
XFILLER_27_0 vccd vssd sg13cmos5l_decap_8
XFILLER_6_1701 vccd vssd sg13cmos5l_decap_8
XFILLER_6_2457 vccd vssd sg13cmos5l_decap_8
XFILLER_38_610 vccd vssd sg13cmos5l_decap_8
XFILLER_22_2249 vccd vssd sg13cmos5l_decap_8
XFILLER_38_665 vccd vssd sg13cmos5l_decap_8
XFILLER_38_643 vccd vssd sg13cmos5l_decap_8
XFILLER_0_2023 vccd vssd sg13cmos5l_decap_8
XFILLER_4_2170 vccd vssd sg13cmos5l_decap_8
XFILLER_6_1778 vccd vssd sg13cmos5l_decap_8
X_1216_ _1217_/A _1216_/A _1216_/B vccd vssd sg13cmos5l_nand2_1
X_1147_ _1147_/Y status[13] _1147_/B vccd vssd sg13cmos5l_nand2b_1
XFILLER_39_2724 vccd vssd sg13cmos5l_decap_8
XFILLER_37_175 vccd vssd sg13cmos5l_decap_8
XFILLER_25_315 vccd vssd sg13cmos5l_decap_8
XFILLER_1_70 vccd vssd sg13cmos5l_decap_8
XFILLER_0_1344 vccd vssd sg13cmos5l_decap_8
XFILLER_4_1491 vccd vssd sg13cmos5l_decap_8
X_1078_ _1217_/B _1390_/B _1078_/B vccd vssd sg13cmos5l_nor2_1
XFILLER_40_329 vccd vssd sg13cmos5l_decap_8
XFILLER_33_2323 vccd vssd sg13cmos5l_decap_8
XFILLER_37_1780 vccd vssd sg13cmos5l_decap_8
XFILLER_33_1611 vccd vssd sg13cmos5l_decap_8
XFILLER_33_392 vccd vssd sg13cmos5l_decap_8
XFILLER_21_532 vccd vssd sg13cmos5l_decap_8
XFILLER_18_1190 vccd vssd sg13cmos5l_decap_8
XFILLER_33_1677 vccd vssd sg13cmos5l_decap_8
XFILLER_14_1043 vccd vssd sg13cmos5l_decap_8
XFILLER_11_1953 vccd vssd sg13cmos5l_decap_8
XFILLER_11_2676 vccd vssd sg13cmos5l_decap_8
XFILLER_20_35 vccd vssd sg13cmos5l_decap_8
XFILLER_1_959 vccd vssd sg13cmos5l_decap_8
XFILLER_44_2485 vccd vssd sg13cmos5l_decap_8
XFILLER_27_1448 vccd vssd sg13cmos5l_decap_8
XFILLER_0_469 vccd vssd sg13cmos5l_decap_8
XFILLER_40_2338 vccd vssd sg13cmos5l_decap_8
XFILLER_29_77 vccd vssd sg13cmos5l_decap_8
XFILLER_25_1161 vccd vssd sg13cmos5l_decap_8
XFILLER_5_1211 vccd vssd sg13cmos5l_decap_8
XFILLER_29_632 vccd vssd sg13cmos5l_decap_8
XFILLER_21_1036 vccd vssd sg13cmos5l_decap_8
XFILLER_17_805 vccd vssd sg13cmos5l_decap_8
XFILLER_45_21 vccd vssd sg13cmos5l_decap_8
XFILLER_44_613 vccd vssd sg13cmos5l_decap_8
XFILLER_28_175 vccd vssd sg13cmos5l_decap_8
XFILLER_16_315 vccd vssd sg13cmos5l_decap_8
XFILLER_5_1288 vccd vssd sg13cmos5l_decap_8
XFILLER_45_98 vccd vssd sg13cmos5l_decap_8
XFILLER_25_871 vccd vssd sg13cmos5l_decap_8
XFILLER_0_2590 vccd vssd sg13cmos5l_decap_8
XFILLER_31_329 vccd vssd sg13cmos5l_decap_8
XFILLER_40_852 vccd vssd sg13cmos5l_decap_8
XFILLER_24_392 vccd vssd sg13cmos5l_decap_8
XFILLER_16_1820 vccd vssd sg13cmos5l_decap_8
XFILLER_12_532 vccd vssd sg13cmos5l_decap_8
XFILLER_40_885 vccd vssd sg13cmos5l_decap_8
XFILLER_8_525 vccd vssd sg13cmos5l_decap_8
Xtiedowns\[77\] status[77] vccd vssd sg13cmos5l_antennanp
XANTENNA_8 RSTB vccd vssd sg13cmos5l_antennanp
XFILLER_10_2142 vccd vssd sg13cmos5l_decap_8
XFILLER_45_2205 vccd vssd sg13cmos5l_decap_8
XFILLER_4_742 vccd vssd sg13cmos5l_decap_8
XFILLER_3_252 vccd vssd sg13cmos5l_decap_8
XFILLER_10_1463 vccd vssd sg13cmos5l_decap_8
XFILLER_45_1526 vccd vssd sg13cmos5l_decap_8
XFILLER_7_2722 vccd vssd sg13cmos5l_decap_8
XFILLER_27_2672 vccd vssd sg13cmos5l_decap_8
XFILLER_27_1960 vccd vssd sg13cmos5l_decap_8
XFILLER_23_2536 vccd vssd sg13cmos5l_decap_8
XFILLER_6_1008 vccd vssd sg13cmos5l_decap_8
XFILLER_20_7 vccd vssd sg13cmos5l_decap_8
XFILLER_43_1272 vccd vssd sg13cmos5l_decap_4
XFILLER_3_1918 vccd vssd sg13cmos5l_decap_8
XFILLER_1_2310 vccd vssd sg13cmos5l_decap_8
X_1001_ _1001_/Y _1029_/A _1045_/A _1046_/B vccd vssd sg13cmos5l_nor3_1
XFILLER_35_613 vccd vssd sg13cmos5l_decap_8
XFILLER_21_2271 vccd vssd sg13cmos5l_decap_8
XFILLER_34_112 vccd vssd sg13cmos5l_decap_8
XFILLER_19_175 vccd vssd sg13cmos5l_decap_8
XFILLER_1_2387 vccd vssd sg13cmos5l_decap_8
XFILLER_1_1631 vccd vssd sg13cmos5l_decap_8
XFILLER_23_819 vccd vssd sg13cmos5l_decap_8
XFILLER_21_1592 vccd vssd sg13cmos5l_decap_8
XFILLER_34_189 vccd vssd sg13cmos5l_decap_8
XFILLER_31_830 vccd vssd sg13cmos5l_decap_8
XFILLER_22_329 vccd vssd sg13cmos5l_decap_8
XFILLER_17_1617 vccd vssd sg13cmos5l_decap_8
XFILLER_16_882 vccd vssd sg13cmos5l_decap_8
XFILLER_34_2665 vccd vssd sg13cmos5l_decap_8
XFILLER_15_392 vccd vssd sg13cmos5l_decap_8
XFILLER_37_1098 vccd vssd sg13cmos5l_decap_8
XFILLER_15_1330 vccd vssd sg13cmos5l_decap_8
XFILLER_34_1986 vccd vssd sg13cmos5l_decap_8
XFILLER_34_1975 vccd vssd sg13cmos5l_decap_8
XFILLER_30_1817 vccd vssd sg13cmos5l_decap_8
XFILLER_30_1806 vccd vssd sg13cmos5l_decap_4
XFILLER_15_2086 vccd vssd sg13cmos5l_decap_8
X_1765_ _1765_/Q clkload8/A _1765_/D fanout118/X vccd vssd sg13cmos5l_dfrbpq_1
Xhold514 _1792_/D _1594_/X vccd vssd sg13cmos5l_dlygate4sd3_1
XFILLER_28_2403 vccd vssd sg13cmos5l_decap_8
Xhold503 _1773_/D _1571_/X vccd vssd sg13cmos5l_dlygate4sd3_1
Xhold525 hold525/X _1649_/Q vccd vssd sg13cmos5l_dlygate4sd3_1
Xhold536 hold536/X _1660_/Q vccd vssd sg13cmos5l_dlygate4sd3_1
X_1696_ _1696_/Q _1711_/CLK _1696_/D _1638_/B_N vccd vssd sg13cmos5l_dfrbpq_1
XFILLER_28_2436 vccd vssd sg13cmos5l_decap_8
Xoutbuffers\[60\] control[60] _1728_/Q vccd vssd sg13cmos5l_buf_8
XFILLER_28_1735 vccd vssd sg13cmos5l_decap_8
XFILLER_45_2772 vccd vssd sg13cmos5l_decap_8
XFILLER_44_1014 vccd vssd sg13cmos5l_decap_8
XFILLER_41_2614 vccd vssd sg13cmos5l_decap_8
XFILLER_39_930 vccd vssd sg13cmos5l_decap_8
XFILLER_22_1301 vccd vssd sg13cmos5l_decap_8
XFILLER_2_2107 vccd vssd sg13cmos5l_decap_8
XFILLER_6_2254 vccd vssd sg13cmos5l_decap_8
XFILLER_41_1957 vccd vssd sg13cmos5l_decap_8
XFILLER_39_963 vccd vssd sg13cmos5l_decap_8
XFILLER_6_1575 vccd vssd sg13cmos5l_decap_8
XFILLER_2_1428 vccd vssd sg13cmos5l_decap_8
XFILLER_39_2521 vccd vssd sg13cmos5l_decap_8
XFILLER_38_495 vccd vssd sg13cmos5l_decap_8
XFILLER_26_657 vccd vssd sg13cmos5l_decap_8
XFILLER_25_112 vccd vssd sg13cmos5l_decap_8
XFILLER_0_1141 vccd vssd sg13cmos5l_decap_8
XFILLER_14_819 vccd vssd sg13cmos5l_decap_8
XFILLER_41_649 vccd vssd sg13cmos5l_decap_8
XFILLER_39_2598 vccd vssd sg13cmos5l_decap_8
XFILLER_39_1853 vccd vssd sg13cmos5l_decap_8
XFILLER_40_126 vccd vssd sg13cmos5l_decap_8
XFILLER_35_1706 vccd vssd sg13cmos5l_decap_8
XFILLER_25_189 vccd vssd sg13cmos5l_decap_8
XFILLER_13_329 vccd vssd sg13cmos5l_decap_8
XFILLER_15_35 vccd vssd sg13cmos5l_decap_8
XFILLER_22_896 vccd vssd sg13cmos5l_decap_8
XFILLER_16_1127 vccd vssd sg13cmos5l_decap_8
XFILLER_33_2197 vccd vssd sg13cmos5l_decap_8
XFILLER_33_1452 vccd vssd sg13cmos5l_decap_8
XFILLER_31_56 vccd vssd sg13cmos5l_decap_8
XFILLER_5_539 vccd vssd sg13cmos5l_decap_8
XFILLER_11_1750 vccd vssd sg13cmos5l_decap_8
XFILLER_40_2102 vccd vssd sg13cmos5l_decap_8
XFILLER_27_1234 vccd vssd sg13cmos5l_decap_8
XFILLER_1_756 vccd vssd sg13cmos5l_decap_8
XFILLER_44_2271 vccd vssd sg13cmos5l_decap_8
XFILLER_20_2709 vccd vssd sg13cmos5l_decap_8
XFILLER_0_266 vccd vssd sg13cmos5l_decap_8
XFILLER_44_1581 vccd vssd sg13cmos5l_decap_8
XFILLER_40_1423 vccd vssd sg13cmos5l_decap_8
XFILLER_40_2179 vccd vssd sg13cmos5l_decap_8
XFILLER_29_462 vccd vssd sg13cmos5l_decap_4
XFILLER_17_602 vccd vssd sg13cmos5l_decap_8
XFILLER_16_112 vccd vssd sg13cmos5l_decap_8
XFILLER_2_2674 vccd vssd sg13cmos5l_decap_8
XFILLER_5_1085 vccd vssd sg13cmos5l_decap_8
XFILLER_45_966 vccd vssd sg13cmos5l_decap_8
XFILLER_44_454 vccd vssd sg13cmos5l_decap_8
XFILLER_38_2042 vccd vssd sg13cmos5l_decap_8
XFILLER_18_2627 vccd vssd sg13cmos5l_decap_8
XFILLER_17_679 vccd vssd sg13cmos5l_decap_8
XFILLER_2_1995 vccd vssd sg13cmos5l_decap_8
XFILLER_38_2086 vccd vssd sg13cmos5l_decap_8
XFILLER_32_616 vccd vssd sg13cmos5l_decap_8
XFILLER_18_2638 vccd vssd sg13cmos5l_decap_8
XFILLER_16_189 vccd vssd sg13cmos5l_decap_8
XFILLER_31_126 vccd vssd sg13cmos5l_decap_8
XFILLER_34_1227 vccd vssd sg13cmos5l_decap_4
XFILLER_9_812 vccd vssd sg13cmos5l_decap_8
XFILLER_12_2215 vccd vssd sg13cmos5l_decap_8
XFILLER_13_896 vccd vssd sg13cmos5l_decap_8
XFILLER_16_2395 vccd vssd sg13cmos5l_decap_8
XFILLER_8_322 vccd vssd sg13cmos5l_decap_8
XFILLER_16_1694 vccd vssd sg13cmos5l_decap_8
XFILLER_9_889 vccd vssd sg13cmos5l_decap_8
XFILLER_12_1547 vccd vssd sg13cmos5l_decap_8
X_1550_ _1550_/X _1562_/A hold324/X _1555_/S vccd vssd sg13cmos5l_mux2_1
XFILLER_8_399 vccd vssd sg13cmos5l_decap_8
XFILLER_45_2002 vccd vssd sg13cmos5l_decap_8
XFILLER_29_2734 vccd vssd sg13cmos5l_decap_8
XFILLER_10_1260 vccd vssd sg13cmos5l_decap_8
X_1481_ _1481_/Y _1481_/A _1485_/S vccd vssd sg13cmos5l_nor2_1
XFILLER_45_2079 vccd vssd sg13cmos5l_decap_8
XFILLER_45_1323 vccd vssd sg13cmos5l_decap_8
XFILLER_25_1919 vccd vssd sg13cmos5l_decap_8
XFILLER_7_2541 vccd vssd sg13cmos5l_decap_8
XFILLER_7_2574 vccd vssd sg13cmos5l_decap_8
XFILLER_39_259 vccd vssd sg13cmos5l_decap_8
XFILLER_23_1643 vccd vssd sg13cmos5l_decap_8
XFILLER_7_1862 vccd vssd sg13cmos5l_decap_8
XFILLER_40_2680 vccd vssd sg13cmos5l_decap_8
XFILLER_3_1715 vccd vssd sg13cmos5l_decap_8
XFILLER_40_1990 vccd vssd sg13cmos5l_decap_8
XFILLER_39_1105 vccd vssd sg13cmos5l_decap_4
XFILLER_36_988 vccd vssd sg13cmos5l_decap_8
XFILLER_1_2184 vccd vssd sg13cmos5l_decap_8
XFILLER_36_2749 vccd vssd sg13cmos5l_decap_8
XFILLER_23_616 vccd vssd sg13cmos5l_decap_8
XFILLER_17_2137 vccd vssd sg13cmos5l_decap_8
XFILLER_22_126 vccd vssd sg13cmos5l_decap_8
XFILLER_17_1414 vccd vssd sg13cmos5l_decap_8
Xoutbuffers\[4\] control[4] _1672_/Q vccd vssd sg13cmos5l_buf_8
XFILLER_30_1603 vccd vssd sg13cmos5l_decap_8
Xhold300 hold300/X _1693_/Q vccd vssd sg13cmos5l_dlygate4sd3_1
Xhold311 _1696_/D _1459_/X vccd vssd sg13cmos5l_dlygate4sd3_1
XFILLER_7_91 vccd vssd sg13cmos5l_decap_8
XFILLER_12_2782 vccd vssd sg13cmos5l_decap_8
Xhold322 hold322/X _1727_/Q vccd vssd sg13cmos5l_dlygate4sd3_1
Xhold333 _1695_/D _1458_/X vccd vssd sg13cmos5l_dlygate4sd3_1
Xhold344 hold344/X _1694_/Q vccd vssd sg13cmos5l_dlygate4sd3_1
X_1748_ _1748_/Q clkload2/A _1748_/D fanout121/X vccd vssd sg13cmos5l_dfrbpq_1
XFILLER_11_1057 vccd vssd sg13cmos5l_decap_8
X_1679_ _1679_/Q clkload9/A _1679_/D fanout139/X vccd vssd sg13cmos5l_dfrbpq_1
Xhold355 _1717_/D _1489_/X vccd vssd sg13cmos5l_dlygate4sd3_1
Xhold366 _1682_/D _1437_/X vccd vssd sg13cmos5l_dlygate4sd3_1
Xhold377 hold377/X _1680_/Q vccd vssd sg13cmos5l_dlygate4sd3_1
XFILLER_28_2266 vccd vssd sg13cmos5l_decap_4
Xhold388 hold388/X _0854_/Y vccd vssd sg13cmos5l_dlygate4sd3_1
XFILLER_28_1543 vccd vssd sg13cmos5l_decap_4
Xhold399 _0927_/A _0924_/Y vccd vssd sg13cmos5l_dlygate4sd3_1
XFILLER_8_2338 vccd vssd sg13cmos5l_decap_8
XFILLER_41_2422 vccd vssd sg13cmos5l_decap_8
XFILLER_6_2051 vccd vssd sg13cmos5l_decap_8
XFILLER_8_1659 vccd vssd sg13cmos5l_decap_8
XFILLER_45_1890 vccd vssd sg13cmos5l_decap_8
XFILLER_41_2488 vccd vssd sg13cmos5l_decap_8
XFILLER_41_1754 vccd vssd sg13cmos5l_decap_8
XFILLER_22_1120 vccd vssd sg13cmos5l_decap_8
XFILLER_6_1372 vccd vssd sg13cmos5l_decap_8
XFILLER_27_944 vccd vssd sg13cmos5l_decap_8
XFILLER_2_1225 vccd vssd sg13cmos5l_decap_8
XFILLER_26_56 vccd vssd sg13cmos5l_decap_8
XFILLER_22_1197 vccd vssd sg13cmos5l_decap_8
XFILLER_26_476 vccd vssd sg13cmos5l_decap_8
XFILLER_14_616 vccd vssd sg13cmos5l_decap_8
XFILLER_41_435 vccd vssd sg13cmos5l_decap_8
XFILLER_39_1672 vccd vssd sg13cmos5l_decap_8
XFILLER_35_1503 vccd vssd sg13cmos5l_decap_8
XFILLER_13_126 vccd vssd sg13cmos5l_decap_8
XFILLER_17_2671 vccd vssd sg13cmos5l_decap_8
XFILLER_9_119 vccd vssd sg13cmos5l_decap_8
XFILLER_13_2524 vccd vssd sg13cmos5l_decap_8
XFILLER_42_77 vccd vssd sg13cmos5l_decap_8
XFILLER_22_693 vccd vssd sg13cmos5l_decap_8
XFILLER_10_833 vccd vssd sg13cmos5l_decap_8
XFILLER_6_826 vccd vssd sg13cmos5l_decap_8
XFILLER_13_1834 vccd vssd sg13cmos5l_decap_8
XFILLER_5_336 vccd vssd sg13cmos5l_decap_8
XFILLER_11_2270 vccd vssd sg13cmos5l_decap_8
XFILLER_29_1307 vccd vssd sg13cmos5l_decap_8
XFILLER_42_2219 vccd vssd sg13cmos5l_decap_8
XFILLER_1_553 vccd vssd sg13cmos5l_decap_8
XFILLER_27_1031 vccd vssd sg13cmos5l_decap_8
XFILLER_3_49 vccd vssd sg13cmos5l_decap_8
XFILLER_27_1075 vccd vssd sg13cmos5l_decap_4
XFILLER_24_2664 vccd vssd sg13cmos5l_decap_8
XFILLER_24_1930 vccd vssd sg13cmos5l_decap_8
XFILLER_20_2506 vccd vssd sg13cmos5l_decap_8
XFILLER_7_1169 vccd vssd sg13cmos5l_decap_8
XFILLER_37_719 vccd vssd sg13cmos5l_decap_8
XFILLER_4_2769 vccd vssd sg13cmos5l_decap_8
XFILLER_2_2471 vccd vssd sg13cmos5l_decap_8
XFILLER_45_763 vccd vssd sg13cmos5l_decap_8
XFILLER_18_966 vccd vssd sg13cmos5l_decap_8
XFILLER_44_262 vccd vssd sg13cmos5l_decap_8
XFILLER_32_413 vccd vssd sg13cmos5l_decap_8
XFILLER_18_2413 vccd vssd sg13cmos5l_decap_8
XFILLER_17_476 vccd vssd sg13cmos5l_decap_8
XFILLER_2_1792 vccd vssd sg13cmos5l_decap_8
XFILLER_18_1701 vccd vssd sg13cmos5l_decap_8
X_0981_ wire78/A _1046_/A _1070_/A _0981_/C _0988_/C vccd vssd sg13cmos5l_nor4_2
XFILLER_40_490 vccd vssd sg13cmos5l_decap_8
XFILLER_34_1046 vccd vssd sg13cmos5l_decap_8
XFILLER_18_1778 vccd vssd sg13cmos5l_decap_8
XFILLER_16_2181 vccd vssd sg13cmos5l_decap_8
XFILLER_12_2023 vccd vssd sg13cmos5l_decap_8
XFILLER_13_693 vccd vssd sg13cmos5l_decap_8
XFILLER_31_2668 vccd vssd sg13cmos5l_decap_8
XFILLER_16_1491 vccd vssd sg13cmos5l_decap_8
XFILLER_9_686 vccd vssd sg13cmos5l_decap_8
XFILLER_31_1956 vccd vssd sg13cmos5l_decap_8
XFILLER_8_196 vccd vssd sg13cmos5l_decap_8
XFILLER_12_1344 vccd vssd sg13cmos5l_decap_8
X_1602_ _1602_/Y _1605_/A _1603_/B_N vccd vssd sg13cmos5l_nor2b_1
X_1533_ _1748_/D _1590_/A1 _1541_/S hold254/X vccd vssd sg13cmos5l_o21ai_1
XFILLER_45_1120 vccd vssd sg13cmos5l_decap_8
X_1464_ _1464_/Y _1464_/A _1471_/S vccd vssd sg13cmos5l_nand2_1
Xfanout109 _1401_/A _1547_/A vccd vssd sg13cmos5l_buf_1
XFILLER_42_2720 vccd vssd sg13cmos5l_decap_8
XFILLER_29_1896 vccd vssd sg13cmos5l_decap_8
XFILLER_9_1946 vccd vssd sg13cmos5l_decap_8
X_1395_ _1395_/X _1495_/A _1472_/A _1401_/B vccd vssd sg13cmos5l_mux2_1
XFILLER_23_2141 vccd vssd sg13cmos5l_decap_8
XFILLER_45_1197 vccd vssd sg13cmos5l_decap_8
XFILLER_3_1512 vccd vssd sg13cmos5l_decap_8
XFILLER_36_730 vccd vssd sg13cmos5l_decap_8
XFILLER_3_2268 vccd vssd sg13cmos5l_decap_8
Xoutbuffers\[23\] control[23] _1691_/Q vccd vssd sg13cmos5l_buf_8
XFILLER_36_741 vccd vssd sg13cmos5l_decap_8
XFILLER_24_903 vccd vssd sg13cmos5l_decap_8
XFILLER_3_1589 vccd vssd sg13cmos5l_decap_8
XFILLER_35_273 vccd vssd sg13cmos5l_decap_8
XFILLER_23_413 vccd vssd sg13cmos5l_decap_8
XFILLER_36_2546 vccd vssd sg13cmos5l_decap_8
XFILLER_36_1801 vccd vssd sg13cmos5l_decap_8
XFILLER_17_1211 vccd vssd sg13cmos5l_decap_8
XFILLER_17_1288 vccd vssd sg13cmos5l_decap_8
XFILLER_12_14 vccd vssd sg13cmos5l_decap_8
XFILLER_30_1433 vccd vssd sg13cmos5l_decap_8
XFILLER_28_2052 vccd vssd sg13cmos5l_decap_8
Xhold185 _0914_/B _0913_/Y vccd vssd sg13cmos5l_dlygate4sd3_1
XFILLER_8_2135 vccd vssd sg13cmos5l_decap_8
Xhold174 _0900_/B _1646_/Q vccd vssd sg13cmos5l_dlygate4sd3_1
XFILLER_28_1351 vccd vssd sg13cmos5l_decap_4
Xhold196 _0898_/A hold515/X vccd vssd sg13cmos5l_dlygate4sd3_1
XFILLER_41_2230 vccd vssd sg13cmos5l_decap_8
XFILLER_8_1456 vccd vssd sg13cmos5l_decap_8
XFILLER_4_1309 vccd vssd sg13cmos5l_decap_8
XFILLER_2_1022 vccd vssd sg13cmos5l_decap_8
XFILLER_41_1595 vccd vssd sg13cmos5l_decap_8
XFILLER_37_77 vccd vssd sg13cmos5l_decap_8
XFILLER_27_763 vccd vssd sg13cmos5l_decap_8
XFILLER_15_903 vccd vssd sg13cmos5l_decap_8
XFILLER_26_273 vccd vssd sg13cmos5l_decap_8
XFILLER_2_1099 vccd vssd sg13cmos5l_decap_8
XFILLER_14_413 vccd vssd sg13cmos5l_decap_8
XFILLER_41_210 vccd vssd sg13cmos5l_decap_8
XFILLER_19_2755 vccd vssd sg13cmos5l_decap_8
XFILLER_18_1008 vccd vssd sg13cmos5l_decap_8
XFILLER_30_917 vccd vssd sg13cmos5l_decap_8
XFILLER_41_298 vccd vssd sg13cmos5l_decap_8
XFILLER_35_1333 vccd vssd sg13cmos5l_decap_8
XFILLER_23_980 vccd vssd sg13cmos5l_decap_8
XFILLER_17_2490 vccd vssd sg13cmos5l_decap_8
XFILLER_15_1918 vccd vssd sg13cmos5l_decap_8
XFILLER_13_2321 vccd vssd sg13cmos5l_decap_8
XFILLER_22_490 vccd vssd sg13cmos5l_decap_8
XFILLER_10_630 vccd vssd sg13cmos5l_decap_8
XFILLER_6_623 vccd vssd sg13cmos5l_decap_8
XFILLER_13_1631 vccd vssd sg13cmos5l_decap_8
XFILLER_13_2398 vccd vssd sg13cmos5l_decap_8
XFILLER_5_133 vccd vssd sg13cmos5l_decap_8
XFILLER_26_2726 vccd vssd sg13cmos5l_decap_8
XFILLER_2_840 vccd vssd sg13cmos5l_decap_8
XFILLER_1_350 vccd vssd sg13cmos5l_decap_8
XFILLER_24_2450 vccd vssd sg13cmos5l_decap_8
X_1180_ _1183_/B status[84] _1359_/A2 _1225_/B status[76] vccd vssd sg13cmos5l_a22oi_1
XFILLER_42_1337 vccd vssd sg13cmos5l_decap_8
XFILLER_20_2325 vccd vssd sg13cmos5l_decap_8
XFILLER_4_2555 vccd vssd sg13cmos5l_decap_8
XFILLER_37_538 vccd vssd sg13cmos5l_decap_8
XFILLER_0_2408 vccd vssd sg13cmos5l_decap_8
XFILLER_18_763 vccd vssd sg13cmos5l_decap_8
XFILLER_0_1729 vccd vssd sg13cmos5l_decap_8
XFILLER_4_1876 vccd vssd sg13cmos5l_decap_8
XFILLER_45_560 vccd vssd sg13cmos5l_decap_8
XFILLER_40_1094 vccd vssd sg13cmos5l_decap_8
XFILLER_33_722 vccd vssd sg13cmos5l_decap_8
XFILLER_20_1668 vccd vssd sg13cmos5l_decap_8
XFILLER_17_273 vccd vssd sg13cmos5l_decap_8
XFILLER_32_210 vccd vssd sg13cmos5l_decap_8
XFILLER_18_2243 vccd vssd sg13cmos5l_decap_8
Xoutbuffers\[113\] control[113] _1781_/Q vccd vssd sg13cmos5l_buf_8
XFILLER_21_917 vccd vssd sg13cmos5l_decap_8
XFILLER_14_2107 vccd vssd sg13cmos5l_decap_8
XFILLER_32_287 vccd vssd sg13cmos5l_decap_8
XFILLER_31_2410 vccd vssd sg13cmos5l_decap_8
XFILLER_20_427 vccd vssd sg13cmos5l_decap_8
XFILLER_18_1575 vccd vssd sg13cmos5l_decap_8
XFILLER_14_980 vccd vssd sg13cmos5l_decap_8
X_0964_ _1009_/A _0997_/A _0997_/B vccd vssd sg13cmos5l_nand2b_1
XFILLER_13_490 vccd vssd sg13cmos5l_decap_8
XFILLER_14_1428 vccd vssd sg13cmos5l_decap_8
XFILLER_31_1720 vccd vssd sg13cmos5l_decap_8
X_0895_ _0895_/Y _0898_/B _0895_/B vccd vssd sg13cmos5l_xnor2_1
XFILLER_9_483 vccd vssd sg13cmos5l_decap_8
XFILLER_12_1141 vccd vssd sg13cmos5l_decap_8
XFILLER_31_1797 vccd vssd sg13cmos5l_decap_8
X_1516_ _1516_/X _1504_/A hold435/X _1518_/S vccd vssd sg13cmos5l_mux2_1
XFILLER_9_2422 vccd vssd sg13cmos5l_decap_8
XFILLER_4_70 vccd vssd sg13cmos5l_decap_8
X_1447_ _1447_/X hold520/X hold396/X _1449_/B vccd vssd sg13cmos5l_mux2_1
XFILLER_9_1743 vccd vssd sg13cmos5l_decap_8
XFILLER_9_2499 vccd vssd sg13cmos5l_decap_8
X_1378_ _1378_/Y _1700_/Q _1463_/B _1164_/B vccd vssd sg13cmos5l_a21oi_1
XFILLER_3_2065 vccd vssd sg13cmos5l_decap_8
XFILLER_24_700 vccd vssd sg13cmos5l_decap_8
XFILLER_3_1386 vccd vssd sg13cmos5l_decap_8
XFILLER_38_1929 vccd vssd sg13cmos5l_decap_8
XFILLER_36_2321 vccd vssd sg13cmos5l_decap_8
XFILLER_36_593 vccd vssd sg13cmos5l_decap_8
XFILLER_23_210 vccd vssd sg13cmos5l_decap_8
XFILLER_24_777 vccd vssd sg13cmos5l_decap_8
XFILLER_12_917 vccd vssd sg13cmos5l_decap_8
XFILLER_36_2398 vccd vssd sg13cmos5l_decap_8
XFILLER_36_1664 vccd vssd sg13cmos5l_decap_4
XFILLER_23_287 vccd vssd sg13cmos5l_decap_8
XFILLER_23_35 vccd vssd sg13cmos5l_decap_8
XFILLER_11_427 vccd vssd sg13cmos5l_decap_8
XFILLER_17_1085 vccd vssd sg13cmos5l_decap_8
XFILLER_20_994 vccd vssd sg13cmos5l_decap_8
XFILLER_14_2685 vccd vssd sg13cmos5l_decap_8
XFILLER_30_1252 vccd vssd sg13cmos5l_decap_8
XFILLER_14_1995 vccd vssd sg13cmos5l_decap_8
XFILLER_3_637 vccd vssd sg13cmos5l_decap_8
XFILLER_10_1848 vccd vssd sg13cmos5l_decap_8
XFILLER_2_147 vccd vssd sg13cmos5l_decap_8
XFILLER_24_1001 vccd vssd sg13cmos5l_decap_8
XFILLER_43_1646 vccd vssd sg13cmos5l_decap_8
XFILLER_25_2770 vccd vssd sg13cmos5l_decap_8
XFILLER_21_2601 vccd vssd sg13cmos5l_decap_8
XFILLER_4_1106 vccd vssd sg13cmos5l_decap_8
XFILLER_8_1253 vccd vssd sg13cmos5l_decap_8
XFILLER_24_1067 vccd vssd sg13cmos5l_decap_8
XFILLER_21_1911 vccd vssd sg13cmos5l_decap_8
XFILLER_21_2678 vccd vssd sg13cmos5l_decap_8
XFILLER_0_28 vccd vssd sg13cmos5l_decap_8
XFILLER_15_700 vccd vssd sg13cmos5l_decap_8
XFILLER_37_1406 vccd vssd sg13cmos5l_decap_8
XFILLER_14_210 vccd vssd sg13cmos5l_decap_8
XFILLER_15_2416 vccd vssd sg13cmos5l_decap_8
XFILLER_15_777 vccd vssd sg13cmos5l_decap_8
XFILLER_30_736 vccd vssd sg13cmos5l_decap_8
XFILLER_15_1715 vccd vssd sg13cmos5l_decap_8
XFILLER_14_287 vccd vssd sg13cmos5l_decap_8
Xfanout80 _1359_/A2 _0979_/Y vccd vssd sg13cmos5l_buf_1
XFILLER_32_2763 vccd vssd sg13cmos5l_decap_8
Xfanout91 _0957_/S fanout93/X vccd vssd sg13cmos5l_buf_8
XFILLER_19_1895 vccd vssd sg13cmos5l_decap_8
XFILLER_7_910 vccd vssd sg13cmos5l_decap_8
XFILLER_31_1016 vccd vssd sg13cmos5l_decap_8
XFILLER_6_420 vccd vssd sg13cmos5l_decap_8
XFILLER_11_994 vccd vssd sg13cmos5l_decap_8
XFILLER_13_2195 vccd vssd sg13cmos5l_decap_8
XFILLER_7_987 vccd vssd sg13cmos5l_decap_8
XFILLER_6_497 vccd vssd sg13cmos5l_decap_8
XFILLER_26_2534 vccd vssd sg13cmos5l_decap_8
X_1301_ _1301_/Y _0850_/Y _1066_/X _1299_/Y _1300_/Y vccd vssd sg13cmos5l_a22oi_1
X_1232_ _1235_/B status[19] _1232_/B vccd vssd sg13cmos5l_nand2_1
XFILLER_38_814 vccd vssd sg13cmos5l_decap_8
XFILLER_0_2205 vccd vssd sg13cmos5l_decap_8
XFILLER_4_2352 vccd vssd sg13cmos5l_decap_8
XFILLER_37_357 vccd vssd sg13cmos5l_decap_8
X_1163_ _1163_/X _1161_/Y _1162_/Y _1164_/B vccd vssd sg13cmos5l_a21o_2
XFILLER_20_1421 vccd vssd sg13cmos5l_decap_8
X_1094_ _1094_/Y status[54] _1268_/B1 _1317_/B1 vccd vssd sg13cmos5l_a21oi_1
Xtiedowns\[103\] status[103] vccd vssd sg13cmos5l_antennanp
XFILLER_20_2199 vccd vssd sg13cmos5l_decap_4
XFILLER_20_1465 vccd vssd sg13cmos5l_decap_8
XFILLER_18_560 vccd vssd sg13cmos5l_decap_8
XFILLER_0_1526 vccd vssd sg13cmos5l_decap_8
XFILLER_4_1673 vccd vssd sg13cmos5l_decap_8
XFILLER_37_2674 vccd vssd sg13cmos5l_decap_8
XFILLER_33_563 vccd vssd sg13cmos5l_decap_8
XFILLER_21_714 vccd vssd sg13cmos5l_decap_8
XFILLER_33_2538 vccd vssd sg13cmos5l_decap_8
XFILLER_20_224 vccd vssd sg13cmos5l_decap_8
XFILLER_18_2095 vccd vssd sg13cmos5l_decap_8
XFILLER_18_1372 vccd vssd sg13cmos5l_decap_8
X_0947_ _0971_/A _1801_/Q _1800_/Q _0947_/S vccd vssd sg13cmos5l_mux2_1
XFILLER_14_1225 vccd vssd sg13cmos5l_decap_8
Xoutbuffers\[90\] control[90] _1758_/Q vccd vssd sg13cmos5l_buf_8
XFILLER_9_280 vccd vssd sg13cmos5l_decap_8
X_0878_ _0878_/Y status[55] vccd vssd sg13cmos5l_inv_1
XFILLER_29_2180 vccd vssd sg13cmos5l_decap_8
XFILLER_44_2667 vccd vssd sg13cmos5l_decap_8
XFILLER_44_1933 vccd vssd sg13cmos5l_decap_8
XFILLER_29_2191 vccd vssd sg13cmos5l_decap_8
XFILLER_9_1540 vccd vssd sg13cmos5l_decap_8
XFILLER_5_2149 vccd vssd sg13cmos5l_decap_8
XFILLER_9_2296 vccd vssd sg13cmos5l_decap_8
XFILLER_44_1977 vccd vssd sg13cmos5l_decap_8
XFILLER_42_2391 vccd vssd sg13cmos5l_decap_8
XFILLER_25_1376 vccd vssd sg13cmos5l_decap_8
XFILLER_18_35 vccd vssd sg13cmos5l_decap_8
XFILLER_28_357 vccd vssd sg13cmos5l_decap_8
XFILLER_44_828 vccd vssd sg13cmos5l_decap_8
XFILLER_37_880 vccd vssd sg13cmos5l_decap_8
XFILLER_3_1183 vccd vssd sg13cmos5l_decap_8
XFILLER_0_2772 vccd vssd sg13cmos5l_decap_8
XFILLER_38_1726 vccd vssd sg13cmos5l_decap_8
XFILLER_36_2151 vccd vssd sg13cmos5l_decap_8
XFILLER_34_56 vccd vssd sg13cmos5l_decap_8
XFILLER_24_574 vccd vssd sg13cmos5l_decap_8
XFILLER_19_1169 vccd vssd sg13cmos5l_decap_8
XFILLER_12_714 vccd vssd sg13cmos5l_decap_8
XFILLER_32_1314 vccd vssd sg13cmos5l_decap_8
XFILLER_16_2769 vccd vssd sg13cmos5l_decap_8
XFILLER_8_707 vccd vssd sg13cmos5l_decap_8
XFILLER_11_224 vccd vssd sg13cmos5l_decap_8
Xclkload0 clkload0/Y clkload0/A vccd vssd sg13cmos5l_inv_1
XFILLER_7_217 vccd vssd sg13cmos5l_decap_8
XFILLER_20_791 vccd vssd sg13cmos5l_decap_8
XFILLER_10_2324 vccd vssd sg13cmos5l_decap_8
XFILLER_4_924 vccd vssd sg13cmos5l_decap_8
XFILLER_10_1645 vccd vssd sg13cmos5l_decap_8
XFILLER_14_1792 vccd vssd sg13cmos5l_decap_8
XFILLER_30_1082 vccd vssd sg13cmos5l_decap_8
XFILLER_3_434 vccd vssd sg13cmos5l_decap_8
XFILLER_45_1708 vccd vssd sg13cmos5l_decap_8
XFILLER_23_2718 vccd vssd sg13cmos5l_decap_8
XFILLER_43_2177 vccd vssd sg13cmos5l_decap_8
XFILLER_43_1432 vccd vssd sg13cmos5l_decap_8
XFILLER_8_1050 vccd vssd sg13cmos5l_decap_8
Xtiedowns\[22\] status[22] vccd vssd sg13cmos5l_antennanp
XFILLER_5_2661 vccd vssd sg13cmos5l_decap_8
XFILLER_21_2475 vccd vssd sg13cmos5l_decap_8
XFILLER_19_357 vccd vssd sg13cmos5l_decap_8
XFILLER_5_1960 vccd vssd sg13cmos5l_decap_8
XFILLER_1_2569 vccd vssd sg13cmos5l_decap_8
XFILLER_1_1813 vccd vssd sg13cmos5l_decap_8
XFILLER_21_1796 vccd vssd sg13cmos5l_decap_8
XFILLER_15_2224 vccd vssd sg13cmos5l_decap_8
XFILLER_15_574 vccd vssd sg13cmos5l_decap_8
XFILLER_37_1269 vccd vssd sg13cmos5l_decap_8
XFILLER_15_1512 vccd vssd sg13cmos5l_decap_8
X_1781_ _1781_/Q _1795_/CLK _1781_/D fanout115/X vccd vssd sg13cmos5l_dfrbpq_1
XFILLER_32_2560 vccd vssd sg13cmos5l_decap_8
XFILLER_15_1589 vccd vssd sg13cmos5l_decap_8
XFILLER_11_791 vccd vssd sg13cmos5l_decap_8
XFILLER_32_1892 vccd vssd sg13cmos5l_decap_8
XFILLER_7_784 vccd vssd sg13cmos5l_decap_8
XFILLER_6_294 vccd vssd sg13cmos5l_decap_8
XFILLER_28_1917 vccd vssd sg13cmos5l_decap_8
XFILLER_26_2364 vccd vssd sg13cmos5l_decap_4
XFILLER_22_2228 vccd vssd sg13cmos5l_decap_8
XFILLER_6_2436 vccd vssd sg13cmos5l_decap_8
XFILLER_6_1757 vccd vssd sg13cmos5l_decap_8
XFILLER_0_2002 vccd vssd sg13cmos5l_decap_8
X_1215_ _1216_/A _1031_/B _1041_/X _1350_/B mask_rev_in[28] vccd vssd sg13cmos5l_a22oi_1
X_1146_ _1146_/Y _1146_/A _1146_/B _1146_/C vccd vssd sg13cmos5l_nand3_1
XFILLER_39_2703 vccd vssd sg13cmos5l_decap_8
XFILLER_38_688 vccd vssd sg13cmos5l_decap_8
XFILLER_37_154 vccd vssd sg13cmos5l_decap_8
XFILLER_4_1470 vccd vssd sg13cmos5l_decap_8
XFILLER_0_2079 vccd vssd sg13cmos5l_decap_8
XFILLER_0_1323 vccd vssd sg13cmos5l_decap_8
XFILLER_40_308 vccd vssd sg13cmos5l_decap_8
XFILLER_20_1295 vccd vssd sg13cmos5l_decap_8
X_1077_ _1078_/B _1077_/A _1077_/B vccd vssd sg13cmos5l_nor2_1
XFILLER_34_883 vccd vssd sg13cmos5l_decap_8
XFILLER_33_2302 vccd vssd sg13cmos5l_decap_8
XFILLER_33_371 vccd vssd sg13cmos5l_decap_8
XFILLER_21_511 vccd vssd sg13cmos5l_decap_8
XFILLER_16_1309 vccd vssd sg13cmos5l_decap_8
Xtiedowns\[6\] status[6] vccd vssd sg13cmos5l_antennanp
XFILLER_21_588 vccd vssd sg13cmos5l_decap_8
XFILLER_14_1022 vccd vssd sg13cmos5l_decap_8
XFILLER_33_1656 vccd vssd sg13cmos5l_decap_8
XFILLER_11_2622 vccd vssd sg13cmos5l_decap_8
XFILLER_11_2655 vccd vssd sg13cmos5l_decap_8
XFILLER_20_14 vccd vssd sg13cmos5l_decap_8
XFILLER_11_1932 vccd vssd sg13cmos5l_decap_8
XFILLER_14_1099 vccd vssd sg13cmos5l_decap_8
XFILLER_1_938 vccd vssd sg13cmos5l_decap_8
XFILLER_44_2464 vccd vssd sg13cmos5l_decap_8
XFILLER_40_2317 vccd vssd sg13cmos5l_decap_8
XFILLER_0_448 vccd vssd sg13cmos5l_decap_8
XFILLER_9_2093 vccd vssd sg13cmos5l_decap_8
XFILLER_29_600 vccd vssd sg13cmos5l_decap_8
XFILLER_29_56 vccd vssd sg13cmos5l_decap_8
XFILLER_25_1140 vccd vssd sg13cmos5l_decap_8
XFILLER_40_1649 vccd vssd sg13cmos5l_decap_8
XFILLER_21_1015 vccd vssd sg13cmos5l_decap_8
XFILLER_5_1267 vccd vssd sg13cmos5l_decap_8
XFILLER_28_154 vccd vssd sg13cmos5l_decap_8
XFILLER_45_77 vccd vssd sg13cmos5l_decap_8
XFILLER_38_2246 vccd vssd sg13cmos5l_decap_8
XFILLER_38_1512 vccd vssd sg13cmos5l_decap_4
XFILLER_31_308 vccd vssd sg13cmos5l_decap_8
XFILLER_25_850 vccd vssd sg13cmos5l_decap_8
XFILLER_16_2500 vccd vssd sg13cmos5l_decap_4
XFILLER_24_371 vccd vssd sg13cmos5l_decap_8
XFILLER_0_1890 vccd vssd sg13cmos5l_decap_8
XFILLER_12_511 vccd vssd sg13cmos5l_decap_8
XFILLER_16_2566 vccd vssd sg13cmos5l_decap_4
XFILLER_8_504 vccd vssd sg13cmos5l_decap_8
XFILLER_12_588 vccd vssd sg13cmos5l_decap_8
XFILLER_32_1155 vccd vssd sg13cmos5l_decap_8
XFILLER_16_1876 vccd vssd sg13cmos5l_decap_8
XFILLER_10_2121 vccd vssd sg13cmos5l_decap_8
XFILLER_12_1729 vccd vssd sg13cmos5l_decap_8
XANTENNA_9 RSTB vccd vssd sg13cmos5l_antennanp
XFILLER_6_49 vccd vssd sg13cmos5l_decap_8
XFILLER_32_1199 vccd vssd sg13cmos5l_decap_8
XFILLER_4_721 vccd vssd sg13cmos5l_decap_8
XFILLER_10_1442 vccd vssd sg13cmos5l_decap_8
XFILLER_10_2198 vccd vssd sg13cmos5l_decap_8
XFILLER_3_231 vccd vssd sg13cmos5l_decap_8
XFILLER_45_1505 vccd vssd sg13cmos5l_decap_8
XFILLER_27_2651 vccd vssd sg13cmos5l_decap_8
XFILLER_4_798 vccd vssd sg13cmos5l_decap_8
XFILLER_10_91 vccd vssd sg13cmos5l_decap_8
XFILLER_39_408 vccd vssd sg13cmos5l_decap_8
XFILLER_23_2515 vccd vssd sg13cmos5l_decap_8
XFILLER_21_2250 vccd vssd sg13cmos5l_decap_8
XFILLER_13_7 vccd vssd sg13cmos5l_decap_8
X_1000_ _1000_/Y _1000_/A _1000_/B _1000_/C vccd vssd sg13cmos5l_nand3_1
XFILLER_23_1869 vccd vssd sg13cmos5l_decap_8
XFILLER_19_154 vccd vssd sg13cmos5l_decap_8
XFILLER_1_1610 vccd vssd sg13cmos5l_decap_8
XFILLER_21_1571 vccd vssd sg13cmos5l_decap_8
XFILLER_1_2366 vccd vssd sg13cmos5l_decap_8
XFILLER_16_861 vccd vssd sg13cmos5l_decap_8
XFILLER_1_1687 vccd vssd sg13cmos5l_decap_8
XFILLER_37_1011 vccd vssd sg13cmos5l_decap_8
XFILLER_34_168 vccd vssd sg13cmos5l_decap_8
XFILLER_22_308 vccd vssd sg13cmos5l_decap_8
XFILLER_15_371 vccd vssd sg13cmos5l_decap_8
XFILLER_37_1077 vccd vssd sg13cmos5l_decap_8
XFILLER_34_2644 vccd vssd sg13cmos5l_decap_8
X_1621__152 _1657_/CLK _1631__159/A vccd vssd sg13cmos5l_inv_1
XFILLER_34_1954 vccd vssd sg13cmos5l_decap_8
XFILLER_31_886 vccd vssd sg13cmos5l_decap_8
XFILLER_15_2065 vccd vssd sg13cmos5l_decap_8
XFILLER_30_385 vccd vssd sg13cmos5l_decap_8
X_1764_ _1764_/Q clkload7/A _1764_/D fanout116/X vccd vssd sg13cmos5l_dfrbpq_1
XFILLER_15_1386 vccd vssd sg13cmos5l_decap_8
XFILLER_11_1239 vccd vssd sg13cmos5l_decap_8
Xhold504 hold504/X _1786_/Q vccd vssd sg13cmos5l_dlygate4sd3_1
Xhold526 hold526/X _1654_/Q vccd vssd sg13cmos5l_dlygate4sd3_1
Xhold515 hold515/X _1807_/Q vccd vssd sg13cmos5l_dlygate4sd3_1
XFILLER_7_581 vccd vssd sg13cmos5l_decap_8
X_1695_ _1695_/Q _1699_/CLK _1695_/D fanout134/X vccd vssd sg13cmos5l_dfrbpq_1
Xhold537 _0930_/A _1800_/Q vccd vssd sg13cmos5l_dlygate4sd3_1
XFILLER_45_2751 vccd vssd sg13cmos5l_decap_8
XFILLER_28_1714 vccd vssd sg13cmos5l_decap_8
XFILLER_26_2172 vccd vssd sg13cmos5l_decap_8
XFILLER_22_2003 vccd vssd sg13cmos5l_decap_8
XFILLER_6_2233 vccd vssd sg13cmos5l_decap_8
Xoutbuffers\[53\] control[53] _1721_/Q vccd vssd sg13cmos5l_buf_8
XFILLER_41_1936 vccd vssd sg13cmos5l_decap_8
XFILLER_6_1554 vccd vssd sg13cmos5l_decap_8
XFILLER_39_2500 vccd vssd sg13cmos5l_decap_8
XFILLER_38_441 vccd vssd sg13cmos5l_decap_8
XFILLER_2_1407 vccd vssd sg13cmos5l_decap_8
XFILLER_0_1120 vccd vssd sg13cmos5l_decap_8
XFILLER_39_2577 vccd vssd sg13cmos5l_decap_8
XFILLER_39_1832 vccd vssd sg13cmos5l_decap_8
XFILLER_20_1092 vccd vssd sg13cmos5l_decap_8
X_1129_ _1129_/Y _0828_/A _0888_/C _1390_/A vccd vssd sg13cmos5l_a21oi_1
XFILLER_15_14 vccd vssd sg13cmos5l_decap_8
XFILLER_41_628 vccd vssd sg13cmos5l_decap_8
XFILLER_40_105 vccd vssd sg13cmos5l_decap_8
XFILLER_25_168 vccd vssd sg13cmos5l_decap_8
XFILLER_0_1197 vccd vssd sg13cmos5l_decap_8
XFILLER_13_308 vccd vssd sg13cmos5l_decap_8
XFILLER_39_1887 vccd vssd sg13cmos5l_decap_8
XFILLER_37_2290 vccd vssd sg13cmos5l_decap_8
XFILLER_16_1106 vccd vssd sg13cmos5l_decap_8
XFILLER_22_875 vccd vssd sg13cmos5l_decap_8
XFILLER_33_2176 vccd vssd sg13cmos5l_decap_8
XFILLER_31_35 vccd vssd sg13cmos5l_decap_8
XFILLER_21_385 vccd vssd sg13cmos5l_decap_8
XFILLER_33_1497 vccd vssd sg13cmos5l_decap_8
XFILLER_5_518 vccd vssd sg13cmos5l_decap_8
XFILLER_1_735 vccd vssd sg13cmos5l_decap_8
XFILLER_44_2250 vccd vssd sg13cmos5l_decap_8
XFILLER_0_245 vccd vssd sg13cmos5l_decap_8
XFILLER_44_1560 vccd vssd sg13cmos5l_decap_8
XFILLER_40_2158 vccd vssd sg13cmos5l_decap_8
XFILLER_40_1402 vccd vssd sg13cmos5l_decap_8
XFILLER_29_441 vccd vssd sg13cmos5l_decap_8
XFILLER_22_2592 vccd vssd sg13cmos5l_decap_8
XFILLER_2_2653 vccd vssd sg13cmos5l_decap_8
XFILLER_5_1064 vccd vssd sg13cmos5l_decap_8
XFILLER_45_945 vccd vssd sg13cmos5l_decap_8
XFILLER_44_433 vccd vssd sg13cmos5l_decap_8
XFILLER_38_2021 vccd vssd sg13cmos5l_decap_8
XFILLER_17_658 vccd vssd sg13cmos5l_decap_8
XFILLER_2_1974 vccd vssd sg13cmos5l_decap_8
XFILLER_38_1320 vccd vssd sg13cmos5l_decap_8
XFILLER_31_105 vccd vssd sg13cmos5l_decap_8
XFILLER_16_168 vccd vssd sg13cmos5l_decap_8
XFILLER_34_1206 vccd vssd sg13cmos5l_decap_8
XFILLER_16_2374 vccd vssd sg13cmos5l_decap_8
XFILLER_8_301 vccd vssd sg13cmos5l_decap_8
XFILLER_13_875 vccd vssd sg13cmos5l_decap_8
XFILLER_16_1673 vccd vssd sg13cmos5l_decap_8
XFILLER_9_868 vccd vssd sg13cmos5l_decap_8
XFILLER_12_385 vccd vssd sg13cmos5l_decap_8
XFILLER_8_378 vccd vssd sg13cmos5l_decap_8
XFILLER_12_1526 vccd vssd sg13cmos5l_decap_8
XFILLER_29_2713 vccd vssd sg13cmos5l_decap_8
XFILLER_45_1302 vccd vssd sg13cmos5l_decap_8
X_1480_ _1480_/X hold524/X hold346/X _1480_/S vccd vssd sg13cmos5l_mux2_1
XFILLER_4_595 vccd vssd sg13cmos5l_decap_8
XFILLER_45_2058 vccd vssd sg13cmos5l_decap_8
XFILLER_7_2520 vccd vssd sg13cmos5l_decap_8
XFILLER_45_1379 vccd vssd sg13cmos5l_decap_8
XFILLER_23_2323 vccd vssd sg13cmos5l_decap_8
XFILLER_39_238 vccd vssd sg13cmos5l_decap_8
XFILLER_23_1611 vccd vssd sg13cmos5l_decap_8
XFILLER_7_1841 vccd vssd sg13cmos5l_decap_8
XFILLER_36_912 vccd vssd sg13cmos5l_decap_8
XFILLER_23_1699 vccd vssd sg13cmos5l_decap_8
XFILLER_21_2091 vccd vssd sg13cmos5l_decap_4
XFILLER_1_2163 vccd vssd sg13cmos5l_decap_8
XFILLER_36_2728 vccd vssd sg13cmos5l_decap_8
XFILLER_22_105 vccd vssd sg13cmos5l_decap_8
XFILLER_17_2116 vccd vssd sg13cmos5l_decap_8
XFILLER_1_1484 vccd vssd sg13cmos5l_decap_8
XFILLER_31_683 vccd vssd sg13cmos5l_decap_8
XFILLER_30_182 vccd vssd sg13cmos5l_decap_8
XFILLER_15_1183 vccd vssd sg13cmos5l_decap_8
XFILLER_12_2761 vccd vssd sg13cmos5l_decap_8
Xhold301 _1693_/D _1456_/X vccd vssd sg13cmos5l_dlygate4sd3_1
XFILLER_30_1659 vccd vssd sg13cmos5l_decap_8
XFILLER_7_70 vccd vssd sg13cmos5l_decap_8
XFILLER_11_1036 vccd vssd sg13cmos5l_decap_8
Xhold323 _1727_/D _1503_/X vccd vssd sg13cmos5l_dlygate4sd3_1
X_1747_ _1747_/Q _1757_/CLK _1747_/D fanout123/X vccd vssd sg13cmos5l_dfrbpq_1
Xhold334 hold334/X _1672_/Q vccd vssd sg13cmos5l_dlygate4sd3_1
Xhold312 hold312/X _1670_/Q vccd vssd sg13cmos5l_dlygate4sd3_1
X_1678_ _1678_/Q clkload9/A _1678_/D fanout139/X vccd vssd sg13cmos5l_dfrbpq_1
Xhold378 _1680_/D _1435_/X vccd vssd sg13cmos5l_dlygate4sd3_1
Xhold345 _1694_/D _1457_/X vccd vssd sg13cmos5l_dlygate4sd3_1
Xhold356 hold356/X _1721_/Q vccd vssd sg13cmos5l_dlygate4sd3_1
Xhold367 hold367/X _1734_/Q vccd vssd sg13cmos5l_dlygate4sd3_1
XFILLER_28_2245 vccd vssd sg13cmos5l_decap_8
XFILLER_8_2317 vccd vssd sg13cmos5l_decap_8
XFILLER_41_2401 vccd vssd sg13cmos5l_decap_8
Xhold389 _1767_/D _1563_/Y vccd vssd sg13cmos5l_dlygate4sd3_1
XFILLER_28_1522 vccd vssd sg13cmos5l_decap_8
XFILLER_28_1588 vccd vssd sg13cmos5l_decap_8
XFILLER_24_1419 vccd vssd sg13cmos5l_decap_8
XFILLER_6_2030 vccd vssd sg13cmos5l_decap_8
XFILLER_8_1638 vccd vssd sg13cmos5l_decap_8
XFILLER_41_1733 vccd vssd sg13cmos5l_decap_8
XFILLER_2_1204 vccd vssd sg13cmos5l_decap_8
XFILLER_6_1351 vccd vssd sg13cmos5l_decap_8
XFILLER_27_923 vccd vssd sg13cmos5l_decap_8
XFILLER_26_455 vccd vssd sg13cmos5l_decap_8
XFILLER_26_35 vccd vssd sg13cmos5l_decap_8
XFILLER_42_926 vccd vssd sg13cmos5l_decap_8
XFILLER_41_414 vccd vssd sg13cmos5l_decap_8
XFILLER_39_2385 vccd vssd sg13cmos5l_decap_8
XFILLER_13_105 vccd vssd sg13cmos5l_decap_8
XFILLER_42_959 vccd vssd sg13cmos5l_decap_8
XFILLER_39_1651 vccd vssd sg13cmos5l_decap_8
XFILLER_35_2249 vccd vssd sg13cmos5l_decap_8
XFILLER_10_812 vccd vssd sg13cmos5l_decap_8
XFILLER_13_2503 vccd vssd sg13cmos5l_decap_8
XFILLER_42_56 vccd vssd sg13cmos5l_decap_8
XFILLER_22_672 vccd vssd sg13cmos5l_decap_8
XFILLER_21_182 vccd vssd sg13cmos5l_decap_8
XFILLER_17_1993 vccd vssd sg13cmos5l_decap_8
XFILLER_6_805 vccd vssd sg13cmos5l_decap_8
XFILLER_13_1813 vccd vssd sg13cmos5l_decap_4
XFILLER_13_2558 vccd vssd sg13cmos5l_decap_8
XFILLER_33_1283 vccd vssd sg13cmos5l_decap_8
XFILLER_29_2009 vccd vssd sg13cmos5l_decap_8
XFILLER_5_315 vccd vssd sg13cmos5l_decap_8
XFILLER_10_889 vccd vssd sg13cmos5l_decap_8
XFILLER_3_28 vccd vssd sg13cmos5l_decap_8
XFILLER_1_532 vccd vssd sg13cmos5l_decap_8
XFILLER_24_2643 vccd vssd sg13cmos5l_decap_8
XFILLER_42_1519 vccd vssd sg13cmos5l_decap_8
XFILLER_7_1148 vccd vssd sg13cmos5l_decap_8
XFILLER_24_1964 vccd vssd sg13cmos5l_decap_8
XFILLER_18_945 vccd vssd sg13cmos5l_decap_8
XFILLER_2_2450 vccd vssd sg13cmos5l_decap_8
XFILLER_45_742 vccd vssd sg13cmos5l_decap_8
XFILLER_44_241 vccd vssd sg13cmos5l_decap_8
XFILLER_40_1298 vccd vssd sg13cmos5l_decap_8
XFILLER_17_455 vccd vssd sg13cmos5l_decap_8
XFILLER_33_937 vccd vssd sg13cmos5l_decap_8
XFILLER_2_1771 vccd vssd sg13cmos5l_decap_8
XFILLER_18_2469 vccd vssd sg13cmos5l_decap_8
X_0980_ _0990_/C status[119] wire81/X _1261_/B vccd vssd sg13cmos5l_a21oi_1
XFILLER_20_609 vccd vssd sg13cmos5l_decap_8
XFILLER_18_1757 vccd vssd sg13cmos5l_decap_8
XFILLER_41_992 vccd vssd sg13cmos5l_decap_8
XFILLER_34_1025 vccd vssd sg13cmos5l_decap_8
XFILLER_31_2647 vccd vssd sg13cmos5l_decap_8
XFILLER_12_2002 vccd vssd sg13cmos5l_decap_8
XFILLER_13_672 vccd vssd sg13cmos5l_decap_8
XFILLER_16_1470 vccd vssd sg13cmos5l_decap_8
XFILLER_9_665 vccd vssd sg13cmos5l_decap_8
XFILLER_12_182 vccd vssd sg13cmos5l_decap_8
XFILLER_8_175 vccd vssd sg13cmos5l_decap_8
XFILLER_12_1323 vccd vssd sg13cmos5l_decap_8
XFILLER_12_2079 vccd vssd sg13cmos5l_decap_8
X_1601_ _1601_/Y _1605_/A _1603_/B_N vccd vssd sg13cmos5l_nor2b_1
X_1532_ _1532_/Y _1532_/A _1541_/S vccd vssd sg13cmos5l_nand2_1
XFILLER_5_882 vccd vssd sg13cmos5l_decap_8
XFILLER_9_2604 vccd vssd sg13cmos5l_decap_8
X_1463_ _1472_/B _1655_/Q _1463_/B vccd vssd sg13cmos5l_nand2_1
XFILLER_29_2587 vccd vssd sg13cmos5l_decap_8
XFILLER_29_1842 vccd vssd sg13cmos5l_decap_8
XFILLER_4_392 vccd vssd sg13cmos5l_decap_8
XFILLER_9_1925 vccd vssd sg13cmos5l_decap_8
XFILLER_9_2659 vccd vssd sg13cmos5l_decap_8
XFILLER_29_1875 vccd vssd sg13cmos5l_decap_8
XFILLER_45_1176 vccd vssd sg13cmos5l_decap_8
XFILLER_42_2776 vccd vssd sg13cmos5l_decap_8
XFILLER_23_2120 vccd vssd sg13cmos5l_decap_8
X_1394_ _1401_/B _1394_/A _1394_/B _1394_/C vccd vssd sg13cmos5l_nand3_1
XFILLER_41_1029 vccd vssd sg13cmos5l_decap_8
XFILLER_28_709 vccd vssd sg13cmos5l_decap_8
XFILLER_3_2247 vccd vssd sg13cmos5l_decap_8
XFILLER_7_2394 vccd vssd sg13cmos5l_decap_8
XFILLER_3_1568 vccd vssd sg13cmos5l_decap_8
Xoutbuffers\[16\] control[16] _1684_/Q vccd vssd sg13cmos5l_buf_8
XFILLER_36_2525 vccd vssd sg13cmos5l_decap_8
XFILLER_35_252 vccd vssd sg13cmos5l_decap_8
XFILLER_24_959 vccd vssd sg13cmos5l_decap_8
XFILLER_1_1281 vccd vssd sg13cmos5l_decap_8
XFILLER_23_469 vccd vssd sg13cmos5l_decap_8
XFILLER_11_609 vccd vssd sg13cmos5l_decap_8
XFILLER_32_981 vccd vssd sg13cmos5l_decap_8
XFILLER_17_1267 vccd vssd sg13cmos5l_decap_8
XFILLER_10_119 vccd vssd sg13cmos5l_decap_8
XFILLER_30_1412 vccd vssd sg13cmos5l_decap_8
XFILLER_3_819 vccd vssd sg13cmos5l_decap_8
XFILLER_30_1489 vccd vssd sg13cmos5l_decap_8
XFILLER_2_329 vccd vssd sg13cmos5l_decap_8
XFILLER_12_1890 vccd vssd sg13cmos5l_decap_8
XFILLER_43_2507 vccd vssd sg13cmos5l_decap_4
Xhold186 _1804_/D _0914_/X vccd vssd sg13cmos5l_dlygate4sd3_1
Xhold175 hold175/X _1410_/Y vccd vssd sg13cmos5l_dlygate4sd3_1
XFILLER_8_2114 vccd vssd sg13cmos5l_decap_8
XFILLER_28_1330 vccd vssd sg13cmos5l_decap_8
Xhold197 _1807_/D _0894_/Y vccd vssd sg13cmos5l_dlygate4sd3_1
XFILLER_28_1396 vccd vssd sg13cmos5l_decap_8
XFILLER_8_1435 vccd vssd sg13cmos5l_decap_8
XFILLER_41_2286 vccd vssd sg13cmos5l_decap_8
XFILLER_41_1574 vccd vssd sg13cmos5l_decap_8
XFILLER_37_56 vccd vssd sg13cmos5l_decap_8
XFILLER_2_1001 vccd vssd sg13cmos5l_decap_8
XFILLER_27_731 vccd vssd sg13cmos5l_decap_4
XFILLER_42_712 vccd vssd sg13cmos5l_decap_8
XFILLER_26_252 vccd vssd sg13cmos5l_decap_8
XFILLER_19_2734 vccd vssd sg13cmos5l_decap_8
XFILLER_2_1078 vccd vssd sg13cmos5l_decap_8
XFILLER_15_959 vccd vssd sg13cmos5l_decap_8
XFILLER_42_767 vccd vssd sg13cmos5l_decap_8
XFILLER_35_1312 vccd vssd sg13cmos5l_decap_8
XFILLER_14_469 vccd vssd sg13cmos5l_decap_8
XFILLER_41_277 vccd vssd sg13cmos5l_decap_8
XFILLER_35_1389 vccd vssd sg13cmos5l_decap_8
XFILLER_6_602 vccd vssd sg13cmos5l_decap_8
XFILLER_13_1610 vccd vssd sg13cmos5l_decap_8
XFILLER_5_112 vccd vssd sg13cmos5l_decap_8
XFILLER_10_686 vccd vssd sg13cmos5l_decap_8
XFILLER_13_2377 vccd vssd sg13cmos5l_decap_8
XFILLER_30_2680 vccd vssd sg13cmos5l_decap_8
XFILLER_6_679 vccd vssd sg13cmos5l_decap_8
XFILLER_13_1687 vccd vssd sg13cmos5l_decap_8
XFILLER_5_189 vccd vssd sg13cmos5l_decap_8
Xtiedowns\[52\] status[52] vccd vssd sg13cmos5l_antennanp
XFILLER_29_1116 vccd vssd sg13cmos5l_decap_4
XFILLER_26_2705 vccd vssd sg13cmos5l_decap_8
XFILLER_42_2039 vccd vssd sg13cmos5l_decap_8
XFILLER_42_1316 vccd vssd sg13cmos5l_decap_8
XFILLER_2_896 vccd vssd sg13cmos5l_decap_8
XFILLER_4_2534 vccd vssd sg13cmos5l_decap_8
XFILLER_37_517 vccd vssd sg13cmos5l_decap_8
XFILLER_4_1855 vccd vssd sg13cmos5l_decap_8
XFILLER_40_1073 vccd vssd sg13cmos5l_decap_8
XFILLER_20_1647 vccd vssd sg13cmos5l_decap_8
XFILLER_18_742 vccd vssd sg13cmos5l_decap_8
XFILLER_0_1708 vccd vssd sg13cmos5l_decap_8
XFILLER_17_252 vccd vssd sg13cmos5l_decap_8
XFILLER_36_1109 vccd vssd sg13cmos5l_decap_8
XFILLER_32_266 vccd vssd sg13cmos5l_decap_8
XFILLER_20_406 vccd vssd sg13cmos5l_decap_8
Xoutbuffers\[106\] control[106] _1774_/Q vccd vssd sg13cmos5l_buf_8
XFILLER_18_1554 vccd vssd sg13cmos5l_decap_8
XFILLER_14_1407 vccd vssd sg13cmos5l_decap_8
X_0963_ _1017_/B _0997_/A _0997_/B vccd vssd sg13cmos5l_nor2b_1
XFILLER_9_462 vccd vssd sg13cmos5l_decap_8
XFILLER_31_2488 vccd vssd sg13cmos5l_decap_8
X_0894_ _0894_/Y _0898_/A _0894_/B vccd vssd sg13cmos5l_xnor2_1
XFILLER_12_1120 vccd vssd sg13cmos5l_decap_8
XFILLER_31_1776 vccd vssd sg13cmos5l_decap_8
XFILLER_9_2401 vccd vssd sg13cmos5l_decap_8
XFILLER_12_1197 vccd vssd sg13cmos5l_decap_8
X_1515_ _1515_/X _1445_/A hold360/X _1518_/S vccd vssd sg13cmos5l_mux2_1
XFILLER_29_2384 vccd vssd sg13cmos5l_decap_8
XFILLER_29_1650 vccd vssd sg13cmos5l_decap_4
XFILLER_9_1722 vccd vssd sg13cmos5l_decap_8
XFILLER_9_2478 vccd vssd sg13cmos5l_decap_8
X_1446_ _1446_/Y hold222/X _1451_/B _1445_/Y vccd vssd sg13cmos5l_a21oi_1
X_1377_ _1377_/Y _1708_/Q _1474_/B vccd vssd sg13cmos5l_nor2b_1
XFILLER_7_2191 vccd vssd sg13cmos5l_decap_8
XFILLER_9_1799 vccd vssd sg13cmos5l_decap_8
XFILLER_42_2595 vccd vssd sg13cmos5l_decap_8
XFILLER_42_1850 vccd vssd sg13cmos5l_decap_8
XFILLER_3_2044 vccd vssd sg13cmos5l_decap_8
XFILLER_42_1883 vccd vssd sg13cmos5l_decap_8
XFILLER_38_2609 vccd vssd sg13cmos5l_decap_8
XFILLER_23_1293 vccd vssd sg13cmos5l_decap_8
XFILLER_43_509 vccd vssd sg13cmos5l_decap_4
XFILLER_38_1908 vccd vssd sg13cmos5l_decap_8
XFILLER_36_2300 vccd vssd sg13cmos5l_decap_8
XFILLER_3_1365 vccd vssd sg13cmos5l_decap_8
XFILLER_24_756 vccd vssd sg13cmos5l_decap_8
XFILLER_11_406 vccd vssd sg13cmos5l_decap_8
XFILLER_36_2377 vccd vssd sg13cmos5l_decap_8
XFILLER_36_1654 vccd vssd sg13cmos5l_decap_4
XFILLER_23_266 vccd vssd sg13cmos5l_decap_8
XFILLER_23_14 vccd vssd sg13cmos5l_decap_8
XFILLER_34_2090 vccd vssd sg13cmos5l_decap_8
XFILLER_17_1064 vccd vssd sg13cmos5l_decap_8
XFILLER_14_2642 vccd vssd sg13cmos5l_decap_8
XFILLER_20_973 vccd vssd sg13cmos5l_decap_8
XFILLER_10_2528 vccd vssd sg13cmos5l_decap_8
XFILLER_10_1827 vccd vssd sg13cmos5l_decap_8
XFILLER_14_1974 vccd vssd sg13cmos5l_decap_8
XFILLER_3_616 vccd vssd sg13cmos5l_decap_8
XFILLER_30_1297 vccd vssd sg13cmos5l_decap_8
XFILLER_2_126 vccd vssd sg13cmos5l_decap_8
XFILLER_43_2315 vccd vssd sg13cmos5l_decap_4
XFILLER_8_1232 vccd vssd sg13cmos5l_decap_8
XFILLER_41_2083 vccd vssd sg13cmos5l_decap_8
XFILLER_21_2657 vccd vssd sg13cmos5l_decap_8
XFILLER_19_539 vccd vssd sg13cmos5l_decap_8
XFILLER_41_1360 vccd vssd sg13cmos5l_decap_4
XFILLER_21_1967 vccd vssd sg13cmos5l_decap_8
XFILLER_42_564 vccd vssd sg13cmos5l_decap_8
XFILLER_15_756 vccd vssd sg13cmos5l_decap_8
XFILLER_42_597 vccd vssd sg13cmos5l_decap_8
XFILLER_30_715 vccd vssd sg13cmos5l_decap_4
XFILLER_9_49 vccd vssd sg13cmos5l_decap_8
XFILLER_14_266 vccd vssd sg13cmos5l_decap_8
XFILLER_35_1153 vccd vssd sg13cmos5l_decap_8
XFILLER_32_2742 vccd vssd sg13cmos5l_decap_8
Xfanout70 _1077_/B _1042_/Y vccd vssd sg13cmos5l_buf_1
Xfanout92 _0947_/S fanout93/X vccd vssd sg13cmos5l_buf_16
XFILLER_11_973 vccd vssd sg13cmos5l_decap_8
XFILLER_7_966 vccd vssd sg13cmos5l_decap_8
XFILLER_10_483 vccd vssd sg13cmos5l_decap_8
XFILLER_13_91 vccd vssd sg13cmos5l_decap_8
XFILLER_6_476 vccd vssd sg13cmos5l_decap_8
XFILLER_13_1484 vccd vssd sg13cmos5l_decap_8
XFILLER_43_7 vccd vssd sg13cmos5l_decap_8
XFILLER_26_2513 vccd vssd sg13cmos5l_decap_8
XFILLER_9_1029 vccd vssd sg13cmos5l_decap_8
XFILLER_2_693 vccd vssd sg13cmos5l_decap_8
XFILLER_6_2629 vccd vssd sg13cmos5l_decap_8
X_1300_ _1300_/Y mask_rev_in[10] _1306_/B _1347_/B1 vccd vssd sg13cmos5l_a21oi_1
X_1231_ _1235_/A _1228_/Y _1229_/Y _1230_/Y vccd vssd sg13cmos5l_a21o_1
XFILLER_4_2331 vccd vssd sg13cmos5l_decap_8
XFILLER_6_1939 vccd vssd sg13cmos5l_decap_8
XFILLER_37_336 vccd vssd sg13cmos5l_decap_8
X_1162_ _1162_/Y _1705_/Q _1162_/B vccd vssd sg13cmos5l_nand2b_1
XFILLER_20_1400 vccd vssd sg13cmos5l_decap_8
XFILLER_4_1652 vccd vssd sg13cmos5l_decap_8
X_1093_ _1093_/X _0872_/Y _1315_/B1 _1268_/B1 vccd vssd sg13cmos5l_a21o_1
XFILLER_20_1444 vccd vssd sg13cmos5l_decap_8
XFILLER_0_1505 vccd vssd sg13cmos5l_decap_8
XFILLER_37_2653 vccd vssd sg13cmos5l_decap_8
XFILLER_33_542 vccd vssd sg13cmos5l_decap_8
XFILLER_20_203 vccd vssd sg13cmos5l_decap_8
XFILLER_18_2074 vccd vssd sg13cmos5l_decap_8
XFILLER_37_1996 vccd vssd sg13cmos5l_decap_8
XFILLER_18_1351 vccd vssd sg13cmos5l_decap_8
XFILLER_14_1204 vccd vssd sg13cmos5l_decap_8
XFILLER_33_1849 vccd vssd sg13cmos5l_decap_8
X_0946_ _1667_/D _1390_/A vccd vssd sg13cmos5l_inv_1
XFILLER_31_2285 vccd vssd sg13cmos5l_decap_8
X_0877_ _0877_/Y status[23] vccd vssd sg13cmos5l_inv_1
Xoutbuffers\[83\] control[83] _1751_/Q vccd vssd sg13cmos5l_buf_8
XFILLER_44_2646 vccd vssd sg13cmos5l_decap_8
XFILLER_44_1912 vccd vssd sg13cmos5l_decap_8
XFILLER_9_2275 vccd vssd sg13cmos5l_decap_8
XFILLER_44_1956 vccd vssd sg13cmos5l_decap_8
X_1429_ _1438_/S _1520_/A _1429_/B vccd vssd sg13cmos5l_nand2_1
XFILLER_25_2067 vccd vssd sg13cmos5l_decap_8
XFILLER_5_2128 vccd vssd sg13cmos5l_decap_8
XFILLER_25_1355 vccd vssd sg13cmos5l_decap_8
XFILLER_18_14 vccd vssd sg13cmos5l_decap_8
XFILLER_5_1449 vccd vssd sg13cmos5l_decap_8
XFILLER_9_1596 vccd vssd sg13cmos5l_decap_8
XFILLER_44_807 vccd vssd sg13cmos5l_decap_8
XFILLER_42_1680 vccd vssd sg13cmos5l_decap_8
XFILLER_28_336 vccd vssd sg13cmos5l_decap_8
XFILLER_3_1162 vccd vssd sg13cmos5l_decap_8
XFILLER_0_2751 vccd vssd sg13cmos5l_decap_8
XFILLER_43_328 vccd vssd sg13cmos5l_decap_8
XFILLER_38_1705 vccd vssd sg13cmos5l_decap_8
XFILLER_36_2130 vccd vssd sg13cmos5l_decap_8
XFILLER_34_35 vccd vssd sg13cmos5l_decap_8
XFILLER_24_553 vccd vssd sg13cmos5l_decap_8
XFILLER_19_1148 vccd vssd sg13cmos5l_decap_8
XFILLER_11_203 vccd vssd sg13cmos5l_decap_8
XFILLER_32_2049 vccd vssd sg13cmos5l_decap_8
Xclkload1 clkload1/Y clkload1/A vccd vssd sg13cmos5l_inv_1
XFILLER_20_770 vccd vssd sg13cmos5l_decap_8
XFILLER_10_2303 vccd vssd sg13cmos5l_decap_8
XFILLER_14_1771 vccd vssd sg13cmos5l_decap_8
XFILLER_30_1061 vccd vssd sg13cmos5l_decap_8
XFILLER_4_903 vccd vssd sg13cmos5l_decap_8
XFILLER_10_1624 vccd vssd sg13cmos5l_decap_8
XFILLER_3_413 vccd vssd sg13cmos5l_decap_8
XFILLER_43_2112 vccd vssd sg13cmos5l_decap_8
XFILLER_5_2640 vccd vssd sg13cmos5l_decap_8
XFILLER_21_2454 vccd vssd sg13cmos5l_decap_8
XFILLER_19_336 vccd vssd sg13cmos5l_decap_8
Xtiedowns\[15\] status[15] vccd vssd sg13cmos5l_antennanp
XFILLER_1_2548 vccd vssd sg13cmos5l_decap_8
XFILLER_21_1775 vccd vssd sg13cmos5l_decap_8
XFILLER_1_1869 vccd vssd sg13cmos5l_decap_8
XFILLER_15_553 vccd vssd sg13cmos5l_decap_8
XFILLER_37_1237 vccd vssd sg13cmos5l_decap_8
XFILLER_30_501 vccd vssd sg13cmos5l_decap_8
XFILLER_15_2203 vccd vssd sg13cmos5l_decap_8
XFILLER_42_383 vccd vssd sg13cmos5l_decap_8
X_1780_ _1780_/Q _1790_/CLK _1780_/D fanout115/X vccd vssd sg13cmos5l_dfrbpq_1
XFILLER_15_2269 vccd vssd sg13cmos5l_decap_8
XFILLER_11_770 vccd vssd sg13cmos5l_decap_8
XFILLER_15_1568 vccd vssd sg13cmos5l_decap_8
XFILLER_10_280 vccd vssd sg13cmos5l_decap_8
XFILLER_32_1871 vccd vssd sg13cmos5l_decap_8
XFILLER_7_763 vccd vssd sg13cmos5l_decap_8
XFILLER_6_273 vccd vssd sg13cmos5l_decap_8
XFILLER_13_1281 vccd vssd sg13cmos5l_decap_8
XFILLER_26_2343 vccd vssd sg13cmos5l_decap_8
XFILLER_3_980 vccd vssd sg13cmos5l_decap_8
XFILLER_6_2415 vccd vssd sg13cmos5l_decap_8
XFILLER_26_2387 vccd vssd sg13cmos5l_decap_8
XFILLER_22_2207 vccd vssd sg13cmos5l_decap_8
XFILLER_2_490 vccd vssd sg13cmos5l_decap_8
XFILLER_22_1506 vccd vssd sg13cmos5l_decap_8
XFILLER_6_1736 vccd vssd sg13cmos5l_decap_8
XFILLER_37_133 vccd vssd sg13cmos5l_decap_8
X_1214_ _1216_/B mask_rev_in[20] _1348_/B _1213_/Y vccd vssd sg13cmos5l_o21ai_1
X_1145_ _1146_/C status[21] _1232_/B _1147_/B vccd vssd sg13cmos5l_a21oi_1
XFILLER_0_1302 vccd vssd sg13cmos5l_decap_8
XFILLER_39_2759 vccd vssd sg13cmos5l_decap_8
XFILLER_20_1274 vccd vssd sg13cmos5l_decap_8
XFILLER_0_2058 vccd vssd sg13cmos5l_decap_8
XFILLER_34_862 vccd vssd sg13cmos5l_decap_8
XFILLER_0_1379 vccd vssd sg13cmos5l_decap_8
X_1076_ _1390_/B _1076_/A vccd vssd sg13cmos5l_inv_1
XFILLER_37_2483 vccd vssd sg13cmos5l_decap_8
XFILLER_33_350 vccd vssd sg13cmos5l_decap_8
XFILLER_21_567 vccd vssd sg13cmos5l_decap_8
XFILLER_14_1001 vccd vssd sg13cmos5l_decap_8
XFILLER_31_2093 vccd vssd sg13cmos5l_decap_8
X_0929_ _0929_/Y _0930_/A _0908_/B _0920_/A vccd vssd sg13cmos5l_o21ai_1
XFILLER_11_1911 vccd vssd sg13cmos5l_decap_8
XFILLER_14_1078 vccd vssd sg13cmos5l_decap_8
XFILLER_1_917 vccd vssd sg13cmos5l_decap_8
XFILLER_11_1988 vccd vssd sg13cmos5l_decap_8
XFILLER_44_2443 vccd vssd sg13cmos5l_decap_8
XFILLER_27_1417 vccd vssd sg13cmos5l_decap_8
XFILLER_0_427 vccd vssd sg13cmos5l_decap_8
XFILLER_44_1742 vccd vssd sg13cmos5l_decap_8
XFILLER_29_35 vccd vssd sg13cmos5l_decap_8
XFILLER_9_2072 vccd vssd sg13cmos5l_decap_8
XFILLER_40_1606 vccd vssd sg13cmos5l_decap_8
XFILLER_9_1393 vccd vssd sg13cmos5l_decap_8
XFILLER_44_1786 vccd vssd sg13cmos5l_decap_8
XFILLER_22_2774 vccd vssd sg13cmos5l_decap_8
XFILLER_5_1246 vccd vssd sg13cmos5l_decap_8
XFILLER_29_667 vccd vssd sg13cmos5l_decap_8
XFILLER_28_133 vccd vssd sg13cmos5l_decap_8
XFILLER_25_1196 vccd vssd sg13cmos5l_decap_8
XFILLER_45_56 vccd vssd sg13cmos5l_decap_8
XFILLER_38_2225 vccd vssd sg13cmos5l_decap_8
XFILLER_38_2269 vccd vssd sg13cmos5l_decap_8
XFILLER_24_350 vccd vssd sg13cmos5l_decap_8
XFILLER_16_2545 vccd vssd sg13cmos5l_decap_8
XFILLER_16_1855 vccd vssd sg13cmos5l_decap_8
XFILLER_12_567 vccd vssd sg13cmos5l_decap_8
XFILLER_32_1134 vccd vssd sg13cmos5l_decap_8
XFILLER_10_2100 vccd vssd sg13cmos5l_decap_8
XFILLER_12_1708 vccd vssd sg13cmos5l_decap_8
XFILLER_32_1178 vccd vssd sg13cmos5l_decap_8
XFILLER_4_700 vccd vssd sg13cmos5l_decap_8
XFILLER_6_28 vccd vssd sg13cmos5l_decap_8
XFILLER_3_210 vccd vssd sg13cmos5l_decap_8
XFILLER_10_1421 vccd vssd sg13cmos5l_decap_8
XFILLER_10_2177 vccd vssd sg13cmos5l_decap_8
XFILLER_4_777 vccd vssd sg13cmos5l_decap_8
XFILLER_27_2630 vccd vssd sg13cmos5l_decap_8
XFILLER_3_287 vccd vssd sg13cmos5l_decap_8
XFILLER_10_70 vccd vssd sg13cmos5l_decap_8
XFILLER_10_1498 vccd vssd sg13cmos5l_decap_8
XFILLER_23_1804 vccd vssd sg13cmos5l_decap_8
XFILLER_27_1995 vccd vssd sg13cmos5l_decap_8
XFILLER_23_1848 vccd vssd sg13cmos5l_decap_8
XFILLER_0_994 vccd vssd sg13cmos5l_decap_8
XFILLER_43_1296 vccd vssd sg13cmos5l_decap_8
XFILLER_19_133 vccd vssd sg13cmos5l_decap_8
XFILLER_1_2345 vccd vssd sg13cmos5l_decap_8
XFILLER_5_2492 vccd vssd sg13cmos5l_decap_8
XFILLER_21_1550 vccd vssd sg13cmos5l_decap_8
XFILLER_34_147 vccd vssd sg13cmos5l_decap_8
XFILLER_16_840 vccd vssd sg13cmos5l_decap_8
XFILLER_1_1666 vccd vssd sg13cmos5l_decap_8
XFILLER_38_2770 vccd vssd sg13cmos5l_decap_8
XFILLER_34_2623 vccd vssd sg13cmos5l_decap_8
XFILLER_15_350 vccd vssd sg13cmos5l_decap_8
XFILLER_42_191 vccd vssd sg13cmos5l_decap_8
XFILLER_31_865 vccd vssd sg13cmos5l_decap_8
XFILLER_30_364 vccd vssd sg13cmos5l_decap_8
XFILLER_15_2044 vccd vssd sg13cmos5l_decap_8
XFILLER_15_1365 vccd vssd sg13cmos5l_decap_8
X_1763_ _1763_/Q _1763_/CLK _1763_/D fanout120/X vccd vssd sg13cmos5l_dfrbpq_1
XFILLER_7_560 vccd vssd sg13cmos5l_decap_8
XFILLER_11_1218 vccd vssd sg13cmos5l_decap_8
X_1694_ _1694_/Q _1707_/CLK _1694_/D _1638_/B_N vccd vssd sg13cmos5l_dfrbpq_1
Xhold505 _1786_/D _1586_/X vccd vssd sg13cmos5l_dlygate4sd3_1
Xhold527 _1654_/D _1395_/X vccd vssd sg13cmos5l_dlygate4sd3_1
Xhold516 _0903_/B _1403_/B vccd vssd sg13cmos5l_dlygate4sd3_1
Xhold538 hold538/X _0931_/Y vccd vssd sg13cmos5l_dlygate4sd3_1
XFILLER_45_2730 vccd vssd sg13cmos5l_decap_8
XFILLER_32_0 vccd vssd sg13cmos5l_decap_8
XFILLER_26_2151 vccd vssd sg13cmos5l_decap_8
XFILLER_6_2212 vccd vssd sg13cmos5l_decap_8
XFILLER_44_1049 vccd vssd sg13cmos5l_decap_8
XFILLER_41_2649 vccd vssd sg13cmos5l_decap_8
XFILLER_41_1915 vccd vssd sg13cmos5l_decap_8
XFILLER_26_1461 vccd vssd sg13cmos5l_decap_8
Xoutbuffers\[46\] control[46] _1714_/Q vccd vssd sg13cmos5l_buf_8
XFILLER_38_420 vccd vssd sg13cmos5l_decap_8
XFILLER_6_1533 vccd vssd sg13cmos5l_decap_8
XFILLER_6_2289 vccd vssd sg13cmos5l_decap_8
XFILLER_26_604 vccd vssd sg13cmos5l_decap_8
XFILLER_22_1336 vccd vssd sg13cmos5l_decap_8
XFILLER_41_607 vccd vssd sg13cmos5l_decap_8
XFILLER_39_2556 vccd vssd sg13cmos5l_decap_8
XFILLER_25_147 vccd vssd sg13cmos5l_decap_8
XFILLER_20_1071 vccd vssd sg13cmos5l_decap_8
X_1128_ _1128_/Y _1072_/Y _1127_/Y _1217_/B vccd vssd sg13cmos5l_o21ai_1
X_1059_ _1598_/B _1102_/C _1070_/C vccd vssd sg13cmos5l_nor2_1
XFILLER_0_1176 vccd vssd sg13cmos5l_decap_8
XFILLER_33_2111 vccd vssd sg13cmos5l_decap_8
XFILLER_22_854 vccd vssd sg13cmos5l_decap_8
XFILLER_33_2155 vccd vssd sg13cmos5l_decap_8
XFILLER_21_364 vccd vssd sg13cmos5l_decap_8
XFILLER_31_14 vccd vssd sg13cmos5l_decap_8
XFILLER_11_2464 vccd vssd sg13cmos5l_decap_4
XFILLER_11_2486 vccd vssd sg13cmos5l_decap_4
XFILLER_11_1785 vccd vssd sg13cmos5l_decap_8
XFILLER_1_714 vccd vssd sg13cmos5l_decap_8
XFILLER_7_2009 vccd vssd sg13cmos5l_decap_8
XFILLER_0_224 vccd vssd sg13cmos5l_decap_8
XFILLER_40_2137 vccd vssd sg13cmos5l_decap_8
XFILLER_29_420 vccd vssd sg13cmos5l_decap_8
XFILLER_9_1190 vccd vssd sg13cmos5l_decap_8
XFILLER_22_2571 vccd vssd sg13cmos5l_decap_8
XFILLER_2_2632 vccd vssd sg13cmos5l_decap_8
XFILLER_5_1043 vccd vssd sg13cmos5l_decap_8
XFILLER_45_924 vccd vssd sg13cmos5l_decap_8
XFILLER_38_2000 vccd vssd sg13cmos5l_decap_8
XFILLER_22_1881 vccd vssd sg13cmos5l_decap_8
XFILLER_17_637 vccd vssd sg13cmos5l_decap_8
XFILLER_2_1953 vccd vssd sg13cmos5l_decap_8
XFILLER_18_2618 vccd vssd sg13cmos5l_decap_4
XFILLER_16_147 vccd vssd sg13cmos5l_decap_8
XFILLER_44_489 vccd vssd sg13cmos5l_decap_8
XFILLER_13_854 vccd vssd sg13cmos5l_decap_8
XFILLER_40_662 vccd vssd sg13cmos5l_decap_8
XFILLER_16_2353 vccd vssd sg13cmos5l_decap_8
XFILLER_16_1652 vccd vssd sg13cmos5l_decap_8
XFILLER_9_847 vccd vssd sg13cmos5l_decap_8
XFILLER_12_364 vccd vssd sg13cmos5l_decap_8
Xtiedowns\[82\] status[82] vccd vssd sg13cmos5l_antennanp
XFILLER_8_357 vccd vssd sg13cmos5l_decap_8
XFILLER_12_1505 vccd vssd sg13cmos5l_decap_8
XFILLER_21_91 vccd vssd sg13cmos5l_decap_8
XFILLER_45_2037 vccd vssd sg13cmos5l_decap_8
XFILLER_29_2769 vccd vssd sg13cmos5l_decap_8
XFILLER_4_574 vccd vssd sg13cmos5l_decap_8
XFILLER_10_1295 vccd vssd sg13cmos5l_decap_8
XFILLER_23_2302 vccd vssd sg13cmos5l_decap_8
XFILLER_45_1358 vccd vssd sg13cmos5l_decap_8
XFILLER_7_1820 vccd vssd sg13cmos5l_decap_8
XFILLER_39_217 vccd vssd sg13cmos5l_decap_8
XFILLER_27_1781 vccd vssd sg13cmos5l_decap_8
XFILLER_0_791 vccd vssd sg13cmos5l_decap_8
XFILLER_3_2429 vccd vssd sg13cmos5l_decap_8
XFILLER_7_1897 vccd vssd sg13cmos5l_decap_8
XFILLER_23_1678 vccd vssd sg13cmos5l_decap_8
XFILLER_21_2070 vccd vssd sg13cmos5l_decap_8
XFILLER_1_2142 vccd vssd sg13cmos5l_decap_8
XFILLER_36_2707 vccd vssd sg13cmos5l_decap_8
XFILLER_35_456 vccd vssd sg13cmos5l_decap_4
XFILLER_1_1463 vccd vssd sg13cmos5l_decap_8
XFILLER_34_2420 vccd vssd sg13cmos5l_decap_8
XFILLER_31_662 vccd vssd sg13cmos5l_decap_8
XFILLER_17_1449 vccd vssd sg13cmos5l_decap_8
XFILLER_34_2475 vccd vssd sg13cmos5l_decap_8
XFILLER_30_2328 vccd vssd sg13cmos5l_decap_8
XFILLER_30_161 vccd vssd sg13cmos5l_decap_8
XFILLER_34_1785 vccd vssd sg13cmos5l_decap_8
XFILLER_15_1162 vccd vssd sg13cmos5l_decap_8
XFILLER_12_2740 vccd vssd sg13cmos5l_decap_8
Xhold302 hold302/X _1671_/Q vccd vssd sg13cmos5l_dlygate4sd3_1
XFILLER_30_1638 vccd vssd sg13cmos5l_decap_8
X_1746_ _1746_/Q clkload1/A _1746_/D fanout121/X vccd vssd sg13cmos5l_dfrbpq_1
XFILLER_11_1015 vccd vssd sg13cmos5l_decap_8
Xhold324 hold324/X _1759_/Q vccd vssd sg13cmos5l_dlygate4sd3_1
Xhold335 _1672_/D _1425_/X vccd vssd sg13cmos5l_dlygate4sd3_1
Xhold313 _1670_/D _1423_/X vccd vssd sg13cmos5l_dlygate4sd3_1
X_1677_ _1677_/Q _1685_/CLK _1677_/D fanout139/X vccd vssd sg13cmos5l_dfrbpq_1
Xhold357 _1721_/D _1494_/X vccd vssd sg13cmos5l_dlygate4sd3_1
Xhold346 hold346/X _1711_/Q vccd vssd sg13cmos5l_dlygate4sd3_1
Xhold368 _1734_/D _1514_/X vccd vssd sg13cmos5l_dlygate4sd3_1
XFILLER_28_2224 vccd vssd sg13cmos5l_decap_8
XFILLER_28_1501 vccd vssd sg13cmos5l_decap_8
Xhold379 hold379/X _1701_/Q vccd vssd sg13cmos5l_dlygate4sd3_1
XFILLER_8_1617 vccd vssd sg13cmos5l_decap_8
XFILLER_41_1712 vccd vssd sg13cmos5l_decap_8
XFILLER_6_1330 vccd vssd sg13cmos5l_decap_8
XFILLER_27_902 vccd vssd sg13cmos5l_decap_8
XFILLER_6_2086 vccd vssd sg13cmos5l_decap_8
XFILLER_41_1789 vccd vssd sg13cmos5l_decap_8
XFILLER_26_14 vccd vssd sg13cmos5l_decap_8
XFILLER_22_1155 vccd vssd sg13cmos5l_decap_8
XFILLER_42_905 vccd vssd sg13cmos5l_decap_8
XFILLER_38_294 vccd vssd sg13cmos5l_decap_8
XFILLER_26_434 vccd vssd sg13cmos5l_decap_8
XFILLER_39_2364 vccd vssd sg13cmos5l_decap_8
XFILLER_39_1630 vccd vssd sg13cmos5l_decap_8
XFILLER_42_35 vccd vssd sg13cmos5l_decap_8
XFILLER_22_651 vccd vssd sg13cmos5l_decap_8
XFILLER_21_161 vccd vssd sg13cmos5l_decap_8
XFILLER_17_1972 vccd vssd sg13cmos5l_decap_8
XFILLER_33_1240 vccd vssd sg13cmos5l_decap_4
XFILLER_10_868 vccd vssd sg13cmos5l_decap_8
XFILLER_13_1869 vccd vssd sg13cmos5l_decap_8
XFILLER_1_511 vccd vssd sg13cmos5l_decap_8
XFILLER_11_1582 vccd vssd sg13cmos5l_decap_8
XFILLER_24_2622 vccd vssd sg13cmos5l_decap_8
XFILLER_1_588 vccd vssd sg13cmos5l_decap_8
XFILLER_4_2716 vccd vssd sg13cmos5l_decap_8
XFILLER_7_1127 vccd vssd sg13cmos5l_decap_8
XFILLER_24_2699 vccd vssd sg13cmos5l_decap_8
XFILLER_24_1943 vccd vssd sg13cmos5l_decap_8
XFILLER_45_721 vccd vssd sg13cmos5l_decap_8
XFILLER_18_924 vccd vssd sg13cmos5l_decap_8
XFILLER_44_220 vccd vssd sg13cmos5l_decap_8
XFILLER_29_294 vccd vssd sg13cmos5l_decap_8
XFILLER_17_434 vccd vssd sg13cmos5l_decap_8
XFILLER_2_1750 vccd vssd sg13cmos5l_decap_8
XFILLER_45_798 vccd vssd sg13cmos5l_decap_8
XFILLER_33_916 vccd vssd sg13cmos5l_decap_8
XFILLER_18_2448 vccd vssd sg13cmos5l_decap_8
XFILLER_41_971 vccd vssd sg13cmos5l_decap_8
XFILLER_38_1162 vccd vssd sg13cmos5l_decap_8
XFILLER_18_1736 vccd vssd sg13cmos5l_decap_8
XFILLER_16_91 vccd vssd sg13cmos5l_decap_8
XFILLER_13_651 vccd vssd sg13cmos5l_decap_8
XFILLER_35_2784 vccd vssd sg13cmos5l_decap_8
XFILLER_31_2626 vccd vssd sg13cmos5l_decap_8
XFILLER_9_644 vccd vssd sg13cmos5l_decap_8
XFILLER_12_161 vccd vssd sg13cmos5l_decap_8
XFILLER_31_1925 vccd vssd sg13cmos5l_decap_8
XFILLER_31_1914 vccd vssd sg13cmos5l_decap_8
XFILLER_8_154 vccd vssd sg13cmos5l_decap_8
XFILLER_12_1302 vccd vssd sg13cmos5l_decap_8
XFILLER_12_2058 vccd vssd sg13cmos5l_decap_8
X_1600_ _1600_/Y _1600_/A1 _1599_/B hold511/X vccd vssd sg13cmos5l_o21ai_1
XFILLER_12_1379 vccd vssd sg13cmos5l_decap_8
X_1531_ _1531_/Y _1588_/A _1531_/B vccd vssd sg13cmos5l_nand2_1
XFILLER_5_861 vccd vssd sg13cmos5l_decap_8
X_1462_ _1462_/X _1472_/A hold296/X _1462_/S vccd vssd sg13cmos5l_mux2_1
XFILLER_29_2566 vccd vssd sg13cmos5l_decap_8
XFILLER_29_1854 vccd vssd sg13cmos5l_decap_8
XFILLER_4_371 vccd vssd sg13cmos5l_decap_8
XFILLER_9_1904 vccd vssd sg13cmos5l_decap_8
XFILLER_9_2638 vccd vssd sg13cmos5l_decap_8
XFILLER_10_1092 vccd vssd sg13cmos5l_decap_8
XFILLER_45_1155 vccd vssd sg13cmos5l_decap_8
XFILLER_42_2755 vccd vssd sg13cmos5l_decap_8
XFILLER_25_1729 vccd vssd sg13cmos5l_decap_4
X_1393_ _1655_/D _1393_/A vccd vssd sg13cmos5l_inv_1
XFILLER_7_2373 vccd vssd sg13cmos5l_decap_8
Xtiedowns\[126\] status[126] vccd vssd sg13cmos5l_antennanp
XFILLER_23_2176 vccd vssd sg13cmos5l_decap_8
XFILLER_3_2226 vccd vssd sg13cmos5l_decap_8
XFILLER_3_1547 vccd vssd sg13cmos5l_decap_8
XFILLER_7_1694 vccd vssd sg13cmos5l_decap_8
XFILLER_35_231 vccd vssd sg13cmos5l_decap_8
XFILLER_36_787 vccd vssd sg13cmos5l_decap_8
XFILLER_24_938 vccd vssd sg13cmos5l_decap_8
XFILLER_1_1260 vccd vssd sg13cmos5l_decap_8
XFILLER_23_448 vccd vssd sg13cmos5l_decap_8
XFILLER_32_960 vccd vssd sg13cmos5l_decap_8
Xclkbuf_5_9_0_SCK clkload6/A clkbuf_5_9_0_SCK/A vccd vssd sg13cmos5l_buf_8
XFILLER_36_1869 vccd vssd sg13cmos5l_decap_8
XFILLER_17_1246 vccd vssd sg13cmos5l_decap_8
XFILLER_12_49 vccd vssd sg13cmos5l_decap_8
X_1729_ _1729_/Q clkload4/A _1729_/D fanout125/X vccd vssd sg13cmos5l_dfrbpq_1
XFILLER_2_308 vccd vssd sg13cmos5l_decap_8
Xhold176 _1647_/D _1411_/Y vccd vssd sg13cmos5l_dlygate4sd3_1
XFILLER_43_1807 vccd vssd sg13cmos5l_decap_4
XFILLER_28_2087 vccd vssd sg13cmos5l_decap_8
Xhold198 _0915_/A _1802_/Q vccd vssd sg13cmos5l_dlygate4sd3_1
XFILLER_8_1414 vccd vssd sg13cmos5l_decap_8
Xhold187 _0831_/A hold533/X vccd vssd sg13cmos5l_dlygate4sd3_1
XFILLER_43_1818 vccd vssd sg13cmos5l_decap_4
XFILLER_41_2265 vccd vssd sg13cmos5l_decap_8
XFILLER_41_1553 vccd vssd sg13cmos5l_decap_8
XFILLER_37_35 vccd vssd sg13cmos5l_decap_8
XFILLER_27_710 vccd vssd sg13cmos5l_decap_8
XFILLER_26_231 vccd vssd sg13cmos5l_decap_8
XFILLER_19_2713 vccd vssd sg13cmos5l_decap_8
XFILLER_2_1057 vccd vssd sg13cmos5l_decap_8
XFILLER_42_746 vccd vssd sg13cmos5l_decap_8
XFILLER_15_938 vccd vssd sg13cmos5l_decap_8
XFILLER_41_245 vccd vssd sg13cmos5l_decap_8
XFILLER_14_448 vccd vssd sg13cmos5l_decap_8
XFILLER_39_1493 vccd vssd sg13cmos5l_decap_8
XFILLER_13_2356 vccd vssd sg13cmos5l_decap_8
XFILLER_10_665 vccd vssd sg13cmos5l_decap_8
XFILLER_6_658 vccd vssd sg13cmos5l_decap_8
XFILLER_13_1666 vccd vssd sg13cmos5l_decap_8
XFILLER_30_1980 vccd vssd sg13cmos5l_decap_8
XFILLER_5_168 vccd vssd sg13cmos5l_decap_8
Xtiedowns\[45\] status[45] vccd vssd sg13cmos5l_antennanp
XFILLER_2_875 vccd vssd sg13cmos5l_decap_8
XFILLER_1_385 vccd vssd sg13cmos5l_decap_8
XFILLER_4_2513 vccd vssd sg13cmos5l_decap_8
XFILLER_20_2305 vccd vssd sg13cmos5l_decap_4
XFILLER_8_1981 vccd vssd sg13cmos5l_decap_8
XFILLER_24_1784 vccd vssd sg13cmos5l_decap_8
XFILLER_4_1834 vccd vssd sg13cmos5l_decap_8
XFILLER_40_1052 vccd vssd sg13cmos5l_decap_8
XFILLER_20_1626 vccd vssd sg13cmos5l_decap_8
XFILLER_18_721 vccd vssd sg13cmos5l_decap_8
XFILLER_17_231 vccd vssd sg13cmos5l_decap_8
XFILLER_45_595 vccd vssd sg13cmos5l_decap_8
XFILLER_18_2234 vccd vssd sg13cmos5l_decap_4
XFILLER_18_798 vccd vssd sg13cmos5l_decap_8
XFILLER_32_245 vccd vssd sg13cmos5l_decap_8
XFILLER_18_1533 vccd vssd sg13cmos5l_decap_8
XFILLER_35_2581 vccd vssd sg13cmos5l_decap_8
X_0962_ _1070_/B _0985_/A _1074_/A vccd vssd sg13cmos5l_or2_1
XFILLER_18_2278 vccd vssd sg13cmos5l_decap_8
XFILLER_9_441 vccd vssd sg13cmos5l_decap_8
XFILLER_35_1880 vccd vssd sg13cmos5l_decap_8
XFILLER_31_2467 vccd vssd sg13cmos5l_decap_8
X_0893_ _0894_/B _0896_/B _0898_/C _0898_/B vccd vssd sg13cmos5l_nand3b_1
XFILLER_31_1755 vccd vssd sg13cmos5l_decap_8
XFILLER_12_1176 vccd vssd sg13cmos5l_decap_8
X_1514_ _1514_/X _1560_/A hold367/X _1518_/S vccd vssd sg13cmos5l_mux2_1
XFILLER_25_2227 vccd vssd sg13cmos5l_decap_8
XFILLER_9_1701 vccd vssd sg13cmos5l_decap_8
XFILLER_9_2457 vccd vssd sg13cmos5l_decap_8
X_1445_ _1445_/Y _1445_/A _1451_/B vccd vssd sg13cmos5l_nor2_1
XFILLER_25_1526 vccd vssd sg13cmos5l_decap_8
XFILLER_42_2552 vccd vssd sg13cmos5l_decap_8
X_1376_ _1376_/Y _1716_/Q _1486_/B _1374_/Y _1375_/Y _1114_/B vccd vssd sg13cmos5l_a221oi_1
XFILLER_3_2023 vccd vssd sg13cmos5l_decap_8
XFILLER_7_2170 vccd vssd sg13cmos5l_decap_8
XFILLER_9_1778 vccd vssd sg13cmos5l_decap_8
XFILLER_23_1261 vccd vssd sg13cmos5l_decap_8
XFILLER_3_1344 vccd vssd sg13cmos5l_decap_8
XFILLER_7_1491 vccd vssd sg13cmos5l_decap_8
XFILLER_24_735 vccd vssd sg13cmos5l_decap_8
XFILLER_36_2356 vccd vssd sg13cmos5l_decap_8
XFILLER_23_245 vccd vssd sg13cmos5l_decap_8
XFILLER_36_1633 vccd vssd sg13cmos5l_decap_8
XFILLER_14_2621 vccd vssd sg13cmos5l_decap_8
XFILLER_36_1688 vccd vssd sg13cmos5l_decap_4
XFILLER_32_1519 vccd vssd sg13cmos5l_decap_8
XFILLER_32_790 vccd vssd sg13cmos5l_decap_8
XFILLER_20_952 vccd vssd sg13cmos5l_decap_8
XFILLER_17_1043 vccd vssd sg13cmos5l_decap_8
Xclkbuf_0_SCK clkbuf_0_SCK/X SCK vccd vssd sg13cmos5l_buf_8
XFILLER_14_1953 vccd vssd sg13cmos5l_decap_8
XFILLER_14_2665 vccd vssd sg13cmos5l_decap_8
XFILLER_10_1806 vccd vssd sg13cmos5l_decap_8
XFILLER_30_1276 vccd vssd sg13cmos5l_decap_8
XFILLER_3_7 vccd vssd sg13cmos5l_decap_8
XFILLER_2_105 vccd vssd sg13cmos5l_decap_8
XFILLER_8_1211 vccd vssd sg13cmos5l_decap_8
XFILLER_41_2062 vccd vssd sg13cmos5l_decap_8
XFILLER_21_2636 vccd vssd sg13cmos5l_decap_8
XFILLER_19_518 vccd vssd sg13cmos5l_decap_8
XFILLER_8_1288 vccd vssd sg13cmos5l_decap_8
XFILLER_3_2590 vccd vssd sg13cmos5l_decap_8
XFILLER_19_2532 vccd vssd sg13cmos5l_decap_8
XFILLER_15_735 vccd vssd sg13cmos5l_decap_8
XFILLER_42_543 vccd vssd sg13cmos5l_decap_8
XFILLER_14_245 vccd vssd sg13cmos5l_decap_8
XFILLER_35_1132 vccd vssd sg13cmos5l_decap_8
XFILLER_32_2721 vccd vssd sg13cmos5l_decap_8
XFILLER_19_2587 vccd vssd sg13cmos5l_decap_8
XFILLER_9_28 vccd vssd sg13cmos5l_decap_8
Xfanout60 _1362_/B1 _0998_/Y vccd vssd sg13cmos5l_buf_1
Xfanout82 _1029_/A _1197_/B vccd vssd sg13cmos5l_buf_1
Xfanout71 _1074_/C _1041_/X vccd vssd sg13cmos5l_buf_1
XFILLER_11_952 vccd vssd sg13cmos5l_decap_8
Xfanout93 fanout93/X _1666_/Q vccd vssd sg13cmos5l_buf_8
XFILLER_10_462 vccd vssd sg13cmos5l_decap_8
XFILLER_7_945 vccd vssd sg13cmos5l_decap_8
XFILLER_13_70 vccd vssd sg13cmos5l_decap_8
XFILLER_13_1463 vccd vssd sg13cmos5l_decap_8
XFILLER_6_455 vccd vssd sg13cmos5l_decap_8
XFILLER_6_2608 vccd vssd sg13cmos5l_decap_8
XFILLER_9_1008 vccd vssd sg13cmos5l_decap_8
XFILLER_36_7 vccd vssd sg13cmos5l_decap_8
XFILLER_26_2569 vccd vssd sg13cmos5l_decap_8
XFILLER_26_1824 vccd vssd sg13cmos5l_decap_8
XFILLER_2_672 vccd vssd sg13cmos5l_decap_8
X_1230_ _1230_/Y status[27] _1321_/B _1011_/X vccd vssd sg13cmos5l_o21ai_1
XFILLER_42_1125 vccd vssd sg13cmos5l_decap_8
XFILLER_1_182 vccd vssd sg13cmos5l_decap_8
XFILLER_4_2310 vccd vssd sg13cmos5l_decap_8
XFILLER_6_1918 vccd vssd sg13cmos5l_decap_8
XFILLER_42_1169 vccd vssd sg13cmos5l_decap_8
XFILLER_37_315 vccd vssd sg13cmos5l_decap_8
X_1161_ _1161_/Y _1158_/Y _1161_/B _1161_/C vccd vssd sg13cmos5l_nand3b_1
XFILLER_38_849 vccd vssd sg13cmos5l_decap_8
XFILLER_24_1581 vccd vssd sg13cmos5l_decap_8
XFILLER_20_2157 vccd vssd sg13cmos5l_decap_4
XFILLER_4_1631 vccd vssd sg13cmos5l_decap_8
XFILLER_4_2387 vccd vssd sg13cmos5l_decap_8
X_1092_ _1092_/Y status[78] _1225_/B _1089_/Y _1090_/Y _1091_/X vccd vssd sg13cmos5l_a221oi_1
XFILLER_37_2632 vccd vssd sg13cmos5l_decap_8
XFILLER_33_521 vccd vssd sg13cmos5l_decap_8
XFILLER_18_595 vccd vssd sg13cmos5l_decap_8
XFILLER_45_392 vccd vssd sg13cmos5l_decap_8
XFILLER_33_598 vccd vssd sg13cmos5l_decap_8
XFILLER_18_2053 vccd vssd sg13cmos5l_decap_8
XFILLER_18_1330 vccd vssd sg13cmos5l_decap_8
XFILLER_37_1975 vccd vssd sg13cmos5l_decap_8
XFILLER_33_1828 vccd vssd sg13cmos5l_decap_8
XFILLER_21_749 vccd vssd sg13cmos5l_decap_8
XFILLER_31_2264 vccd vssd sg13cmos5l_decap_8
XFILLER_31_2242 vccd vssd sg13cmos5l_decap_8
XFILLER_20_259 vccd vssd sg13cmos5l_decap_8
X_0945_ _0945_/Y _1809_/Q _1665_/Q vccd vssd sg13cmos5l_nand2_1
X_0876_ _0876_/Y _0876_/A vccd vssd sg13cmos5l_inv_1
XFILLER_44_2625 vccd vssd sg13cmos5l_decap_8
Xoutbuffers\[76\] control[76] _1744_/Q vccd vssd sg13cmos5l_buf_8
XFILLER_0_609 vccd vssd sg13cmos5l_decap_8
XFILLER_25_2035 vccd vssd sg13cmos5l_decap_8
XFILLER_5_2107 vccd vssd sg13cmos5l_decap_8
XFILLER_9_2254 vccd vssd sg13cmos5l_decap_8
X_1428_ _1428_/X _1472_/A hold423/X _1428_/S vccd vssd sg13cmos5l_mux2_1
XFILLER_9_1575 vccd vssd sg13cmos5l_decap_8
XFILLER_28_315 vccd vssd sg13cmos5l_decap_8
XFILLER_5_1428 vccd vssd sg13cmos5l_decap_8
X_1359_ _1364_/A status[80] _1359_/A2 _1358_/Y vccd vssd sg13cmos5l_a21oi_2
XFILLER_29_849 vccd vssd sg13cmos5l_decap_4
XFILLER_42_1692 vccd vssd sg13cmos5l_decap_8
XFILLER_23_1091 vccd vssd sg13cmos5l_decap_8
XFILLER_3_1141 vccd vssd sg13cmos5l_decap_8
XFILLER_0_2730 vccd vssd sg13cmos5l_decap_8
XFILLER_38_2429 vccd vssd sg13cmos5l_decap_8
XFILLER_36_392 vccd vssd sg13cmos5l_decap_8
XFILLER_34_14 vccd vssd sg13cmos5l_decap_8
XFILLER_24_532 vccd vssd sg13cmos5l_decap_8
XFILLER_19_1127 vccd vssd sg13cmos5l_decap_8
XFILLER_16_2727 vccd vssd sg13cmos5l_decap_8
XFILLER_36_1441 vccd vssd sg13cmos5l_decap_8
XFILLER_12_749 vccd vssd sg13cmos5l_decap_8
XFILLER_36_1485 vccd vssd sg13cmos5l_decap_8
Xclkload2 clkload2/Y clkload2/A vccd vssd sg13cmos5l_inv_1
XFILLER_11_259 vccd vssd sg13cmos5l_decap_8
XFILLER_14_1750 vccd vssd sg13cmos5l_decap_8
XFILLER_14_2484 vccd vssd sg13cmos5l_decap_8
XFILLER_30_1040 vccd vssd sg13cmos5l_decap_8
XFILLER_10_1603 vccd vssd sg13cmos5l_decap_8
XFILLER_10_2359 vccd vssd sg13cmos5l_decap_8
XFILLER_4_959 vccd vssd sg13cmos5l_decap_8
XFILLER_3_469 vccd vssd sg13cmos5l_decap_8
XFILLER_25_2580 vccd vssd sg13cmos5l_decap_8
XFILLER_21_2433 vccd vssd sg13cmos5l_decap_8
XFILLER_8_1085 vccd vssd sg13cmos5l_decap_8
XFILLER_19_315 vccd vssd sg13cmos5l_decap_8
XFILLER_1_2527 vccd vssd sg13cmos5l_decap_8
XFILLER_5_2696 vccd vssd sg13cmos5l_decap_8
XFILLER_21_1732 vccd vssd sg13cmos5l_decap_8
XFILLER_5_1995 vccd vssd sg13cmos5l_decap_8
XFILLER_34_329 vccd vssd sg13cmos5l_decap_8
XFILLER_28_882 vccd vssd sg13cmos5l_decap_8
XFILLER_1_1848 vccd vssd sg13cmos5l_decap_8
XFILLER_37_1216 vccd vssd sg13cmos5l_decap_8
XFILLER_27_392 vccd vssd sg13cmos5l_decap_8
XFILLER_15_532 vccd vssd sg13cmos5l_decap_8
XFILLER_43_896 vccd vssd sg13cmos5l_decap_8
XFILLER_24_91 vccd vssd sg13cmos5l_decap_8
XFILLER_19_1694 vccd vssd sg13cmos5l_decap_8
XFILLER_15_1547 vccd vssd sg13cmos5l_decap_8
XFILLER_32_2595 vccd vssd sg13cmos5l_decap_8
XFILLER_32_1850 vccd vssd sg13cmos5l_decap_8
XFILLER_7_742 vccd vssd sg13cmos5l_decap_8
XFILLER_6_252 vccd vssd sg13cmos5l_decap_8
XFILLER_13_1260 vccd vssd sg13cmos5l_decap_8
XFILLER_28_2609 vccd vssd sg13cmos5l_decap_8
XFILLER_26_2322 vccd vssd sg13cmos5l_decap_8
XFILLER_6_1715 vccd vssd sg13cmos5l_decap_8
XFILLER_26_1665 vccd vssd sg13cmos5l_decap_8
X_1213_ _1213_/Y _1211_/Y _1213_/B vccd vssd sg13cmos5l_nand2b_1
XFILLER_38_624 vccd vssd sg13cmos5l_decap_8
XFILLER_37_112 vccd vssd sg13cmos5l_decap_8
X_1144_ _1146_/B status[29] _1144_/B vccd vssd sg13cmos5l_nand2_1
XFILLER_26_819 vccd vssd sg13cmos5l_decap_8
XFILLER_0_2037 vccd vssd sg13cmos5l_decap_8
XFILLER_4_2184 vccd vssd sg13cmos5l_decap_8
XFILLER_39_2738 vccd vssd sg13cmos5l_decap_8
XFILLER_37_189 vccd vssd sg13cmos5l_decap_8
XFILLER_25_329 vccd vssd sg13cmos5l_decap_8
XFILLER_20_1253 vccd vssd sg13cmos5l_decap_8
XFILLER_19_882 vccd vssd sg13cmos5l_decap_8
XFILLER_1_84 vccd vssd sg13cmos5l_decap_8
X_1075_ _1076_/A _1036_/B _1041_/X _0888_/C vccd vssd sg13cmos5l_a21oi_1
XFILLER_18_392 vccd vssd sg13cmos5l_decap_8
XFILLER_0_1358 vccd vssd sg13cmos5l_decap_8
XFILLER_37_2462 vccd vssd sg13cmos5l_decap_8
XFILLER_21_546 vccd vssd sg13cmos5l_decap_8
XFILLER_37_1794 vccd vssd sg13cmos5l_decap_8
XFILLER_11_2602 vccd vssd sg13cmos5l_decap_8
XFILLER_31_2072 vccd vssd sg13cmos5l_decap_8
XFILLER_14_1057 vccd vssd sg13cmos5l_decap_8
X_0928_ _0928_/Y _0928_/A _0957_/S vccd vssd sg13cmos5l_nand2_1
X_0859_ _0859_/Y status[4] vccd vssd sg13cmos5l_inv_1
XFILLER_31_1393 vccd vssd sg13cmos5l_decap_8
XFILLER_20_49 vccd vssd sg13cmos5l_decap_8
XFILLER_11_1967 vccd vssd sg13cmos5l_decap_8
XFILLER_27_2108 vccd vssd sg13cmos5l_decap_8
XFILLER_44_2422 vccd vssd sg13cmos5l_decap_8
XFILLER_0_406 vccd vssd sg13cmos5l_decap_8
XFILLER_9_2051 vccd vssd sg13cmos5l_decap_8
XFILLER_44_1721 vccd vssd sg13cmos5l_decap_8
XFILLER_29_14 vccd vssd sg13cmos5l_decap_8
XFILLER_44_2499 vccd vssd sg13cmos5l_decap_8
XFILLER_9_1372 vccd vssd sg13cmos5l_decap_8
XFILLER_29_646 vccd vssd sg13cmos5l_decap_8
XFILLER_28_112 vccd vssd sg13cmos5l_decap_8
XFILLER_25_1175 vccd vssd sg13cmos5l_decap_8
XFILLER_22_2753 vccd vssd sg13cmos5l_decap_8
XFILLER_5_1225 vccd vssd sg13cmos5l_decap_8
XFILLER_17_819 vccd vssd sg13cmos5l_decap_8
XFILLER_45_35 vccd vssd sg13cmos5l_decap_8
XFILLER_44_627 vccd vssd sg13cmos5l_decap_8
XFILLER_28_189 vccd vssd sg13cmos5l_decap_8
XFILLER_16_329 vccd vssd sg13cmos5l_decap_8
XFILLER_40_811 vccd vssd sg13cmos5l_decap_8
XFILLER_25_885 vccd vssd sg13cmos5l_decap_8
XFILLER_12_546 vccd vssd sg13cmos5l_decap_8
XFILLER_40_866 vccd vssd sg13cmos5l_decap_8
XFILLER_32_1113 vccd vssd sg13cmos5l_decap_8
XFILLER_16_1834 vccd vssd sg13cmos5l_decap_8
XFILLER_8_539 vccd vssd sg13cmos5l_decap_8
XFILLER_10_1400 vccd vssd sg13cmos5l_decap_8
XFILLER_10_2156 vccd vssd sg13cmos5l_decap_8
XFILLER_45_2219 vccd vssd sg13cmos5l_decap_8
XFILLER_4_756 vccd vssd sg13cmos5l_decap_8
XFILLER_10_1477 vccd vssd sg13cmos5l_decap_8
XFILLER_3_266 vccd vssd sg13cmos5l_decap_8
XFILLER_7_2703 vccd vssd sg13cmos5l_decap_8
XFILLER_27_2686 vccd vssd sg13cmos5l_decap_8
XFILLER_7_2736 vccd vssd sg13cmos5l_decap_8
XFILLER_27_1974 vccd vssd sg13cmos5l_decap_8
XFILLER_0_973 vccd vssd sg13cmos5l_decap_8
XFILLER_7_2769 vccd vssd sg13cmos5l_decap_8
XFILLER_19_112 vccd vssd sg13cmos5l_decap_8
XFILLER_5_2471 vccd vssd sg13cmos5l_decap_8
XFILLER_19_91 vccd vssd sg13cmos5l_decap_8
XFILLER_1_2324 vccd vssd sg13cmos5l_decap_8
XFILLER_19_189 vccd vssd sg13cmos5l_decap_8
XFILLER_1_1645 vccd vssd sg13cmos5l_decap_8
XFILLER_5_1792 vccd vssd sg13cmos5l_decap_8
XFILLER_35_649 vccd vssd sg13cmos5l_decap_8
XFILLER_34_126 vccd vssd sg13cmos5l_decap_8
XFILLER_34_2602 vccd vssd sg13cmos5l_decap_8
XFILLER_42_170 vccd vssd sg13cmos5l_decap_4
XFILLER_31_844 vccd vssd sg13cmos5l_decap_8
XFILLER_19_2170 vccd vssd sg13cmos5l_decap_8
XFILLER_16_896 vccd vssd sg13cmos5l_decap_8
XFILLER_15_2023 vccd vssd sg13cmos5l_decap_8
XFILLER_34_2679 vccd vssd sg13cmos5l_decap_8
XFILLER_30_343 vccd vssd sg13cmos5l_decap_8
XFILLER_19_1491 vccd vssd sg13cmos5l_decap_8
XFILLER_15_1344 vccd vssd sg13cmos5l_decap_8
XFILLER_32_2381 vccd vssd sg13cmos5l_decap_8
X_1762_ _1762_/Q clkload8/A _1762_/D fanout120/X vccd vssd sg13cmos5l_dfrbpq_1
X_1693_ _1693_/Q _1699_/CLK _1693_/D _1638_/B_N vccd vssd sg13cmos5l_dfrbpq_1
Xhold506 hold506/X _1784_/Q vccd vssd sg13cmos5l_dlygate4sd3_1
Xhold517 _1666_/D _1416_/Y vccd vssd sg13cmos5l_dlygate4sd3_1
Xhold528 hold528/X _1793_/Q vccd vssd sg13cmos5l_dlygate4sd3_1
XFILLER_45_2786 vccd vssd sg13cmos5l_decap_4
XFILLER_44_1028 vccd vssd sg13cmos5l_decap_8
XFILLER_28_1749 vccd vssd sg13cmos5l_decap_8
XFILLER_26_2130 vccd vssd sg13cmos5l_decap_8
XFILLER_41_2628 vccd vssd sg13cmos5l_decap_8
XFILLER_26_1440 vccd vssd sg13cmos5l_decap_8
XFILLER_25_0 vccd vssd sg13cmos5l_decap_8
XFILLER_22_2027 vccd vssd sg13cmos5l_decap_8
XFILLER_6_1512 vccd vssd sg13cmos5l_decap_8
XFILLER_6_2268 vccd vssd sg13cmos5l_decap_8
XFILLER_39_944 vccd vssd sg13cmos5l_decap_4
XFILLER_22_1315 vccd vssd sg13cmos5l_decap_8
Xoutbuffers\[39\] control[39] _1707_/Q vccd vssd sg13cmos5l_buf_8
XFILLER_39_988 vccd vssd sg13cmos5l_decap_8
XFILLER_22_1359 vccd vssd sg13cmos5l_decap_4
XFILLER_6_1589 vccd vssd sg13cmos5l_decap_8
XFILLER_39_2535 vccd vssd sg13cmos5l_decap_8
X_1127_ _1127_/Y _0866_/Y _1389_/A2 _1125_/X _1126_/Y vccd vssd sg13cmos5l_a22oi_1
XFILLER_25_126 vccd vssd sg13cmos5l_decap_8
XFILLER_20_1050 vccd vssd sg13cmos5l_decap_8
X_1058_ _1058_/Y _1070_/A _1058_/B _1070_/C vccd vssd sg13cmos5l_nor3_1
XFILLER_0_1155 vccd vssd sg13cmos5l_decap_8
XFILLER_39_1867 vccd vssd sg13cmos5l_decap_8
XFILLER_22_833 vccd vssd sg13cmos5l_decap_8
XFILLER_15_49 vccd vssd sg13cmos5l_decap_8
XFILLER_21_343 vccd vssd sg13cmos5l_decap_8
XFILLER_11_2410 vccd vssd sg13cmos5l_decap_8
XFILLER_33_1466 vccd vssd sg13cmos5l_decap_4
XFILLER_11_2443 vccd vssd sg13cmos5l_decap_8
XFILLER_11_1764 vccd vssd sg13cmos5l_decap_8
XFILLER_0_203 vccd vssd sg13cmos5l_decap_8
XFILLER_7_1309 vccd vssd sg13cmos5l_decap_8
XFILLER_44_2285 vccd vssd sg13cmos5l_decap_8
XFILLER_40_2116 vccd vssd sg13cmos5l_decap_8
XFILLER_27_1248 vccd vssd sg13cmos5l_decap_8
XFILLER_22_2550 vccd vssd sg13cmos5l_decap_8
XFILLER_2_2611 vccd vssd sg13cmos5l_decap_8
XFILLER_5_1022 vccd vssd sg13cmos5l_decap_8
XFILLER_45_903 vccd vssd sg13cmos5l_decap_8
XFILLER_44_1595 vccd vssd sg13cmos5l_decap_8
XFILLER_40_1437 vccd vssd sg13cmos5l_decap_8
XFILLER_44_413 vccd vssd sg13cmos5l_decap_8
XFILLER_29_487 vccd vssd sg13cmos5l_decap_8
XFILLER_22_1860 vccd vssd sg13cmos5l_decap_8
XFILLER_17_616 vccd vssd sg13cmos5l_decap_8
XFILLER_2_2688 vccd vssd sg13cmos5l_decap_8
XFILLER_2_1932 vccd vssd sg13cmos5l_decap_8
XFILLER_5_1099 vccd vssd sg13cmos5l_decap_8
XFILLER_16_126 vccd vssd sg13cmos5l_decap_8
XFILLER_44_468 vccd vssd sg13cmos5l_decap_8
XFILLER_38_2056 vccd vssd sg13cmos5l_decap_8
XFILLER_25_682 vccd vssd sg13cmos5l_decap_8
XFILLER_13_833 vccd vssd sg13cmos5l_decap_8
XFILLER_40_641 vccd vssd sg13cmos5l_decap_8
XFILLER_38_1388 vccd vssd sg13cmos5l_decap_8
XFILLER_9_826 vccd vssd sg13cmos5l_decap_8
XFILLER_12_343 vccd vssd sg13cmos5l_decap_8
XFILLER_16_1631 vccd vssd sg13cmos5l_decap_8
XFILLER_8_336 vccd vssd sg13cmos5l_decap_8
XFILLER_12_2229 vccd vssd sg13cmos5l_decap_8
Xtiedowns\[75\] status[75] vccd vssd sg13cmos5l_antennanp
XFILLER_21_70 vccd vssd sg13cmos5l_decap_8
XFILLER_45_2016 vccd vssd sg13cmos5l_decap_8
XFILLER_29_2748 vccd vssd sg13cmos5l_decap_8
XFILLER_4_553 vccd vssd sg13cmos5l_decap_8
XFILLER_10_1274 vccd vssd sg13cmos5l_decap_8
XFILLER_27_2450 vccd vssd sg13cmos5l_decap_8
XFILLER_45_1337 vccd vssd sg13cmos5l_decap_8
XFILLER_0_770 vccd vssd sg13cmos5l_decap_8
XFILLER_3_2408 vccd vssd sg13cmos5l_decap_8
XFILLER_7_2588 vccd vssd sg13cmos5l_decap_8
XFILLER_23_1657 vccd vssd sg13cmos5l_decap_8
XFILLER_3_1729 vccd vssd sg13cmos5l_decap_8
XFILLER_1_2121 vccd vssd sg13cmos5l_decap_8
XFILLER_7_1876 vccd vssd sg13cmos5l_decap_8
XFILLER_40_2694 vccd vssd sg13cmos5l_decap_8
XFILLER_35_413 vccd vssd sg13cmos5l_decap_8
XFILLER_1_2198 vccd vssd sg13cmos5l_decap_8
XFILLER_1_1442 vccd vssd sg13cmos5l_decap_8
XFILLER_16_693 vccd vssd sg13cmos5l_decap_8
XFILLER_34_2454 vccd vssd sg13cmos5l_decap_8
XFILLER_17_1428 vccd vssd sg13cmos5l_decap_8
XFILLER_34_1753 vccd vssd sg13cmos5l_decap_4
XFILLER_30_2307 vccd vssd sg13cmos5l_decap_8
XFILLER_30_140 vccd vssd sg13cmos5l_decap_8
XFILLER_30_1617 vccd vssd sg13cmos5l_decap_8
XFILLER_15_1141 vccd vssd sg13cmos5l_decap_8
X_1745_ _1745_/Q clkload4/A _1745_/D fanout123/X vccd vssd sg13cmos5l_dfrbpq_1
Xhold325 _1759_/D _1550_/X vccd vssd sg13cmos5l_dlygate4sd3_1
Xhold314 hold314/X _1737_/Q vccd vssd sg13cmos5l_dlygate4sd3_1
Xhold303 _1671_/D _1424_/X vccd vssd sg13cmos5l_dlygate4sd3_1
Xhold336 hold336/X _1745_/Q vccd vssd sg13cmos5l_dlygate4sd3_1
X_1676_ _1676_/Q _1682_/CLK _1676_/D fanout137/X vccd vssd sg13cmos5l_dfrbpq_1
Xhold369 hold369/X _1703_/Q vccd vssd sg13cmos5l_dlygate4sd3_1
Xhold347 _1711_/D _1480_/X vccd vssd sg13cmos5l_dlygate4sd3_1
Xhold358 hold358/X _1747_/Q vccd vssd sg13cmos5l_dlygate4sd3_1
XFILLER_45_2583 vccd vssd sg13cmos5l_decap_8
XFILLER_41_2436 vccd vssd sg13cmos5l_decap_8
XFILLER_6_2065 vccd vssd sg13cmos5l_decap_8
XFILLER_22_1134 vccd vssd sg13cmos5l_decap_8
XFILLER_41_1768 vccd vssd sg13cmos5l_decap_8
XFILLER_38_273 vccd vssd sg13cmos5l_decap_8
XFILLER_26_413 vccd vssd sg13cmos5l_decap_8
XFILLER_2_1239 vccd vssd sg13cmos5l_decap_8
XFILLER_6_1386 vccd vssd sg13cmos5l_decap_8
XFILLER_39_2332 vccd vssd sg13cmos5l_decap_8
XFILLER_41_449 vccd vssd sg13cmos5l_decap_8
XFILLER_35_2218 vccd vssd sg13cmos5l_decap_8
XFILLER_42_14 vccd vssd sg13cmos5l_decap_8
XFILLER_39_1686 vccd vssd sg13cmos5l_decap_8
XFILLER_35_1517 vccd vssd sg13cmos5l_decap_8
XFILLER_22_630 vccd vssd sg13cmos5l_decap_8
XFILLER_21_140 vccd vssd sg13cmos5l_decap_8
XFILLER_17_2685 vccd vssd sg13cmos5l_decap_8
XFILLER_17_1951 vccd vssd sg13cmos5l_decap_8
XFILLER_13_2538 vccd vssd sg13cmos5l_decap_8
XFILLER_10_847 vccd vssd sg13cmos5l_decap_8
XFILLER_13_1848 vccd vssd sg13cmos5l_decap_8
XFILLER_11_2284 vccd vssd sg13cmos5l_decap_8
XFILLER_11_1561 vccd vssd sg13cmos5l_decap_8
XFILLER_28_2770 vccd vssd sg13cmos5l_decap_8
XFILLER_27_1012 vccd vssd sg13cmos5l_decap_8
XFILLER_24_2601 vccd vssd sg13cmos5l_decap_8
XFILLER_27_1045 vccd vssd sg13cmos5l_decap_4
XFILLER_1_567 vccd vssd sg13cmos5l_decap_8
XFILLER_7_1106 vccd vssd sg13cmos5l_decap_8
XFILLER_44_2082 vccd vssd sg13cmos5l_decap_8
XFILLER_44_1392 vccd vssd sg13cmos5l_decap_8
XFILLER_40_1223 vccd vssd sg13cmos5l_decap_8
XFILLER_24_2678 vccd vssd sg13cmos5l_decap_8
XFILLER_18_903 vccd vssd sg13cmos5l_decap_8
XFILLER_45_700 vccd vssd sg13cmos5l_decap_8
XFILLER_29_273 vccd vssd sg13cmos5l_decap_8
XFILLER_17_413 vccd vssd sg13cmos5l_decap_8
XFILLER_22_1690 vccd vssd sg13cmos5l_decap_8
XFILLER_2_2485 vccd vssd sg13cmos5l_decap_8
XFILLER_45_777 vccd vssd sg13cmos5l_decap_8
XFILLER_44_287 vccd vssd sg13cmos5l_decap_8
XFILLER_38_1141 vccd vssd sg13cmos5l_decap_8
XFILLER_32_427 vccd vssd sg13cmos5l_decap_8
XFILLER_18_2427 vccd vssd sg13cmos5l_decap_8
XFILLER_18_1715 vccd vssd sg13cmos5l_decap_8
XFILLER_16_70 vccd vssd sg13cmos5l_decap_8
XFILLER_41_950 vccd vssd sg13cmos5l_decap_8
XFILLER_35_2763 vccd vssd sg13cmos5l_decap_8
XFILLER_25_490 vccd vssd sg13cmos5l_decap_8
XFILLER_13_630 vccd vssd sg13cmos5l_decap_8
XFILLER_31_2605 vccd vssd sg13cmos5l_decap_8
XFILLER_9_623 vccd vssd sg13cmos5l_decap_8
XFILLER_12_140 vccd vssd sg13cmos5l_decap_8
XFILLER_31_1904 vccd vssd sg13cmos5l_decap_4
XFILLER_16_2195 vccd vssd sg13cmos5l_decap_8
XFILLER_8_133 vccd vssd sg13cmos5l_decap_8
XFILLER_12_2037 vccd vssd sg13cmos5l_decap_8
XFILLER_32_91 vccd vssd sg13cmos5l_decap_8
XFILLER_5_840 vccd vssd sg13cmos5l_decap_8
XFILLER_12_1358 vccd vssd sg13cmos5l_decap_8
X_1530_ _1530_/X _1542_/A hold358/X _1530_/S vccd vssd sg13cmos5l_mux2_1
XFILLER_29_2545 vccd vssd sg13cmos5l_decap_8
XFILLER_4_350 vccd vssd sg13cmos5l_decap_8
X_1461_ _1461_/X _1553_/A hold439/X _1461_/S vccd vssd sg13cmos5l_mux2_1
XFILLER_29_1822 vccd vssd sg13cmos5l_decap_8
XFILLER_25_2409 vccd vssd sg13cmos5l_decap_8
XFILLER_10_1071 vccd vssd sg13cmos5l_decap_8
XFILLER_45_1134 vccd vssd sg13cmos5l_decap_8
XFILLER_25_1708 vccd vssd sg13cmos5l_decap_8
X_1392_ _1393_/A _1808_/Q _1520_/A _0904_/B vccd vssd sg13cmos5l_o21ai_1
XFILLER_42_2734 vccd vssd sg13cmos5l_decap_8
XFILLER_3_2205 vccd vssd sg13cmos5l_decap_8
XFILLER_7_2352 vccd vssd sg13cmos5l_decap_8
XFILLER_23_2155 vccd vssd sg13cmos5l_decap_8
XFILLER_7_1673 vccd vssd sg13cmos5l_decap_8
Xtiedowns\[119\] status[119] vccd vssd sg13cmos5l_antennanp
XFILLER_23_1443 vccd vssd sg13cmos5l_decap_8
XFILLER_3_1526 vccd vssd sg13cmos5l_decap_8
XFILLER_40_2491 vccd vssd sg13cmos5l_decap_8
XFILLER_35_210 vccd vssd sg13cmos5l_decap_8
XFILLER_23_1498 vccd vssd sg13cmos5l_decap_8
XFILLER_36_766 vccd vssd sg13cmos5l_decap_8
XFILLER_24_917 vccd vssd sg13cmos5l_decap_8
XFILLER_35_287 vccd vssd sg13cmos5l_decap_8
XFILLER_23_427 vccd vssd sg13cmos5l_decap_8
XFILLER_17_980 vccd vssd sg13cmos5l_decap_8
XFILLER_17_1225 vccd vssd sg13cmos5l_decap_8
XFILLER_16_490 vccd vssd sg13cmos5l_decap_8
Xoutbuffers\[2\] control[2] _1670_/Q vccd vssd sg13cmos5l_buf_8
XFILLER_30_2104 vccd vssd sg13cmos5l_decap_8
XFILLER_34_1583 vccd vssd sg13cmos5l_decap_8
XFILLER_12_28 vccd vssd sg13cmos5l_decap_8
XFILLER_30_1447 vccd vssd sg13cmos5l_decap_4
X_1728_ _1728_/Q _1736_/CLK _1728_/D fanout125/X vccd vssd sg13cmos5l_dfrbpq_1
Xhold177 _0883_/A _1809_/Q vccd vssd sg13cmos5l_dlygate4sd3_1
X_1659_ _1659_/Q _1659_/CLK _1659_/D _1605_/Y vccd vssd sg13cmos5l_dfrbpq_1
XFILLER_28_2066 vccd vssd sg13cmos5l_decap_8
Xhold199 hold199/X _0921_/Y vccd vssd sg13cmos5l_dlygate4sd3_1
XFILLER_8_2149 vccd vssd sg13cmos5l_decap_8
Xhold188 hold188/X _0831_/Y vccd vssd sg13cmos5l_dlygate4sd3_1
XFILLER_45_2380 vccd vssd sg13cmos5l_decap_8
XFILLER_41_2244 vccd vssd sg13cmos5l_decap_8
XFILLER_41_1510 vccd vssd sg13cmos5l_decap_8
XFILLER_37_14 vccd vssd sg13cmos5l_decap_8
XFILLER_26_210 vccd vssd sg13cmos5l_decap_8
XFILLER_2_1036 vccd vssd sg13cmos5l_decap_8
XFILLER_3_2772 vccd vssd sg13cmos5l_decap_8
XFILLER_6_1183 vccd vssd sg13cmos5l_decap_8
XFILLER_27_777 vccd vssd sg13cmos5l_decap_8
XFILLER_15_917 vccd vssd sg13cmos5l_decap_8
XFILLER_41_224 vccd vssd sg13cmos5l_decap_8
XFILLER_39_2162 vccd vssd sg13cmos5l_decap_8
XFILLER_27_799 vccd vssd sg13cmos5l_decap_8
XFILLER_26_287 vccd vssd sg13cmos5l_decap_8
XFILLER_14_427 vccd vssd sg13cmos5l_decap_8
XFILLER_19_2769 vccd vssd sg13cmos5l_decap_8
XFILLER_35_1347 vccd vssd sg13cmos5l_decap_8
XFILLER_23_994 vccd vssd sg13cmos5l_decap_8
XFILLER_10_644 vccd vssd sg13cmos5l_decap_8
XFILLER_13_2335 vccd vssd sg13cmos5l_decap_8
XFILLER_17_1792 vccd vssd sg13cmos5l_decap_8
XFILLER_13_1645 vccd vssd sg13cmos5l_decap_8
XFILLER_6_637 vccd vssd sg13cmos5l_decap_8
XFILLER_5_147 vccd vssd sg13cmos5l_decap_8
XFILLER_29_1129 vccd vssd sg13cmos5l_decap_8
XFILLER_42_2008 vccd vssd sg13cmos5l_decap_8
XFILLER_2_854 vccd vssd sg13cmos5l_decap_8
XFILLER_1_364 vccd vssd sg13cmos5l_decap_8
XFILLER_8_2683 vccd vssd sg13cmos5l_decap_8
Xtiedowns\[38\] status[38] vccd vssd sg13cmos5l_antennanp
XFILLER_8_1960 vccd vssd sg13cmos5l_decap_8
XFILLER_40_1031 vccd vssd sg13cmos5l_decap_8
XFILLER_24_1763 vccd vssd sg13cmos5l_decap_8
XFILLER_20_2339 vccd vssd sg13cmos5l_decap_8
XFILLER_20_1605 vccd vssd sg13cmos5l_decap_8
XFILLER_18_700 vccd vssd sg13cmos5l_decap_8
XFILLER_4_1813 vccd vssd sg13cmos5l_decap_8
XFILLER_4_2569 vccd vssd sg13cmos5l_decap_8
XFILLER_17_210 vccd vssd sg13cmos5l_decap_8
XFILLER_18_777 vccd vssd sg13cmos5l_decap_8
XFILLER_2_2282 vccd vssd sg13cmos5l_decap_8
XFILLER_45_574 vccd vssd sg13cmos5l_decap_8
XFILLER_27_91 vccd vssd sg13cmos5l_decap_8
XFILLER_18_2213 vccd vssd sg13cmos5l_decap_8
XFILLER_17_287 vccd vssd sg13cmos5l_decap_8
XFILLER_32_224 vccd vssd sg13cmos5l_decap_8
XFILLER_18_2257 vccd vssd sg13cmos5l_decap_8
XFILLER_18_1512 vccd vssd sg13cmos5l_decap_8
XFILLER_35_2560 vccd vssd sg13cmos5l_decap_8
X_0961_ _0961_/Y _1036_/A _1067_/A vccd vssd sg13cmos5l_nand2_1
XFILLER_14_994 vccd vssd sg13cmos5l_decap_8
XFILLER_31_2446 vccd vssd sg13cmos5l_decap_8
XFILLER_31_2424 vccd vssd sg13cmos5l_decap_8
XFILLER_18_1589 vccd vssd sg13cmos5l_decap_8
XFILLER_9_420 vccd vssd sg13cmos5l_decap_8
XFILLER_31_1734 vccd vssd sg13cmos5l_decap_8
X_0892_ _0895_/B _1394_/B _1403_/A _0898_/C vccd vssd sg13cmos5l_o21ai_1
XFILLER_9_497 vccd vssd sg13cmos5l_decap_8
XFILLER_12_1155 vccd vssd sg13cmos5l_decap_8
X_1513_ _1513_/X _1591_/A0 hold413/X _1518_/S vccd vssd sg13cmos5l_mux2_1
XFILLER_29_2331 vccd vssd sg13cmos5l_decap_4
XFILLER_25_2206 vccd vssd sg13cmos5l_decap_8
XFILLER_9_2436 vccd vssd sg13cmos5l_decap_8
X_1444_ _1444_/Y hold262/X _1449_/B _1443_/Y vccd vssd sg13cmos5l_a21oi_1
XFILLER_25_1505 vccd vssd sg13cmos5l_decap_8
XFILLER_4_84 vccd vssd sg13cmos5l_decap_8
XFILLER_9_1757 vccd vssd sg13cmos5l_decap_8
X_1375_ _1375_/Y _0837_/Y _1498_/B _1486_/B vccd vssd sg13cmos5l_a21oi_1
XFILLER_3_2002 vccd vssd sg13cmos5l_decap_8
XFILLER_7_1470 vccd vssd sg13cmos5l_decap_8
XFILLER_3_2079 vccd vssd sg13cmos5l_decap_8
XFILLER_3_1323 vccd vssd sg13cmos5l_decap_8
Xoutbuffers\[21\] control[21] _1689_/Q vccd vssd sg13cmos5l_buf_8
XFILLER_36_541 vccd vssd sg13cmos5l_decap_8
XFILLER_24_714 vccd vssd sg13cmos5l_decap_8
XFILLER_19_1309 vccd vssd sg13cmos5l_decap_8
XFILLER_36_2335 vccd vssd sg13cmos5l_decap_8
XFILLER_36_1612 vccd vssd sg13cmos5l_decap_8
XFILLER_23_224 vccd vssd sg13cmos5l_decap_8
XFILLER_17_1022 vccd vssd sg13cmos5l_decap_8
XFILLER_23_49 vccd vssd sg13cmos5l_decap_8
XFILLER_20_931 vccd vssd sg13cmos5l_decap_8
XFILLER_17_1099 vccd vssd sg13cmos5l_decap_8
XFILLER_14_1932 vccd vssd sg13cmos5l_decap_8
XFILLER_14_2699 vccd vssd sg13cmos5l_decap_8
XFILLER_30_1266 vccd vssd sg13cmos5l_decap_4
XFILLER_28_1162 vccd vssd sg13cmos5l_decap_8
XFILLER_28_1140 vccd vssd sg13cmos5l_decap_8
XFILLER_43_1627 vccd vssd sg13cmos5l_decap_8
XFILLER_41_2041 vccd vssd sg13cmos5l_decap_8
XFILLER_25_2784 vccd vssd sg13cmos5l_decap_8
XFILLER_21_2615 vccd vssd sg13cmos5l_decap_8
XFILLER_8_1267 vccd vssd sg13cmos5l_decap_8
XFILLER_1_2709 vccd vssd sg13cmos5l_decap_8
XFILLER_21_1925 vccd vssd sg13cmos5l_decap_8
XFILLER_41_1384 vccd vssd sg13cmos5l_decap_8
XFILLER_42_522 vccd vssd sg13cmos5l_decap_8
XFILLER_19_2511 vccd vssd sg13cmos5l_decap_8
XFILLER_15_714 vccd vssd sg13cmos5l_decap_8
XFILLER_3_1890 vccd vssd sg13cmos5l_decap_8
XFILLER_19_2566 vccd vssd sg13cmos5l_decap_8
XFILLER_14_224 vccd vssd sg13cmos5l_decap_8
XFILLER_35_1111 vccd vssd sg13cmos5l_decap_8
XFILLER_32_2700 vccd vssd sg13cmos5l_decap_8
XFILLER_19_1854 vccd vssd sg13cmos5l_decap_8
Xfanout61 _1315_/B1 _0996_/Y vccd vssd sg13cmos5l_buf_1
Xfanout50 _1366_/B1 _1018_/Y vccd vssd sg13cmos5l_buf_1
Xfanout72 _1309_/B1 wire73/X vccd vssd sg13cmos5l_buf_1
Xfanout83 _1197_/B _0952_/Y vccd vssd sg13cmos5l_buf_2
XFILLER_23_791 vccd vssd sg13cmos5l_decap_8
XFILLER_15_1729 vccd vssd sg13cmos5l_decap_8
XFILLER_11_931 vccd vssd sg13cmos5l_decap_8
XFILLER_13_2121 vccd vssd sg13cmos5l_decap_8
Xfanout94 _1542_/A _1472_/A vccd vssd sg13cmos5l_buf_1
XFILLER_32_2777 vccd vssd sg13cmos5l_decap_8
XFILLER_7_924 vccd vssd sg13cmos5l_decap_8
XFILLER_10_441 vccd vssd sg13cmos5l_decap_8
XFILLER_6_434 vccd vssd sg13cmos5l_decap_8
XFILLER_13_1442 vccd vssd sg13cmos5l_decap_8
XFILLER_30_2490 vccd vssd sg13cmos5l_decap_8
XFILLER_2_651 vccd vssd sg13cmos5l_decap_8
Xclkbuf_5_8_0_SCK _1779_/CLK clkbuf_5_9_0_SCK/A vccd vssd sg13cmos5l_buf_8
XFILLER_26_2548 vccd vssd sg13cmos5l_decap_8
XFILLER_26_1803 vccd vssd sg13cmos5l_decap_8
XFILLER_1_161 vccd vssd sg13cmos5l_decap_8
XFILLER_29_7 vccd vssd sg13cmos5l_decap_8
XFILLER_42_1148 vccd vssd sg13cmos5l_decap_8
XFILLER_38_828 vccd vssd sg13cmos5l_decap_8
X_1160_ _1161_/C _1713_/Q _1114_/B _1162_/B vccd vssd sg13cmos5l_a21oi_1
XFILLER_26_1869 vccd vssd sg13cmos5l_decap_8
XFILLER_20_2125 vccd vssd sg13cmos5l_decap_4
XFILLER_4_1610 vccd vssd sg13cmos5l_decap_8
XFILLER_0_2219 vccd vssd sg13cmos5l_decap_8
XFILLER_4_2366 vccd vssd sg13cmos5l_decap_8
X_1091_ _1091_/X status[70] _1314_/B _1315_/B1 vccd vssd sg13cmos5l_a21o_1
XFILLER_20_1435 vccd vssd sg13cmos5l_decap_4
XFILLER_4_1687 vccd vssd sg13cmos5l_decap_8
XFILLER_45_371 vccd vssd sg13cmos5l_decap_8
XFILLER_37_2611 vccd vssd sg13cmos5l_decap_8
XFILLER_20_1479 vccd vssd sg13cmos5l_decap_8
XFILLER_18_574 vccd vssd sg13cmos5l_decap_8
Xoutbuffers\[111\] control[111] _1779_/Q vccd vssd sg13cmos5l_buf_8
XFILLER_37_2688 vccd vssd sg13cmos5l_decap_8
XFILLER_37_1932 vccd vssd sg13cmos5l_decap_8
XFILLER_33_577 vccd vssd sg13cmos5l_decap_8
XFILLER_21_728 vccd vssd sg13cmos5l_decap_8
XFILLER_33_1807 vccd vssd sg13cmos5l_decap_8
XFILLER_20_238 vccd vssd sg13cmos5l_decap_8
XFILLER_14_791 vccd vssd sg13cmos5l_decap_8
X_0944_ _0944_/Y _1407_/A _1403_/B _0904_/B _0902_/Y vccd vssd sg13cmos5l_a22oi_1
XFILLER_18_1386 vccd vssd sg13cmos5l_decap_8
XFILLER_14_1239 vccd vssd sg13cmos5l_decap_8
X_0875_ _0875_/Y _0875_/A vccd vssd sg13cmos5l_inv_1
XFILLER_9_294 vccd vssd sg13cmos5l_decap_8
Xclkload20 clkload20/Y _1802_/CLK vccd vssd sg13cmos5l_inv_1
XFILLER_31_1564 vccd vssd sg13cmos5l_decap_8
XFILLER_44_2604 vccd vssd sg13cmos5l_decap_8
XFILLER_9_2233 vccd vssd sg13cmos5l_decap_8
Xoutbuffers\[69\] control[69] _1737_/Q vccd vssd sg13cmos5l_buf_8
XFILLER_25_2014 vccd vssd sg13cmos5l_decap_8
X_1427_ _1427_/X _1495_/A hold385/X _1428_/S vccd vssd sg13cmos5l_mux2_1
XFILLER_5_1407 vccd vssd sg13cmos5l_decap_8
XFILLER_9_1554 vccd vssd sg13cmos5l_decap_8
XFILLER_29_828 vccd vssd sg13cmos5l_decap_8
X_1358_ _1358_/Y _0836_/Y _1358_/A2 _1356_/Y _1357_/Y _1261_/B vccd vssd sg13cmos5l_a221oi_1
XFILLER_18_49 vccd vssd sg13cmos5l_decap_8
XFILLER_3_1120 vccd vssd sg13cmos5l_decap_8
X_1289_ _1289_/Y _1726_/Q _1036_/Y _1288_/Y vccd vssd sg13cmos5l_o21ai_1
XFILLER_23_1070 vccd vssd sg13cmos5l_decap_8
XFILLER_20_2681 vccd vssd sg13cmos5l_decap_8
XFILLER_37_894 vccd vssd sg13cmos5l_decap_8
XFILLER_36_371 vccd vssd sg13cmos5l_decap_8
XFILLER_24_511 vccd vssd sg13cmos5l_decap_8
XFILLER_3_1197 vccd vssd sg13cmos5l_decap_8
XFILLER_0_2786 vccd vssd sg13cmos5l_decap_4
XFILLER_20_1980 vccd vssd sg13cmos5l_decap_8
XFILLER_19_1106 vccd vssd sg13cmos5l_decap_8
XFILLER_16_2706 vccd vssd sg13cmos5l_decap_8
XFILLER_36_2165 vccd vssd sg13cmos5l_decap_4
XFILLER_24_588 vccd vssd sg13cmos5l_decap_8
XFILLER_12_728 vccd vssd sg13cmos5l_decap_8
XFILLER_36_1464 vccd vssd sg13cmos5l_decap_8
XFILLER_11_238 vccd vssd sg13cmos5l_decap_8
Xclkload3 clkload3/Y clkload3/A vccd vssd sg13cmos5l_inv_1
XFILLER_10_2338 vccd vssd sg13cmos5l_decap_8
XFILLER_4_938 vccd vssd sg13cmos5l_decap_8
XFILLER_10_1659 vccd vssd sg13cmos5l_decap_8
XFILLER_30_1096 vccd vssd sg13cmos5l_decap_8
XFILLER_3_448 vccd vssd sg13cmos5l_decap_8
XFILLER_43_1446 vccd vssd sg13cmos5l_decap_8
XFILLER_21_2412 vccd vssd sg13cmos5l_decap_8
XFILLER_8_1064 vccd vssd sg13cmos5l_decap_8
XFILLER_25_1891 vccd vssd sg13cmos5l_decap_8
XFILLER_21_1711 vccd vssd sg13cmos5l_decap_8
XFILLER_1_2506 vccd vssd sg13cmos5l_decap_8
XFILLER_5_2675 vccd vssd sg13cmos5l_decap_8
XFILLER_28_850 vccd vssd sg13cmos5l_decap_8
XFILLER_21_2489 vccd vssd sg13cmos5l_decap_8
XFILLER_1_1827 vccd vssd sg13cmos5l_decap_8
XFILLER_5_1974 vccd vssd sg13cmos5l_decap_8
XFILLER_41_1192 vccd vssd sg13cmos5l_decap_8
XFILLER_34_308 vccd vssd sg13cmos5l_decap_8
XFILLER_27_371 vccd vssd sg13cmos5l_decap_8
XFILLER_15_511 vccd vssd sg13cmos5l_decap_8
XFILLER_42_341 vccd vssd sg13cmos5l_decap_4
XFILLER_19_2385 vccd vssd sg13cmos5l_decap_8
XFILLER_15_588 vccd vssd sg13cmos5l_decap_8
XFILLER_30_536 vccd vssd sg13cmos5l_decap_8
XFILLER_19_1673 vccd vssd sg13cmos5l_decap_8
XFILLER_24_70 vccd vssd sg13cmos5l_decap_8
XFILLER_15_1526 vccd vssd sg13cmos5l_decap_8
XFILLER_32_2574 vccd vssd sg13cmos5l_decap_8
XFILLER_7_721 vccd vssd sg13cmos5l_decap_8
XFILLER_6_231 vccd vssd sg13cmos5l_decap_8
XFILLER_7_798 vccd vssd sg13cmos5l_decap_8
XFILLER_40_91 vccd vssd sg13cmos5l_decap_8
XFILLER_38_603 vccd vssd sg13cmos5l_decap_8
X_1212_ _1213_/B mask_rev_in[12] _1306_/B _1347_/B1 vccd vssd sg13cmos5l_a21oi_1
XFILLER_4_2163 vccd vssd sg13cmos5l_decap_8
X_1143_ _1146_/A _1141_/X _1140_/Y _1142_/Y vccd vssd sg13cmos5l_o21ai_1
XFILLER_39_2717 vccd vssd sg13cmos5l_decap_8
XFILLER_38_658 vccd vssd sg13cmos5l_decap_8
XFILLER_20_1232 vccd vssd sg13cmos5l_decap_8
XFILLER_19_861 vccd vssd sg13cmos5l_decap_8
XFILLER_0_2016 vccd vssd sg13cmos5l_decap_8
XFILLER_1_63 vccd vssd sg13cmos5l_decap_8
Xtiedowns\[101\] status[101] vccd vssd sg13cmos5l_antennanp
XFILLER_37_168 vccd vssd sg13cmos5l_decap_8
XFILLER_25_308 vccd vssd sg13cmos5l_decap_8
X_1074_ _1351_/A _1074_/A _1074_/B _1074_/C vccd vssd sg13cmos5l_nand3_1
XFILLER_18_371 vccd vssd sg13cmos5l_decap_8
XFILLER_0_1337 vccd vssd sg13cmos5l_decap_8
XFILLER_4_1484 vccd vssd sg13cmos5l_decap_8
XFILLER_34_897 vccd vssd sg13cmos5l_decap_8
XFILLER_33_2316 vccd vssd sg13cmos5l_decap_8
XFILLER_33_1604 vccd vssd sg13cmos5l_decap_8
XFILLER_33_385 vccd vssd sg13cmos5l_decap_8
XFILLER_21_525 vccd vssd sg13cmos5l_decap_8
XFILLER_37_1773 vccd vssd sg13cmos5l_decap_8
XFILLER_33_2349 vccd vssd sg13cmos5l_decap_8
XFILLER_18_1183 vccd vssd sg13cmos5l_decap_8
XFILLER_15_2772 vccd vssd sg13cmos5l_decap_8
X_0927_ _0927_/Y _0927_/A _0927_/B vccd vssd sg13cmos5l_xnor2_1
XFILLER_14_1036 vccd vssd sg13cmos5l_decap_8
XFILLER_11_2669 vccd vssd sg13cmos5l_decap_8
XFILLER_31_1372 vccd vssd sg13cmos5l_decap_8
X_0858_ _0858_/Y _0858_/A vccd vssd sg13cmos5l_inv_1
XFILLER_20_28 vccd vssd sg13cmos5l_decap_8
XFILLER_11_1946 vccd vssd sg13cmos5l_decap_8
XFILLER_44_2401 vccd vssd sg13cmos5l_decap_8
XFILLER_9_2030 vccd vssd sg13cmos5l_decap_8
XFILLER_44_2478 vccd vssd sg13cmos5l_decap_8
XFILLER_44_1700 vccd vssd sg13cmos5l_decap_8
XFILLER_29_1290 vccd vssd sg13cmos5l_decap_4
XFILLER_22_2732 vccd vssd sg13cmos5l_decap_8
XFILLER_5_1204 vccd vssd sg13cmos5l_decap_8
XFILLER_9_1351 vccd vssd sg13cmos5l_decap_8
XFILLER_42_2180 vccd vssd sg13cmos5l_decap_4
XFILLER_29_625 vccd vssd sg13cmos5l_decap_8
XFILLER_25_1154 vccd vssd sg13cmos5l_decap_8
XFILLER_44_606 vccd vssd sg13cmos5l_decap_8
XFILLER_21_1029 vccd vssd sg13cmos5l_decap_8
XFILLER_45_14 vccd vssd sg13cmos5l_decap_8
XFILLER_43_116 vccd vssd sg13cmos5l_decap_8
XFILLER_28_168 vccd vssd sg13cmos5l_decap_8
XFILLER_16_308 vccd vssd sg13cmos5l_decap_8
XFILLER_37_691 vccd vssd sg13cmos5l_decap_8
XFILLER_0_2583 vccd vssd sg13cmos5l_decap_8
XFILLER_25_864 vccd vssd sg13cmos5l_decap_8
XFILLER_24_385 vccd vssd sg13cmos5l_decap_8
XFILLER_16_1813 vccd vssd sg13cmos5l_decap_8
XFILLER_12_525 vccd vssd sg13cmos5l_decap_8
XFILLER_8_518 vccd vssd sg13cmos5l_decap_8
XFILLER_36_1294 vccd vssd sg13cmos5l_decap_8
XFILLER_14_2271 vccd vssd sg13cmos5l_decap_8
XFILLER_10_2135 vccd vssd sg13cmos5l_decap_8
XFILLER_4_735 vccd vssd sg13cmos5l_decap_8
XFILLER_3_245 vccd vssd sg13cmos5l_decap_8
XFILLER_10_1456 vccd vssd sg13cmos5l_decap_8
XFILLER_45_1519 vccd vssd sg13cmos5l_decap_8
XFILLER_27_2665 vccd vssd sg13cmos5l_decap_8
XFILLER_27_1953 vccd vssd sg13cmos5l_decap_8
XFILLER_23_2529 vccd vssd sg13cmos5l_decap_8
XFILLER_0_952 vccd vssd sg13cmos5l_decap_8
Xtiedowns\[20\] status[20] vccd vssd sg13cmos5l_antennanp
XFILLER_1_2303 vccd vssd sg13cmos5l_decap_8
XFILLER_5_2450 vccd vssd sg13cmos5l_decap_8
XFILLER_21_2264 vccd vssd sg13cmos5l_decap_8
XFILLER_19_70 vccd vssd sg13cmos5l_decap_8
XFILLER_5_1771 vccd vssd sg13cmos5l_decap_8
XFILLER_35_606 vccd vssd sg13cmos5l_decap_8
XFILLER_34_105 vccd vssd sg13cmos5l_decap_8
XFILLER_19_168 vccd vssd sg13cmos5l_decap_8
XFILLER_1_1624 vccd vssd sg13cmos5l_decap_8
XFILLER_21_1585 vccd vssd sg13cmos5l_decap_8
XFILLER_43_661 vccd vssd sg13cmos5l_decap_8
XFILLER_37_1025 vccd vssd sg13cmos5l_decap_8
XFILLER_16_875 vccd vssd sg13cmos5l_decap_8
XFILLER_37_1047 vccd vssd sg13cmos5l_decap_4
XFILLER_35_91 vccd vssd sg13cmos5l_decap_8
XFILLER_31_823 vccd vssd sg13cmos5l_decap_8
XFILLER_30_322 vccd vssd sg13cmos5l_decap_8
XFILLER_15_2002 vccd vssd sg13cmos5l_decap_8
XFILLER_15_385 vccd vssd sg13cmos5l_decap_8
XFILLER_34_2658 vccd vssd sg13cmos5l_decap_8
XFILLER_19_1470 vccd vssd sg13cmos5l_decap_8
XFILLER_34_1968 vccd vssd sg13cmos5l_decap_8
XFILLER_15_2079 vccd vssd sg13cmos5l_decap_8
XFILLER_15_1323 vccd vssd sg13cmos5l_decap_8
X_1761_ _1761_/Q _1763_/CLK _1761_/D fanout119/X vccd vssd sg13cmos5l_dfrbpq_1
XFILLER_30_399 vccd vssd sg13cmos5l_decap_8
Xhold507 _1784_/D _1584_/X vccd vssd sg13cmos5l_dlygate4sd3_1
XFILLER_32_1681 vccd vssd sg13cmos5l_decap_4
X_1692_ _1692_/Q _1711_/CLK _1692_/D fanout134/X vccd vssd sg13cmos5l_dfrbpq_1
Xhold518 hold518/X _1648_/Q vccd vssd sg13cmos5l_dlygate4sd3_1
XFILLER_28_2429 vccd vssd sg13cmos5l_decap_8
Xhold529 hold529/X _1655_/Q vccd vssd sg13cmos5l_dlygate4sd3_1
XFILLER_7_595 vccd vssd sg13cmos5l_decap_8
XFILLER_10_2691 vccd vssd sg13cmos5l_decap_8
XFILLER_28_1728 vccd vssd sg13cmos5l_decap_8
XFILLER_45_2765 vccd vssd sg13cmos5l_decap_8
XFILLER_44_1007 vccd vssd sg13cmos5l_decap_8
XFILLER_41_2607 vccd vssd sg13cmos5l_decap_8
XFILLER_26_2186 vccd vssd sg13cmos5l_decap_8
XFILLER_22_2017 vccd vssd sg13cmos5l_decap_8
XFILLER_6_2247 vccd vssd sg13cmos5l_decap_8
XFILLER_39_923 vccd vssd sg13cmos5l_decap_8
XFILLER_18_0 vccd vssd sg13cmos5l_decap_8
XFILLER_6_1568 vccd vssd sg13cmos5l_decap_8
XFILLER_39_2514 vccd vssd sg13cmos5l_decap_8
XFILLER_38_488 vccd vssd sg13cmos5l_decap_8
XFILLER_25_105 vccd vssd sg13cmos5l_decap_8
X_1126_ _1126_/Y mask_rev_in[22] _1347_/B1 _1389_/A2 vccd vssd sg13cmos5l_a21oi_1
XFILLER_0_1134 vccd vssd sg13cmos5l_decap_8
XFILLER_4_1281 vccd vssd sg13cmos5l_decap_8
XFILLER_39_1846 vccd vssd sg13cmos5l_decap_8
X_1057_ _1057_/Y _1683_/Q _1429_/B _1419_/B vccd vssd sg13cmos5l_a21oi_1
XFILLER_15_28 vccd vssd sg13cmos5l_decap_8
XFILLER_40_119 vccd vssd sg13cmos5l_decap_8
XFILLER_22_812 vccd vssd sg13cmos5l_decap_8
XFILLER_33_182 vccd vssd sg13cmos5l_decap_8
XFILLER_21_322 vccd vssd sg13cmos5l_decap_8
XFILLER_13_2709 vccd vssd sg13cmos5l_decap_8
Xtiedowns\[4\] status[4] vccd vssd sg13cmos5l_antennanp
XFILLER_33_1445 vccd vssd sg13cmos5l_decap_8
XFILLER_22_889 vccd vssd sg13cmos5l_decap_8
XFILLER_31_49 vccd vssd sg13cmos5l_decap_8
XFILLER_21_399 vccd vssd sg13cmos5l_decap_8
XFILLER_15_1890 vccd vssd sg13cmos5l_decap_8
XFILLER_11_1743 vccd vssd sg13cmos5l_decap_8
XFILLER_31_1180 vccd vssd sg13cmos5l_decap_8
XFILLER_27_1227 vccd vssd sg13cmos5l_decap_8
XFILLER_1_749 vccd vssd sg13cmos5l_decap_8
XFILLER_44_2264 vccd vssd sg13cmos5l_decap_8
XFILLER_0_259 vccd vssd sg13cmos5l_decap_8
XFILLER_44_1574 vccd vssd sg13cmos5l_decap_8
XFILLER_5_1001 vccd vssd sg13cmos5l_decap_8
XFILLER_40_1416 vccd vssd sg13cmos5l_decap_8
XFILLER_29_455 vccd vssd sg13cmos5l_decap_8
XFILLER_16_105 vccd vssd sg13cmos5l_decap_8
XFILLER_2_2667 vccd vssd sg13cmos5l_decap_8
XFILLER_2_1911 vccd vssd sg13cmos5l_decap_8
XFILLER_5_1078 vccd vssd sg13cmos5l_decap_8
XFILLER_45_959 vccd vssd sg13cmos5l_decap_8
XFILLER_44_447 vccd vssd sg13cmos5l_decap_8
XFILLER_38_2035 vccd vssd sg13cmos5l_decap_8
XFILLER_32_609 vccd vssd sg13cmos5l_decap_8
XFILLER_25_661 vccd vssd sg13cmos5l_decap_8
XFILLER_2_1988 vccd vssd sg13cmos5l_decap_8
XFILLER_0_2380 vccd vssd sg13cmos5l_decap_8
XFILLER_38_2079 vccd vssd sg13cmos5l_decap_8
XFILLER_38_1334 vccd vssd sg13cmos5l_decap_4
XFILLER_31_119 vccd vssd sg13cmos5l_decap_8
XFILLER_13_812 vccd vssd sg13cmos5l_decap_8
XFILLER_24_182 vccd vssd sg13cmos5l_decap_8
XFILLER_16_1610 vccd vssd sg13cmos5l_decap_8
XFILLER_9_805 vccd vssd sg13cmos5l_decap_8
XFILLER_12_322 vccd vssd sg13cmos5l_decap_8
XFILLER_40_697 vccd vssd sg13cmos5l_decap_8
XFILLER_16_2388 vccd vssd sg13cmos5l_decap_8
XFILLER_8_315 vccd vssd sg13cmos5l_decap_8
XFILLER_12_2208 vccd vssd sg13cmos5l_decap_8
XFILLER_13_889 vccd vssd sg13cmos5l_decap_8
XFILLER_16_1687 vccd vssd sg13cmos5l_decap_8
XFILLER_12_399 vccd vssd sg13cmos5l_decap_8
Xtiedowns\[68\] status[68] vccd vssd sg13cmos5l_antennanp
XFILLER_29_2727 vccd vssd sg13cmos5l_decap_8
XFILLER_4_532 vccd vssd sg13cmos5l_decap_8
XFILLER_10_1253 vccd vssd sg13cmos5l_decap_8
XFILLER_45_1316 vccd vssd sg13cmos5l_decap_8
XFILLER_27_2495 vccd vssd sg13cmos5l_decap_8
XFILLER_27_2473 vccd vssd sg13cmos5l_decap_4
XFILLER_7_2534 vccd vssd sg13cmos5l_decap_8
XFILLER_7_2567 vccd vssd sg13cmos5l_decap_8
XFILLER_23_2359 vccd vssd sg13cmos5l_decap_4
XFILLER_23_2337 vccd vssd sg13cmos5l_decap_8
XFILLER_23_1625 vccd vssd sg13cmos5l_decap_8
XFILLER_7_1855 vccd vssd sg13cmos5l_decap_8
XFILLER_40_2673 vccd vssd sg13cmos5l_decap_8
XFILLER_3_1708 vccd vssd sg13cmos5l_decap_8
XFILLER_1_2100 vccd vssd sg13cmos5l_decap_8
XFILLER_11_7 vccd vssd sg13cmos5l_decap_8
XFILLER_40_1983 vccd vssd sg13cmos5l_decap_8
XFILLER_1_2177 vccd vssd sg13cmos5l_decap_8
XFILLER_1_1421 vccd vssd sg13cmos5l_decap_8
XFILLER_23_609 vccd vssd sg13cmos5l_decap_8
XFILLER_21_1393 vccd vssd sg13cmos5l_decap_8
XFILLER_22_119 vccd vssd sg13cmos5l_decap_8
XFILLER_17_1407 vccd vssd sg13cmos5l_decap_8
XFILLER_16_672 vccd vssd sg13cmos5l_decap_8
XFILLER_1_1498 vccd vssd sg13cmos5l_decap_8
XFILLER_43_491 vccd vssd sg13cmos5l_decap_4
XFILLER_15_182 vccd vssd sg13cmos5l_decap_8
XFILLER_34_1732 vccd vssd sg13cmos5l_decap_8
XFILLER_31_697 vccd vssd sg13cmos5l_decap_8
XFILLER_15_1120 vccd vssd sg13cmos5l_decap_8
XFILLER_30_196 vccd vssd sg13cmos5l_decap_8
X_1744_ _1744_/Q clkload1/A _1744_/D fanout123/X vccd vssd sg13cmos5l_dfrbpq_1
XFILLER_15_1197 vccd vssd sg13cmos5l_decap_8
XFILLER_8_882 vccd vssd sg13cmos5l_decap_8
XFILLER_12_2775 vccd vssd sg13cmos5l_decap_8
Xhold326 hold326/X _1685_/Q vccd vssd sg13cmos5l_dlygate4sd3_1
Xhold315 _1737_/D _1517_/X vccd vssd sg13cmos5l_dlygate4sd3_1
Xhold304 hold304/X _1761_/Q vccd vssd sg13cmos5l_dlygate4sd3_1
XFILLER_7_84 vccd vssd sg13cmos5l_decap_8
XFILLER_7_392 vccd vssd sg13cmos5l_decap_8
Xhold337 _1745_/D _1527_/X vccd vssd sg13cmos5l_dlygate4sd3_1
Xhold359 _1747_/D _1530_/X vccd vssd sg13cmos5l_dlygate4sd3_1
X_1675_ _1675_/Q _1675_/CLK _1675_/D fanout139/X vccd vssd sg13cmos5l_dfrbpq_1
Xhold348 hold348/X _1763_/Q vccd vssd sg13cmos5l_dlygate4sd3_1
XFILLER_28_2259 vccd vssd sg13cmos5l_decap_8
XFILLER_28_1536 vccd vssd sg13cmos5l_decap_8
XFILLER_45_2562 vccd vssd sg13cmos5l_decap_8
XFILLER_41_2415 vccd vssd sg13cmos5l_decap_8
XFILLER_45_1883 vccd vssd sg13cmos5l_decap_8
Xoutbuffers\[51\] control[51] _1719_/Q vccd vssd sg13cmos5l_buf_8
XFILLER_6_2044 vccd vssd sg13cmos5l_decap_8
XFILLER_41_1747 vccd vssd sg13cmos5l_decap_8
XFILLER_22_1113 vccd vssd sg13cmos5l_decap_8
XFILLER_6_1365 vccd vssd sg13cmos5l_decap_8
XFILLER_39_2300 vccd vssd sg13cmos5l_decap_8
XFILLER_38_252 vccd vssd sg13cmos5l_decap_8
XFILLER_27_937 vccd vssd sg13cmos5l_decap_8
XFILLER_2_1218 vccd vssd sg13cmos5l_decap_8
X_1109_ _1109_/Y _1106_/Y _1107_/X _1108_/Y vccd vssd sg13cmos5l_o21ai_1
XFILLER_26_469 vccd vssd sg13cmos5l_decap_8
XFILLER_26_49 vccd vssd sg13cmos5l_decap_8
XFILLER_14_609 vccd vssd sg13cmos5l_decap_8
XFILLER_41_428 vccd vssd sg13cmos5l_decap_8
XFILLER_39_2399 vccd vssd sg13cmos5l_decap_8
XFILLER_13_119 vccd vssd sg13cmos5l_decap_8
XFILLER_17_2664 vccd vssd sg13cmos5l_decap_8
XFILLER_22_686 vccd vssd sg13cmos5l_decap_8
XFILLER_10_826 vccd vssd sg13cmos5l_decap_8
XFILLER_13_2517 vccd vssd sg13cmos5l_decap_8
XFILLER_21_196 vccd vssd sg13cmos5l_decap_8
XFILLER_6_819 vccd vssd sg13cmos5l_decap_8
XFILLER_33_1297 vccd vssd sg13cmos5l_decap_8
XFILLER_5_329 vccd vssd sg13cmos5l_decap_8
XFILLER_11_2263 vccd vssd sg13cmos5l_decap_8
XFILLER_11_1540 vccd vssd sg13cmos5l_decap_8
XFILLER_44_2061 vccd vssd sg13cmos5l_decap_8
XFILLER_1_546 vccd vssd sg13cmos5l_decap_8
XFILLER_24_2657 vccd vssd sg13cmos5l_decap_8
XFILLER_44_1371 vccd vssd sg13cmos5l_decap_8
XFILLER_40_1202 vccd vssd sg13cmos5l_decap_8
XFILLER_29_252 vccd vssd sg13cmos5l_decap_8
XFILLER_18_959 vccd vssd sg13cmos5l_decap_8
XFILLER_2_2464 vccd vssd sg13cmos5l_decap_8
XFILLER_45_756 vccd vssd sg13cmos5l_decap_8
XFILLER_44_255 vccd vssd sg13cmos5l_decap_8
XFILLER_32_406 vccd vssd sg13cmos5l_decap_8
XFILLER_18_2406 vccd vssd sg13cmos5l_decap_8
XFILLER_17_469 vccd vssd sg13cmos5l_decap_8
XFILLER_2_1785 vccd vssd sg13cmos5l_decap_8
XFILLER_26_992 vccd vssd sg13cmos5l_decap_8
XFILLER_35_2742 vccd vssd sg13cmos5l_decap_8
XFILLER_9_602 vccd vssd sg13cmos5l_decap_8
XFILLER_34_1039 vccd vssd sg13cmos5l_decap_8
XFILLER_8_112 vccd vssd sg13cmos5l_decap_8
XFILLER_13_686 vccd vssd sg13cmos5l_decap_8
XFILLER_40_483 vccd vssd sg13cmos5l_decap_8
XFILLER_12_196 vccd vssd sg13cmos5l_decap_8
XFILLER_12_2016 vccd vssd sg13cmos5l_decap_8
XFILLER_32_70 vccd vssd sg13cmos5l_decap_8
XFILLER_31_1949 vccd vssd sg13cmos5l_decap_8
XFILLER_16_1484 vccd vssd sg13cmos5l_decap_8
XFILLER_9_679 vccd vssd sg13cmos5l_decap_8
XFILLER_12_1337 vccd vssd sg13cmos5l_decap_8
XFILLER_8_189 vccd vssd sg13cmos5l_decap_8
XFILLER_29_1801 vccd vssd sg13cmos5l_decap_8
XFILLER_10_1050 vccd vssd sg13cmos5l_decap_8
X_1460_ _1460_/X hold522/X hold390/X _1461_/S vccd vssd sg13cmos5l_mux2_1
XFILLER_5_896 vccd vssd sg13cmos5l_decap_8
XFILLER_45_1113 vccd vssd sg13cmos5l_decap_8
XFILLER_42_2713 vccd vssd sg13cmos5l_decap_8
XFILLER_7_2331 vccd vssd sg13cmos5l_decap_8
XFILLER_9_1939 vccd vssd sg13cmos5l_decap_8
X_1391_ _1656_/D hold195/X _1391_/A2 _1390_/Y vccd vssd sg13cmos5l_a21o_1
XFILLER_29_1889 vccd vssd sg13cmos5l_decap_8
XFILLER_23_2134 vccd vssd sg13cmos5l_decap_8
XFILLER_27_1591 vccd vssd sg13cmos5l_decap_8
XFILLER_7_1652 vccd vssd sg13cmos5l_decap_8
XFILLER_40_2470 vccd vssd sg13cmos5l_decap_8
XFILLER_3_1505 vccd vssd sg13cmos5l_decap_8
XFILLER_36_723 vccd vssd sg13cmos5l_decap_8
XFILLER_21_1190 vccd vssd sg13cmos5l_decap_8
XFILLER_36_2539 vccd vssd sg13cmos5l_decap_8
XFILLER_35_266 vccd vssd sg13cmos5l_decap_8
XFILLER_23_406 vccd vssd sg13cmos5l_decap_8
XFILLER_1_1295 vccd vssd sg13cmos5l_decap_8
XFILLER_17_1204 vccd vssd sg13cmos5l_decap_8
XFILLER_36_1849 vccd vssd sg13cmos5l_decap_8
XFILLER_32_995 vccd vssd sg13cmos5l_decap_8
XFILLER_31_494 vccd vssd sg13cmos5l_decap_8
XFILLER_30_1426 vccd vssd sg13cmos5l_decap_8
Xoutbuffers\[99\] control[99] _1767_/Q vccd vssd sg13cmos5l_buf_8
XFILLER_12_2572 vccd vssd sg13cmos5l_decap_8
X_1727_ _1727_/Q clkload5/A _1727_/D fanout126/X vccd vssd sg13cmos5l_dfrbpq_1
XFILLER_28_2001 vccd vssd sg13cmos5l_decap_8
X_1658_ _1658_/Q _1658_/CLK _1658_/D _1606_/Y vccd vssd sg13cmos5l_dfrbpq_1
XFILLER_28_1344 vccd vssd sg13cmos5l_decap_8
Xhold178 hold178/X _0883_/Y vccd vssd sg13cmos5l_dlygate4sd3_1
XFILLER_8_2128 vccd vssd sg13cmos5l_decap_8
Xhold189 _0832_/A hold532/X vccd vssd sg13cmos5l_dlygate4sd3_1
XFILLER_41_2223 vccd vssd sg13cmos5l_decap_8
X_1589_ _1589_/Y _1589_/A _1597_/S vccd vssd sg13cmos5l_nand2_1
XFILLER_24_1208 vccd vssd sg13cmos5l_decap_8
XFILLER_8_1449 vccd vssd sg13cmos5l_decap_8
XFILLER_45_1680 vccd vssd sg13cmos5l_decap_8
XFILLER_39_550 vccd vssd sg13cmos5l_decap_8
XFILLER_23_2690 vccd vssd sg13cmos5l_decap_8
XFILLER_3_2751 vccd vssd sg13cmos5l_decap_8
XFILLER_6_1162 vccd vssd sg13cmos5l_decap_8
XFILLER_41_1588 vccd vssd sg13cmos5l_decap_8
XFILLER_2_1015 vccd vssd sg13cmos5l_decap_8
XFILLER_39_2141 vccd vssd sg13cmos5l_decap_8
XFILLER_41_203 vccd vssd sg13cmos5l_decap_8
XFILLER_26_266 vccd vssd sg13cmos5l_decap_8
XFILLER_19_2748 vccd vssd sg13cmos5l_decap_8
XFILLER_14_406 vccd vssd sg13cmos5l_decap_8
XFILLER_39_1451 vccd vssd sg13cmos5l_decap_4
XFILLER_35_1326 vccd vssd sg13cmos5l_decap_8
XFILLER_23_973 vccd vssd sg13cmos5l_decap_8
XFILLER_17_2483 vccd vssd sg13cmos5l_decap_8
XFILLER_13_2314 vccd vssd sg13cmos5l_decap_8
XFILLER_22_483 vccd vssd sg13cmos5l_decap_8
XFILLER_17_1771 vccd vssd sg13cmos5l_decap_8
XFILLER_10_623 vccd vssd sg13cmos5l_decap_8
XFILLER_6_616 vccd vssd sg13cmos5l_decap_8
XFILLER_13_1624 vccd vssd sg13cmos5l_decap_8
XFILLER_30_2694 vccd vssd sg13cmos5l_decap_8
XFILLER_5_126 vccd vssd sg13cmos5l_decap_8
XFILLER_11_2093 vccd vssd sg13cmos5l_decap_8
XFILLER_26_2719 vccd vssd sg13cmos5l_decap_8
XFILLER_2_833 vccd vssd sg13cmos5l_decap_8
XFILLER_1_343 vccd vssd sg13cmos5l_decap_8
XFILLER_24_2443 vccd vssd sg13cmos5l_decap_8
XFILLER_4_2548 vccd vssd sg13cmos5l_decap_8
XFILLER_40_1010 vccd vssd sg13cmos5l_decap_8
XFILLER_20_2318 vccd vssd sg13cmos5l_decap_8
XFILLER_2_2261 vccd vssd sg13cmos5l_decap_8
XFILLER_4_1869 vccd vssd sg13cmos5l_decap_8
XFILLER_45_553 vccd vssd sg13cmos5l_decap_8
XFILLER_40_1087 vccd vssd sg13cmos5l_decap_8
XFILLER_27_70 vccd vssd sg13cmos5l_decap_8
XFILLER_18_756 vccd vssd sg13cmos5l_decap_8
XFILLER_33_715 vccd vssd sg13cmos5l_decap_8
XFILLER_32_203 vccd vssd sg13cmos5l_decap_8
XFILLER_17_266 vccd vssd sg13cmos5l_decap_8
XFILLER_2_1582 vccd vssd sg13cmos5l_decap_8
XFILLER_31_2403 vccd vssd sg13cmos5l_decap_8
X_0960_ _1556_/B _1036_/A _1067_/A vccd vssd sg13cmos5l_and2_1
XFILLER_14_973 vccd vssd sg13cmos5l_decap_8
XFILLER_43_80 vccd vssd sg13cmos5l_decap_4
XFILLER_40_280 vccd vssd sg13cmos5l_decap_8
XFILLER_18_1568 vccd vssd sg13cmos5l_decap_8
XFILLER_13_483 vccd vssd sg13cmos5l_decap_8
XFILLER_31_1713 vccd vssd sg13cmos5l_decap_8
X_0891_ _0896_/B _1394_/B _1403_/A vccd vssd sg13cmos5l_nor2_1
XFILLER_16_1281 vccd vssd sg13cmos5l_decap_8
XFILLER_9_476 vccd vssd sg13cmos5l_decap_8
XFILLER_12_1134 vccd vssd sg13cmos5l_decap_8
XFILLER_29_2310 vccd vssd sg13cmos5l_decap_8
X_1512_ _1732_/D _1590_/A1 _1518_/S hold283/X vccd vssd sg13cmos5l_o21ai_1
XFILLER_5_693 vccd vssd sg13cmos5l_decap_8
XFILLER_9_2415 vccd vssd sg13cmos5l_decap_8
X_1443_ _1443_/Y _1443_/A _1449_/B vccd vssd sg13cmos5l_nor2_1
XFILLER_29_2398 vccd vssd sg13cmos5l_decap_8
XFILLER_42_2521 vccd vssd sg13cmos5l_decap_8
XFILLER_4_63 vccd vssd sg13cmos5l_decap_8
XFILLER_9_1736 vccd vssd sg13cmos5l_decap_8
XFILLER_42_2565 vccd vssd sg13cmos5l_decap_4
X_1374_ _1374_/Y _1374_/A _1374_/B _1374_/C _1374_/D vccd vssd sg13cmos5l_nand4_1
XFILLER_3_1302 vccd vssd sg13cmos5l_decap_8
XFILLER_42_1897 vccd vssd sg13cmos5l_decap_8
XFILLER_36_520 vccd vssd sg13cmos5l_decap_8
XFILLER_3_2058 vccd vssd sg13cmos5l_decap_8
XFILLER_3_1379 vccd vssd sg13cmos5l_decap_8
XFILLER_36_2314 vccd vssd sg13cmos5l_decap_8
XFILLER_36_586 vccd vssd sg13cmos5l_decap_8
XFILLER_23_203 vccd vssd sg13cmos5l_decap_8
Xoutbuffers\[14\] control[14] _1682_/Q vccd vssd sg13cmos5l_buf_8
XFILLER_1_1092 vccd vssd sg13cmos5l_decap_8
XFILLER_32_770 vccd vssd sg13cmos5l_decap_8
XFILLER_23_28 vccd vssd sg13cmos5l_decap_8
XFILLER_20_910 vccd vssd sg13cmos5l_decap_8
XFILLER_17_1001 vccd vssd sg13cmos5l_decap_8
XFILLER_31_280 vccd vssd sg13cmos5l_decap_8
XFILLER_14_1911 vccd vssd sg13cmos5l_decap_8
XFILLER_17_1078 vccd vssd sg13cmos5l_decap_8
XFILLER_14_2656 vccd vssd sg13cmos5l_decap_4
XFILLER_14_2678 vccd vssd sg13cmos5l_decap_8
XFILLER_20_987 vccd vssd sg13cmos5l_decap_8
XFILLER_12_2391 vccd vssd sg13cmos5l_decap_8
XFILLER_14_1988 vccd vssd sg13cmos5l_decap_8
XFILLER_41_2020 vccd vssd sg13cmos5l_decap_8
XFILLER_25_2763 vccd vssd sg13cmos5l_decap_8
XFILLER_8_1246 vccd vssd sg13cmos5l_decap_8
XFILLER_21_1904 vccd vssd sg13cmos5l_decap_8
XFILLER_41_2097 vccd vssd sg13cmos5l_decap_8
XFILLER_14_203 vccd vssd sg13cmos5l_decap_8
XFILLER_42_578 vccd vssd sg13cmos5l_decap_4
Xfanout40 _1284_/B1 _1033_/Y vccd vssd sg13cmos5l_buf_1
XFILLER_30_729 vccd vssd sg13cmos5l_decap_8
XFILLER_15_2409 vccd vssd sg13cmos5l_decap_8
XFILLER_11_910 vccd vssd sg13cmos5l_decap_8
Xfanout51 _1147_/B _1324_/B vccd vssd sg13cmos5l_buf_1
Xfanout62 _1360_/B1 _0996_/Y vccd vssd sg13cmos5l_buf_1
XFILLER_39_1292 vccd vssd sg13cmos5l_decap_8
XFILLER_23_770 vccd vssd sg13cmos5l_decap_8
XFILLER_19_1888 vccd vssd sg13cmos5l_decap_8
XFILLER_15_1708 vccd vssd sg13cmos5l_decap_8
XFILLER_10_420 vccd vssd sg13cmos5l_decap_8
XFILLER_13_2100 vccd vssd sg13cmos5l_decap_8
Xfanout84 _1036_/A _1008_/A vccd vssd sg13cmos5l_buf_1
XFILLER_35_1167 vccd vssd sg13cmos5l_decap_8
XFILLER_32_2756 vccd vssd sg13cmos5l_decap_8
XFILLER_31_1009 vccd vssd sg13cmos5l_decap_8
Xfanout95 _1472_/A hold526/X vccd vssd sg13cmos5l_buf_1
XFILLER_22_280 vccd vssd sg13cmos5l_decap_8
XFILLER_7_903 vccd vssd sg13cmos5l_decap_8
XFILLER_6_413 vccd vssd sg13cmos5l_decap_8
XFILLER_11_987 vccd vssd sg13cmos5l_decap_8
XFILLER_13_1421 vccd vssd sg13cmos5l_decap_8
XFILLER_13_2188 vccd vssd sg13cmos5l_decap_8
XFILLER_10_497 vccd vssd sg13cmos5l_decap_8
XFILLER_13_1498 vccd vssd sg13cmos5l_decap_8
Xtiedowns\[50\] status[50] vccd vssd sg13cmos5l_antennanp
XFILLER_26_2527 vccd vssd sg13cmos5l_decap_8
XFILLER_2_630 vccd vssd sg13cmos5l_decap_8
XFILLER_1_140 vccd vssd sg13cmos5l_decap_8
XFILLER_38_807 vccd vssd sg13cmos5l_decap_8
XFILLER_24_2273 vccd vssd sg13cmos5l_decap_4
XFILLER_4_2345 vccd vssd sg13cmos5l_decap_8
XFILLER_8_2492 vccd vssd sg13cmos5l_decap_8
XFILLER_24_2295 vccd vssd sg13cmos5l_decap_8
XFILLER_20_2148 vccd vssd sg13cmos5l_decap_4
XFILLER_20_1414 vccd vssd sg13cmos5l_decap_8
X_1090_ _1090_/Y _0873_/Y _1359_/A2 _1225_/B vccd vssd sg13cmos5l_a21oi_1
XFILLER_38_91 vccd vssd sg13cmos5l_decap_8
XFILLER_18_553 vccd vssd sg13cmos5l_decap_8
XFILLER_0_1519 vccd vssd sg13cmos5l_decap_8
XFILLER_4_1666 vccd vssd sg13cmos5l_decap_8
XFILLER_45_350 vccd vssd sg13cmos5l_decap_8
XFILLER_20_1458 vccd vssd sg13cmos5l_decap_8
XFILLER_37_1911 vccd vssd sg13cmos5l_decap_8
XFILLER_37_2667 vccd vssd sg13cmos5l_decap_8
XFILLER_33_556 vccd vssd sg13cmos5l_decap_8
XFILLER_21_707 vccd vssd sg13cmos5l_decap_8
Xoutbuffers\[104\] control[104] _1772_/Q vccd vssd sg13cmos5l_buf_8
XFILLER_20_217 vccd vssd sg13cmos5l_decap_8
XFILLER_18_2088 vccd vssd sg13cmos5l_decap_8
XFILLER_18_1365 vccd vssd sg13cmos5l_decap_8
XFILLER_14_770 vccd vssd sg13cmos5l_decap_8
X_0943_ _0943_/Y _1605_/A _1603_/B_N vccd vssd sg13cmos5l_nor2b_1
XFILLER_13_280 vccd vssd sg13cmos5l_decap_8
XFILLER_14_1218 vccd vssd sg13cmos5l_decap_8
X_0874_ _0874_/Y _0874_/A vccd vssd sg13cmos5l_inv_1
Xclkload10 clkload10/Y _1682_/CLK vccd vssd sg13cmos5l_inv_1
XFILLER_31_1543 vccd vssd sg13cmos5l_decap_8
XFILLER_9_273 vccd vssd sg13cmos5l_decap_8
XFILLER_31_2299 vccd vssd sg13cmos5l_decap_8
XFILLER_6_980 vccd vssd sg13cmos5l_decap_8
XFILLER_5_490 vccd vssd sg13cmos5l_decap_8
XFILLER_9_2212 vccd vssd sg13cmos5l_decap_8
XFILLER_29_2173 vccd vssd sg13cmos5l_decap_8
XFILLER_9_1533 vccd vssd sg13cmos5l_decap_8
XFILLER_44_1926 vccd vssd sg13cmos5l_decap_8
X_1426_ _1426_/X _1506_/A hold338/X _1426_/S vccd vssd sg13cmos5l_mux2_1
XFILLER_25_1314 vccd vssd sg13cmos5l_decap_8
XFILLER_9_2289 vccd vssd sg13cmos5l_decap_8
X_1357_ _1357_/Y status[96] _1357_/A2 wire73/X status[104] _1357_/C1 vccd vssd sg13cmos5l_a221oi_1
XFILLER_25_1369 vccd vssd sg13cmos5l_decap_8
XFILLER_18_28 vccd vssd sg13cmos5l_decap_8
X_1288_ _1288_/Y _1288_/A _1288_/B _1288_/C vccd vssd sg13cmos5l_nand3_1
XFILLER_20_2660 vccd vssd sg13cmos5l_decap_8
XFILLER_37_873 vccd vssd sg13cmos5l_decap_8
XFILLER_36_350 vccd vssd sg13cmos5l_decap_8
XFILLER_3_1176 vccd vssd sg13cmos5l_decap_8
XFILLER_0_2765 vccd vssd sg13cmos5l_decap_8
XFILLER_38_1719 vccd vssd sg13cmos5l_decap_8
XFILLER_36_2111 vccd vssd sg13cmos5l_decap_8
XFILLER_36_2144 vccd vssd sg13cmos5l_decap_8
XFILLER_34_49 vccd vssd sg13cmos5l_decap_8
XFILLER_24_567 vccd vssd sg13cmos5l_decap_8
XFILLER_12_707 vccd vssd sg13cmos5l_decap_8
XFILLER_11_217 vccd vssd sg13cmos5l_decap_8
Xclkload4 clkload4/Y clkload4/A vccd vssd sg13cmos5l_inv_1
XFILLER_32_1307 vccd vssd sg13cmos5l_decap_8
XFILLER_14_2442 vccd vssd sg13cmos5l_decap_8
XFILLER_20_784 vccd vssd sg13cmos5l_decap_8
XFILLER_10_2317 vccd vssd sg13cmos5l_decap_8
XFILLER_30_1031 vccd vssd sg13cmos5l_decap_4
XFILLER_4_917 vccd vssd sg13cmos5l_decap_8
XFILLER_14_1785 vccd vssd sg13cmos5l_decap_8
XFILLER_30_1075 vccd vssd sg13cmos5l_decap_8
XFILLER_3_427 vccd vssd sg13cmos5l_decap_8
XFILLER_10_1638 vccd vssd sg13cmos5l_decap_8
XFILLER_43_2126 vccd vssd sg13cmos5l_decap_8
XFILLER_43_1414 vccd vssd sg13cmos5l_decap_4
XFILLER_5_2654 vccd vssd sg13cmos5l_decap_8
XFILLER_8_1043 vccd vssd sg13cmos5l_decap_8
XFILLER_25_1870 vccd vssd sg13cmos5l_decap_8
XFILLER_5_1953 vccd vssd sg13cmos5l_decap_8
XFILLER_41_1171 vccd vssd sg13cmos5l_decap_8
XFILLER_21_2468 vccd vssd sg13cmos5l_decap_8
XFILLER_1_1806 vccd vssd sg13cmos5l_decap_8
XFILLER_27_350 vccd vssd sg13cmos5l_decap_8
XFILLER_21_1789 vccd vssd sg13cmos5l_decap_8
XFILLER_42_320 vccd vssd sg13cmos5l_decap_8
XFILLER_19_2331 vccd vssd sg13cmos5l_decap_8
XFILLER_15_567 vccd vssd sg13cmos5l_decap_8
XFILLER_42_397 vccd vssd sg13cmos5l_decap_8
XFILLER_30_515 vccd vssd sg13cmos5l_decap_4
XFILLER_19_1652 vccd vssd sg13cmos5l_decap_8
XFILLER_15_2217 vccd vssd sg13cmos5l_decap_8
XFILLER_15_1505 vccd vssd sg13cmos5l_decap_8
Xtiedowns\[98\] status[98] vccd vssd sg13cmos5l_antennanp
XFILLER_32_2553 vccd vssd sg13cmos5l_decap_8
XFILLER_7_700 vccd vssd sg13cmos5l_decap_8
XFILLER_6_210 vccd vssd sg13cmos5l_decap_8
XFILLER_11_784 vccd vssd sg13cmos5l_decap_8
XFILLER_32_1885 vccd vssd sg13cmos5l_decap_8
XFILLER_7_777 vccd vssd sg13cmos5l_decap_8
XFILLER_10_294 vccd vssd sg13cmos5l_decap_8
XFILLER_40_70 vccd vssd sg13cmos5l_decap_8
XFILLER_6_287 vccd vssd sg13cmos5l_decap_8
XFILLER_13_1295 vccd vssd sg13cmos5l_decap_8
XFILLER_41_7 vccd vssd sg13cmos5l_decap_8
XFILLER_26_2357 vccd vssd sg13cmos5l_decap_8
XFILLER_3_994 vccd vssd sg13cmos5l_decap_8
XFILLER_6_2429 vccd vssd sg13cmos5l_decap_8
X_1211_ _1211_/Y _1209_/Y _1208_/Y _1210_/Y vccd vssd sg13cmos5l_o21ai_1
XFILLER_43_2693 vccd vssd sg13cmos5l_decap_8
XFILLER_24_2092 vccd vssd sg13cmos5l_decap_8
XFILLER_4_2142 vccd vssd sg13cmos5l_decap_8
X_1142_ _1142_/Y status[37] _1142_/B vccd vssd sg13cmos5l_nand2b_1
XFILLER_37_147 vccd vssd sg13cmos5l_decap_8
XFILLER_24_1391 vccd vssd sg13cmos5l_decap_8
XFILLER_20_1211 vccd vssd sg13cmos5l_decap_8
XFILLER_19_840 vccd vssd sg13cmos5l_decap_8
XFILLER_1_42 vccd vssd sg13cmos5l_decap_8
XFILLER_4_1463 vccd vssd sg13cmos5l_decap_8
XFILLER_18_350 vccd vssd sg13cmos5l_decap_8
XFILLER_0_1316 vccd vssd sg13cmos5l_decap_8
X_1073_ _1217_/C _1197_/C _1074_/C vccd vssd sg13cmos5l_nand2b_1
XFILLER_20_1288 vccd vssd sg13cmos5l_decap_8
XFILLER_34_876 vccd vssd sg13cmos5l_decap_8
XFILLER_33_364 vccd vssd sg13cmos5l_decap_8
XFILLER_21_504 vccd vssd sg13cmos5l_decap_8
XFILLER_37_1752 vccd vssd sg13cmos5l_decap_8
XFILLER_18_1162 vccd vssd sg13cmos5l_decap_8
XFILLER_14_1015 vccd vssd sg13cmos5l_decap_8
X_0926_ _0927_/B _0926_/A _0926_/B vccd vssd sg13cmos5l_nor2_1
XFILLER_11_1925 vccd vssd sg13cmos5l_decap_8
XFILLER_11_2648 vccd vssd sg13cmos5l_decap_8
Xoutbuffers\[81\] control[81] _1749_/Q vccd vssd sg13cmos5l_buf_8
X_0857_ _0857_/Y _0857_/A vccd vssd sg13cmos5l_inv_1
XFILLER_44_2457 vccd vssd sg13cmos5l_decap_8
XFILLER_9_1330 vccd vssd sg13cmos5l_decap_8
XFILLER_9_2086 vccd vssd sg13cmos5l_decap_8
XFILLER_29_49 vccd vssd sg13cmos5l_decap_8
XFILLER_22_2711 vccd vssd sg13cmos5l_decap_8
X_1409_ _1409_/X _1409_/A _1409_/B vccd vssd sg13cmos5l_or2_1
XFILLER_44_1767 vccd vssd sg13cmos5l_decap_8
XFILLER_21_1008 vccd vssd sg13cmos5l_decap_8
XFILLER_28_147 vccd vssd sg13cmos5l_decap_8
XFILLER_42_1491 vccd vssd sg13cmos5l_decap_8
XFILLER_37_670 vccd vssd sg13cmos5l_decap_8
XFILLER_43_128 vccd vssd sg13cmos5l_decap_8
XFILLER_38_1505 vccd vssd sg13cmos5l_decap_8
XFILLER_25_843 vccd vssd sg13cmos5l_decap_8
XFILLER_0_2562 vccd vssd sg13cmos5l_decap_8
XFILLER_0_1883 vccd vssd sg13cmos5l_decap_8
XFILLER_24_364 vccd vssd sg13cmos5l_decap_8
XFILLER_12_504 vccd vssd sg13cmos5l_decap_8
Xclkbuf_5_7_0_SCK clkload5/A clkbuf_5_7_0_SCK/A vccd vssd sg13cmos5l_buf_8
XFILLER_16_2559 vccd vssd sg13cmos5l_decap_8
XFILLER_16_1869 vccd vssd sg13cmos5l_decap_8
XFILLER_32_1148 vccd vssd sg13cmos5l_decap_8
XFILLER_20_581 vccd vssd sg13cmos5l_decap_8
XFILLER_10_2114 vccd vssd sg13cmos5l_decap_8
XFILLER_4_714 vccd vssd sg13cmos5l_decap_8
XFILLER_10_1435 vccd vssd sg13cmos5l_decap_8
XFILLER_14_1582 vccd vssd sg13cmos5l_decap_8
XFILLER_3_224 vccd vssd sg13cmos5l_decap_8
XFILLER_27_2644 vccd vssd sg13cmos5l_decap_8
XFILLER_27_1932 vccd vssd sg13cmos5l_decap_8
XFILLER_23_2508 vccd vssd sg13cmos5l_decap_8
XFILLER_0_931 vccd vssd sg13cmos5l_decap_8
XFILLER_10_84 vccd vssd sg13cmos5l_decap_8
XFILLER_23_1818 vccd vssd sg13cmos5l_decap_8
XFILLER_21_2232 vccd vssd sg13cmos5l_decap_8
XFILLER_19_147 vccd vssd sg13cmos5l_decap_8
XFILLER_5_1750 vccd vssd sg13cmos5l_decap_8
Xtiedowns\[13\] status[13] vccd vssd sg13cmos5l_antennanp
XFILLER_21_1564 vccd vssd sg13cmos5l_decap_8
XFILLER_1_2359 vccd vssd sg13cmos5l_decap_8
XFILLER_1_1603 vccd vssd sg13cmos5l_decap_8
XFILLER_37_1004 vccd vssd sg13cmos5l_decap_8
XFILLER_35_70 vccd vssd sg13cmos5l_decap_8
XFILLER_31_802 vccd vssd sg13cmos5l_decap_8
XFILLER_19_2150 vccd vssd sg13cmos5l_decap_8
XFILLER_16_854 vccd vssd sg13cmos5l_decap_8
XFILLER_38_2784 vccd vssd sg13cmos5l_decap_8
XFILLER_34_2637 vccd vssd sg13cmos5l_decap_8
XFILLER_30_301 vccd vssd sg13cmos5l_decap_8
XFILLER_15_364 vccd vssd sg13cmos5l_decap_8
XFILLER_31_879 vccd vssd sg13cmos5l_decap_8
XFILLER_15_2058 vccd vssd sg13cmos5l_decap_8
XFILLER_15_1302 vccd vssd sg13cmos5l_decap_8
XFILLER_34_1947 vccd vssd sg13cmos5l_decap_8
XFILLER_30_378 vccd vssd sg13cmos5l_decap_8
X_1760_ _1760_/Q clkload6/A _1760_/D fanout119/X vccd vssd sg13cmos5l_dfrbpq_1
XFILLER_15_1379 vccd vssd sg13cmos5l_decap_8
XFILLER_11_581 vccd vssd sg13cmos5l_decap_8
X_1691_ _1691_/Q _1699_/CLK _1691_/D fanout134/X vccd vssd sg13cmos5l_dfrbpq_1
Xhold508 hold508/X _1794_/Q vccd vssd sg13cmos5l_dlygate4sd3_1
XFILLER_7_574 vccd vssd sg13cmos5l_decap_8
Xhold519 hold519/X _1791_/Q vccd vssd sg13cmos5l_dlygate4sd3_1
XFILLER_10_2670 vccd vssd sg13cmos5l_decap_8
XFILLER_13_1092 vccd vssd sg13cmos5l_decap_8
XFILLER_28_1707 vccd vssd sg13cmos5l_decap_8
XFILLER_45_2744 vccd vssd sg13cmos5l_decap_8
XFILLER_3_791 vccd vssd sg13cmos5l_decap_8
XFILLER_39_902 vccd vssd sg13cmos5l_decap_8
XFILLER_26_2165 vccd vssd sg13cmos5l_decap_8
XFILLER_6_2226 vccd vssd sg13cmos5l_decap_8
XFILLER_41_1929 vccd vssd sg13cmos5l_decap_8
XFILLER_6_1547 vccd vssd sg13cmos5l_decap_8
XFILLER_38_434 vccd vssd sg13cmos5l_decap_8
XFILLER_4_1260 vccd vssd sg13cmos5l_decap_8
X_1125_ _1125_/X _1122_/X _1123_/Y _1124_/Y vccd vssd sg13cmos5l_a21o_1
XFILLER_39_1814 vccd vssd sg13cmos5l_decap_4
XFILLER_0_1113 vccd vssd sg13cmos5l_decap_8
X_1056_ _1382_/A _1055_/A _1074_/C vccd vssd sg13cmos5l_nand2b_1
XFILLER_20_1085 vccd vssd sg13cmos5l_decap_8
XFILLER_37_2250 vccd vssd sg13cmos5l_decap_8
XFILLER_34_673 vccd vssd sg13cmos5l_decap_8
XFILLER_33_161 vccd vssd sg13cmos5l_decap_8
XFILLER_21_301 vccd vssd sg13cmos5l_decap_8
XFILLER_22_868 vccd vssd sg13cmos5l_decap_8
XFILLER_37_1582 vccd vssd sg13cmos5l_decap_8
XFILLER_33_2169 vccd vssd sg13cmos5l_decap_8
XFILLER_21_378 vccd vssd sg13cmos5l_decap_8
XFILLER_31_28 vccd vssd sg13cmos5l_decap_8
XFILLER_15_2592 vccd vssd sg13cmos5l_decap_8
X_0909_ _0910_/B _0915_/A _0924_/A _0909_/C vccd vssd sg13cmos5l_nand3_1
XFILLER_11_1722 vccd vssd sg13cmos5l_decap_8
XFILLER_11_1799 vccd vssd sg13cmos5l_decap_8
XFILLER_44_2243 vccd vssd sg13cmos5l_decap_8
XFILLER_1_728 vccd vssd sg13cmos5l_decap_8
XFILLER_0_238 vccd vssd sg13cmos5l_decap_8
XFILLER_44_1553 vccd vssd sg13cmos5l_decap_8
XFILLER_29_434 vccd vssd sg13cmos5l_decap_8
XFILLER_2_2646 vccd vssd sg13cmos5l_decap_8
XFILLER_5_1057 vccd vssd sg13cmos5l_decap_8
XFILLER_45_938 vccd vssd sg13cmos5l_decap_8
XFILLER_22_2585 vccd vssd sg13cmos5l_decap_8
XFILLER_44_426 vccd vssd sg13cmos5l_decap_8
XFILLER_38_2014 vccd vssd sg13cmos5l_decap_8
XFILLER_22_1895 vccd vssd sg13cmos5l_decap_8
XFILLER_2_1967 vccd vssd sg13cmos5l_decap_8
XFILLER_38_1313 vccd vssd sg13cmos5l_decap_8
XFILLER_25_640 vccd vssd sg13cmos5l_decap_8
XFILLER_24_161 vccd vssd sg13cmos5l_decap_8
XFILLER_0_1680 vccd vssd sg13cmos5l_decap_8
XFILLER_12_301 vccd vssd sg13cmos5l_decap_8
XFILLER_13_868 vccd vssd sg13cmos5l_decap_8
XFILLER_40_676 vccd vssd sg13cmos5l_decap_4
XFILLER_36_1081 vccd vssd sg13cmos5l_decap_8
XFILLER_16_2367 vccd vssd sg13cmos5l_decap_8
XFILLER_12_378 vccd vssd sg13cmos5l_decap_8
XFILLER_33_2692 vccd vssd sg13cmos5l_decap_8
XFILLER_16_1666 vccd vssd sg13cmos5l_decap_8
XFILLER_12_1519 vccd vssd sg13cmos5l_decap_8
XFILLER_29_2706 vccd vssd sg13cmos5l_decap_8
XFILLER_4_511 vccd vssd sg13cmos5l_decap_8
XFILLER_10_1232 vccd vssd sg13cmos5l_decap_8
XFILLER_4_588 vccd vssd sg13cmos5l_decap_8
XFILLER_7_2513 vccd vssd sg13cmos5l_decap_8
XFILLER_23_2316 vccd vssd sg13cmos5l_decap_8
XFILLER_23_1604 vccd vssd sg13cmos5l_decap_8
XFILLER_7_1834 vccd vssd sg13cmos5l_decap_8
XFILLER_40_2652 vccd vssd sg13cmos5l_decap_8
XFILLER_27_1795 vccd vssd sg13cmos5l_decap_8
XFILLER_40_1962 vccd vssd sg13cmos5l_decap_8
XFILLER_36_905 vccd vssd sg13cmos5l_decap_8
XFILLER_21_2084 vccd vssd sg13cmos5l_decap_8
XFILLER_1_1400 vccd vssd sg13cmos5l_decap_8
XFILLER_21_1372 vccd vssd sg13cmos5l_decap_8
XFILLER_1_2156 vccd vssd sg13cmos5l_decap_8
XFILLER_17_2109 vccd vssd sg13cmos5l_decap_8
XFILLER_16_651 vccd vssd sg13cmos5l_decap_8
XFILLER_1_1477 vccd vssd sg13cmos5l_decap_8
XFILLER_44_993 vccd vssd sg13cmos5l_decap_8
XFILLER_38_2581 vccd vssd sg13cmos5l_decap_8
XFILLER_15_161 vccd vssd sg13cmos5l_decap_8
XFILLER_38_1880 vccd vssd sg13cmos5l_decap_8
XFILLER_34_2434 vccd vssd sg13cmos5l_decap_8
XFILLER_34_1711 vccd vssd sg13cmos5l_decap_8
XFILLER_34_2489 vccd vssd sg13cmos5l_decap_4
XFILLER_31_676 vccd vssd sg13cmos5l_decap_8
XFILLER_30_175 vccd vssd sg13cmos5l_decap_8
X_1743_ _1743_/Q clkload4/A _1743_/D fanout123/X vccd vssd sg13cmos5l_dfrbpq_1
XFILLER_34_1799 vccd vssd sg13cmos5l_decap_8
XFILLER_32_2180 vccd vssd sg13cmos5l_decap_8
XFILLER_15_1176 vccd vssd sg13cmos5l_decap_8
XFILLER_7_63 vccd vssd sg13cmos5l_decap_8
XFILLER_8_861 vccd vssd sg13cmos5l_decap_8
XFILLER_11_1029 vccd vssd sg13cmos5l_decap_8
XFILLER_12_2754 vccd vssd sg13cmos5l_decap_8
Xhold316 hold316/X _1683_/Q vccd vssd sg13cmos5l_dlygate4sd3_1
Xhold305 _1761_/D _1552_/X vccd vssd sg13cmos5l_dlygate4sd3_1
X_1674_ _1674_/Q _1682_/CLK _1674_/D _1643_/B_N vccd vssd sg13cmos5l_dfrbpq_1
XFILLER_7_371 vccd vssd sg13cmos5l_decap_8
Xhold327 _1685_/D _1442_/X vccd vssd sg13cmos5l_dlygate4sd3_1
Xhold349 _1763_/D _1555_/X vccd vssd sg13cmos5l_dlygate4sd3_1
Xhold338 hold338/X _1673_/Q vccd vssd sg13cmos5l_dlygate4sd3_1
XFILLER_28_2238 vccd vssd sg13cmos5l_decap_8
XFILLER_45_2541 vccd vssd sg13cmos5l_decap_8
XFILLER_28_1515 vccd vssd sg13cmos5l_decap_8
XFILLER_30_0 vccd vssd sg13cmos5l_decap_8
XFILLER_6_2023 vccd vssd sg13cmos5l_decap_8
XFILLER_45_1862 vccd vssd sg13cmos5l_decap_8
XFILLER_26_1250 vccd vssd sg13cmos5l_decap_8
Xoutbuffers\[44\] control[44] _1712_/Q vccd vssd sg13cmos5l_buf_8
XFILLER_41_1726 vccd vssd sg13cmos5l_decap_8
XFILLER_39_743 vccd vssd sg13cmos5l_decap_4
XFILLER_6_1344 vccd vssd sg13cmos5l_decap_8
XFILLER_38_231 vccd vssd sg13cmos5l_decap_8
XFILLER_27_916 vccd vssd sg13cmos5l_decap_8
XFILLER_39_798 vccd vssd sg13cmos5l_decap_8
XFILLER_26_28 vccd vssd sg13cmos5l_decap_8
XFILLER_22_1169 vccd vssd sg13cmos5l_decap_8
XFILLER_42_919 vccd vssd sg13cmos5l_decap_8
X_1108_ _1108_/Y _1754_/Q _1155_/B _1284_/B1 vccd vssd sg13cmos5l_a21oi_1
XFILLER_26_448 vccd vssd sg13cmos5l_decap_8
XFILLER_41_407 vccd vssd sg13cmos5l_decap_8
XFILLER_39_2378 vccd vssd sg13cmos5l_decap_8
XFILLER_39_1644 vccd vssd sg13cmos5l_decap_8
X_1039_ _1040_/B _1747_/Q _1284_/B1 _1198_/A _1739_/Q _1372_/B1 vccd vssd sg13cmos5l_a221oi_1
XFILLER_42_49 vccd vssd sg13cmos5l_decap_8
XFILLER_22_665 vccd vssd sg13cmos5l_decap_8
XFILLER_10_805 vccd vssd sg13cmos5l_decap_8
XFILLER_33_1254 vccd vssd sg13cmos5l_decap_4
XFILLER_21_175 vccd vssd sg13cmos5l_decap_8
XFILLER_17_1986 vccd vssd sg13cmos5l_decap_8
XFILLER_13_1806 vccd vssd sg13cmos5l_decap_8
XFILLER_33_1276 vccd vssd sg13cmos5l_decap_8
XFILLER_5_308 vccd vssd sg13cmos5l_decap_8
XFILLER_11_2242 vccd vssd sg13cmos5l_decap_8
XFILLER_1_525 vccd vssd sg13cmos5l_decap_8
XFILLER_11_1596 vccd vssd sg13cmos5l_decap_8
XFILLER_44_2040 vccd vssd sg13cmos5l_decap_8
XFILLER_44_1350 vccd vssd sg13cmos5l_decap_8
XFILLER_24_2636 vccd vssd sg13cmos5l_decap_8
XFILLER_24_1913 vccd vssd sg13cmos5l_decap_8
XFILLER_24_1957 vccd vssd sg13cmos5l_decap_8
XFILLER_40_1247 vccd vssd sg13cmos5l_decap_4
XFILLER_29_231 vccd vssd sg13cmos5l_decap_8
XFILLER_22_2382 vccd vssd sg13cmos5l_decap_8
XFILLER_22_2371 vccd vssd sg13cmos5l_decap_4
XFILLER_2_2443 vccd vssd sg13cmos5l_decap_8
XFILLER_45_735 vccd vssd sg13cmos5l_decap_8
XFILLER_40_1269 vccd vssd sg13cmos5l_decap_8
XFILLER_18_938 vccd vssd sg13cmos5l_decap_8
XFILLER_44_234 vccd vssd sg13cmos5l_decap_8
XFILLER_17_448 vccd vssd sg13cmos5l_decap_8
XFILLER_2_1764 vccd vssd sg13cmos5l_decap_8
XFILLER_35_2721 vccd vssd sg13cmos5l_decap_8
XFILLER_41_985 vccd vssd sg13cmos5l_decap_8
XFILLER_40_462 vccd vssd sg13cmos5l_decap_8
XFILLER_38_1198 vccd vssd sg13cmos5l_decap_8
XFILLER_34_1018 vccd vssd sg13cmos5l_decap_8
XFILLER_13_665 vccd vssd sg13cmos5l_decap_8
XFILLER_16_1463 vccd vssd sg13cmos5l_decap_8
XFILLER_9_658 vccd vssd sg13cmos5l_decap_8
XFILLER_12_175 vccd vssd sg13cmos5l_decap_8
Xtiedowns\[80\] status[80] vccd vssd sg13cmos5l_antennanp
XFILLER_31_1939 vccd vssd sg13cmos5l_decap_4
XFILLER_8_168 vccd vssd sg13cmos5l_decap_8
XFILLER_12_1316 vccd vssd sg13cmos5l_decap_8
XFILLER_29_2503 vccd vssd sg13cmos5l_decap_4
XFILLER_5_875 vccd vssd sg13cmos5l_decap_8
XFILLER_4_385 vccd vssd sg13cmos5l_decap_8
XFILLER_29_1868 vccd vssd sg13cmos5l_decap_8
XFILLER_7_2310 vccd vssd sg13cmos5l_decap_8
XFILLER_9_1918 vccd vssd sg13cmos5l_decap_8
X_1390_ _1390_/Y _1390_/A _1390_/B _1390_/C vccd vssd sg13cmos5l_nor3_1
XFILLER_45_1169 vccd vssd sg13cmos5l_decap_8
XFILLER_23_2113 vccd vssd sg13cmos5l_decap_8
XFILLER_42_2769 vccd vssd sg13cmos5l_decap_8
XFILLER_27_1570 vccd vssd sg13cmos5l_decap_8
XFILLER_7_1631 vccd vssd sg13cmos5l_decap_8
XFILLER_7_2387 vccd vssd sg13cmos5l_decap_8
XFILLER_36_702 vccd vssd sg13cmos5l_decap_8
XFILLER_40_1781 vccd vssd sg13cmos5l_decap_8
XFILLER_35_245 vccd vssd sg13cmos5l_decap_8
XFILLER_36_2518 vccd vssd sg13cmos5l_decap_8
XFILLER_1_1274 vccd vssd sg13cmos5l_decap_8
XFILLER_34_2242 vccd vssd sg13cmos5l_decap_8
XFILLER_32_974 vccd vssd sg13cmos5l_decap_8
XFILLER_34_1530 vccd vssd sg13cmos5l_decap_8
XFILLER_30_1405 vccd vssd sg13cmos5l_decap_8
X_1726_ _1726_/Q _1736_/CLK _1726_/D fanout126/X vccd vssd sg13cmos5l_dfrbpq_1
XFILLER_12_1883 vccd vssd sg13cmos5l_decap_8
XFILLER_8_2107 vccd vssd sg13cmos5l_decap_8
X_1657_ _1657_/Q _1657_/CLK _1657_/D _1607_/Y vccd vssd sg13cmos5l_dfrbpq_1
X_1588_ _1595_/S _1588_/A _1588_/B vccd vssd sg13cmos5l_nand2_1
XFILLER_28_1323 vccd vssd sg13cmos5l_decap_8
Xhold179 _1809_/D _0884_/Y vccd vssd sg13cmos5l_dlygate4sd3_1
XFILLER_41_2202 vccd vssd sg13cmos5l_decap_8
XFILLER_8_1428 vccd vssd sg13cmos5l_decap_8
XFILLER_41_2279 vccd vssd sg13cmos5l_decap_8
XFILLER_41_1534 vccd vssd sg13cmos5l_decap_4
XFILLER_37_49 vccd vssd sg13cmos5l_decap_8
XFILLER_3_2730 vccd vssd sg13cmos5l_decap_8
XFILLER_6_1141 vccd vssd sg13cmos5l_decap_8
XFILLER_41_1567 vccd vssd sg13cmos5l_decap_8
XFILLER_27_724 vccd vssd sg13cmos5l_decap_8
XFILLER_42_705 vccd vssd sg13cmos5l_decap_8
XFILLER_26_245 vccd vssd sg13cmos5l_decap_8
XFILLER_39_1430 vccd vssd sg13cmos5l_decap_8
XFILLER_19_2727 vccd vssd sg13cmos5l_decap_8
XFILLER_35_1305 vccd vssd sg13cmos5l_decap_8
XFILLER_23_952 vccd vssd sg13cmos5l_decap_8
XFILLER_22_462 vccd vssd sg13cmos5l_decap_8
XFILLER_17_2462 vccd vssd sg13cmos5l_decap_8
XFILLER_10_602 vccd vssd sg13cmos5l_decap_8
XFILLER_17_1750 vccd vssd sg13cmos5l_decap_8
XFILLER_13_1603 vccd vssd sg13cmos5l_decap_8
XFILLER_30_2673 vccd vssd sg13cmos5l_decap_8
XFILLER_5_105 vccd vssd sg13cmos5l_decap_8
XFILLER_10_679 vccd vssd sg13cmos5l_decap_8
XFILLER_11_2072 vccd vssd sg13cmos5l_decap_8
XFILLER_30_1994 vccd vssd sg13cmos5l_decap_8
XFILLER_29_1109 vccd vssd sg13cmos5l_decap_8
XFILLER_2_812 vccd vssd sg13cmos5l_decap_8
XFILLER_11_1393 vccd vssd sg13cmos5l_decap_8
XFILLER_1_322 vccd vssd sg13cmos5l_decap_8
XFILLER_24_2433 vccd vssd sg13cmos5l_decap_4
XFILLER_2_889 vccd vssd sg13cmos5l_decap_8
XFILLER_1_399 vccd vssd sg13cmos5l_decap_8
XFILLER_4_2527 vccd vssd sg13cmos5l_decap_8
XFILLER_24_1743 vccd vssd sg13cmos5l_decap_4
XFILLER_8_1995 vccd vssd sg13cmos5l_decap_8
XFILLER_40_1066 vccd vssd sg13cmos5l_decap_8
XFILLER_24_1798 vccd vssd sg13cmos5l_decap_8
XFILLER_18_735 vccd vssd sg13cmos5l_decap_8
XFILLER_2_2240 vccd vssd sg13cmos5l_decap_8
XFILLER_4_1848 vccd vssd sg13cmos5l_decap_8
XFILLER_45_532 vccd vssd sg13cmos5l_decap_8
XFILLER_17_245 vccd vssd sg13cmos5l_decap_8
XFILLER_2_1561 vccd vssd sg13cmos5l_decap_8
XFILLER_32_259 vccd vssd sg13cmos5l_decap_8
XFILLER_18_1547 vccd vssd sg13cmos5l_decap_8
XFILLER_14_952 vccd vssd sg13cmos5l_decap_8
XFILLER_41_782 vccd vssd sg13cmos5l_decap_8
XFILLER_35_2595 vccd vssd sg13cmos5l_decap_8
X_0890_ _1403_/A _1394_/A _1394_/C vccd vssd sg13cmos5l_nand2_1
XFILLER_13_462 vccd vssd sg13cmos5l_decap_8
XFILLER_35_1894 vccd vssd sg13cmos5l_decap_8
XFILLER_16_1260 vccd vssd sg13cmos5l_decap_8
XFILLER_9_455 vccd vssd sg13cmos5l_decap_8
XFILLER_31_1769 vccd vssd sg13cmos5l_decap_8
XFILLER_12_1113 vccd vssd sg13cmos5l_decap_8
XFILLER_29_1610 vccd vssd sg13cmos5l_decap_8
X_1511_ _1511_/Y _1511_/A _1518_/S vccd vssd sg13cmos5l_nand2_1
XFILLER_5_672 vccd vssd sg13cmos5l_decap_8
X_1442_ _1442_/X _1401_/A hold326/X _1451_/B vccd vssd sg13cmos5l_mux2_1
XFILLER_29_1643 vccd vssd sg13cmos5l_decap_8
XFILLER_4_42 vccd vssd sg13cmos5l_decap_8
XFILLER_4_182 vccd vssd sg13cmos5l_decap_8
XFILLER_9_1715 vccd vssd sg13cmos5l_decap_8
XFILLER_42_2500 vccd vssd sg13cmos5l_decap_8
XFILLER_29_1698 vccd vssd sg13cmos5l_decap_8
X_1373_ _1374_/D _1740_/Q _1520_/B _1198_/A _1732_/Q vccd vssd sg13cmos5l_a22oi_1
Xtiedowns\[124\] status[124] vccd vssd sg13cmos5l_antennanp
XFILLER_42_2588 vccd vssd sg13cmos5l_decap_8
XFILLER_3_2037 vccd vssd sg13cmos5l_decap_8
XFILLER_7_2184 vccd vssd sg13cmos5l_decap_8
XFILLER_42_1876 vccd vssd sg13cmos5l_decap_8
XFILLER_23_1275 vccd vssd sg13cmos5l_decap_8
XFILLER_3_1358 vccd vssd sg13cmos5l_decap_8
XFILLER_24_749 vccd vssd sg13cmos5l_decap_8
XFILLER_1_1071 vccd vssd sg13cmos5l_decap_8
XFILLER_36_1647 vccd vssd sg13cmos5l_decap_8
XFILLER_23_259 vccd vssd sg13cmos5l_decap_8
XFILLER_18_2771 vccd vssd sg13cmos5l_decap_8
XFILLER_14_2602 vccd vssd sg13cmos5l_decap_4
XFILLER_17_1057 vccd vssd sg13cmos5l_decap_8
XFILLER_14_2635 vccd vssd sg13cmos5l_decap_8
XFILLER_34_2083 vccd vssd sg13cmos5l_decap_8
XFILLER_20_966 vccd vssd sg13cmos5l_decap_8
XFILLER_12_2370 vccd vssd sg13cmos5l_decap_8
XFILLER_14_1967 vccd vssd sg13cmos5l_decap_8
XFILLER_3_609 vccd vssd sg13cmos5l_decap_8
X_1709_ _1709_/Q _1713_/CLK _1709_/D fanout130/X vccd vssd sg13cmos5l_dfrbpq_1
XFILLER_2_119 vccd vssd sg13cmos5l_decap_8
XFILLER_12_1680 vccd vssd sg13cmos5l_decap_8
XFILLER_43_2308 vccd vssd sg13cmos5l_decap_8
XFILLER_25_2742 vccd vssd sg13cmos5l_decap_8
XFILLER_8_1225 vccd vssd sg13cmos5l_decap_8
XFILLER_41_2076 vccd vssd sg13cmos5l_decap_8
XFILLER_41_1353 vccd vssd sg13cmos5l_decap_8
XFILLER_27_554 vccd vssd sg13cmos5l_decap_4
XFILLER_27_587 vccd vssd sg13cmos5l_decap_8
XFILLER_15_749 vccd vssd sg13cmos5l_decap_8
XFILLER_42_557 vccd vssd sg13cmos5l_decap_8
XFILLER_39_1271 vccd vssd sg13cmos5l_decap_8
Xfanout30 _1162_/B _1463_/B vccd vssd sg13cmos5l_buf_1
XFILLER_14_259 vccd vssd sg13cmos5l_decap_8
Xfanout63 _1225_/B _1362_/A2 vccd vssd sg13cmos5l_buf_1
Xfanout52 _1324_/B _1015_/Y vccd vssd sg13cmos5l_buf_1
XFILLER_35_1146 vccd vssd sg13cmos5l_decap_8
XFILLER_32_2735 vccd vssd sg13cmos5l_decap_8
Xfanout41 _1520_/B _1033_/Y vccd vssd sg13cmos5l_buf_1
Xfanout85 _1070_/A _1021_/B vccd vssd sg13cmos5l_buf_4
Xfanout96 _1528_/A _1553_/A vccd vssd sg13cmos5l_buf_1
XFILLER_17_2292 vccd vssd sg13cmos5l_decap_8
XFILLER_11_966 vccd vssd sg13cmos5l_decap_8
XFILLER_13_1400 vccd vssd sg13cmos5l_decap_8
XFILLER_7_959 vccd vssd sg13cmos5l_decap_8
XFILLER_10_476 vccd vssd sg13cmos5l_decap_8
XFILLER_13_84 vccd vssd sg13cmos5l_decap_8
XFILLER_6_469 vccd vssd sg13cmos5l_decap_8
XFILLER_13_1477 vccd vssd sg13cmos5l_decap_8
XFILLER_26_2506 vccd vssd sg13cmos5l_decap_8
XFILLER_8_0 vccd vssd sg13cmos5l_decap_8
XFILLER_11_1190 vccd vssd sg13cmos5l_decap_8
Xtiedowns\[43\] status[43] vccd vssd sg13cmos5l_antennanp
XFILLER_24_2230 vccd vssd sg13cmos5l_decap_8
XFILLER_2_686 vccd vssd sg13cmos5l_decap_8
XFILLER_8_2471 vccd vssd sg13cmos5l_decap_8
XFILLER_1_196 vccd vssd sg13cmos5l_decap_8
XFILLER_4_2324 vccd vssd sg13cmos5l_decap_8
XFILLER_38_70 vccd vssd sg13cmos5l_decap_8
XFILLER_37_329 vccd vssd sg13cmos5l_decap_8
XFILLER_4_1645 vccd vssd sg13cmos5l_decap_8
XFILLER_8_1792 vccd vssd sg13cmos5l_decap_8
XFILLER_24_1595 vccd vssd sg13cmos5l_decap_8
XFILLER_18_532 vccd vssd sg13cmos5l_decap_8
XFILLER_37_2646 vccd vssd sg13cmos5l_decap_8
XFILLER_33_535 vccd vssd sg13cmos5l_decap_8
XFILLER_18_2067 vccd vssd sg13cmos5l_decap_8
XFILLER_37_1989 vccd vssd sg13cmos5l_decap_8
XFILLER_18_1344 vccd vssd sg13cmos5l_decap_8
XFILLER_35_2392 vccd vssd sg13cmos5l_decap_8
X_0942_ _0942_/Y _0942_/A _0942_/B vccd vssd sg13cmos5l_nor2_1
XFILLER_9_252 vccd vssd sg13cmos5l_decap_8
X_0873_ _0873_/Y status[86] vccd vssd sg13cmos5l_inv_1
XFILLER_31_2278 vccd vssd sg13cmos5l_decap_8
XFILLER_31_2256 vccd vssd sg13cmos5l_decap_4
XFILLER_31_1522 vccd vssd sg13cmos5l_decap_8
Xclkload11 clkload11/Y _1685_/CLK vccd vssd sg13cmos5l_inv_1
XFILLER_29_2152 vccd vssd sg13cmos5l_decap_8
XFILLER_44_2639 vccd vssd sg13cmos5l_decap_8
XFILLER_44_1905 vccd vssd sg13cmos5l_decap_8
XFILLER_29_1440 vccd vssd sg13cmos5l_decap_8
XFILLER_9_1512 vccd vssd sg13cmos5l_decap_8
XFILLER_9_2268 vccd vssd sg13cmos5l_decap_8
XFILLER_44_1949 vccd vssd sg13cmos5l_decap_8
X_1425_ _1425_/X _1504_/A hold334/X _1428_/S vccd vssd sg13cmos5l_mux2_1
XFILLER_29_1484 vccd vssd sg13cmos5l_decap_8
X_1356_ _1356_/Y status[112] wire81/X wire74/X status[120] vccd vssd sg13cmos5l_a22oi_1
XFILLER_25_1348 vccd vssd sg13cmos5l_decap_8
XFILLER_9_1589 vccd vssd sg13cmos5l_decap_8
XFILLER_42_1673 vccd vssd sg13cmos5l_decap_8
XFILLER_28_329 vccd vssd sg13cmos5l_decap_8
XFILLER_37_852 vccd vssd sg13cmos5l_decap_8
X_1287_ _1288_/C _1734_/Q _1510_/B _1372_/B1 vccd vssd sg13cmos5l_a21oi_1
XFILLER_3_1155 vccd vssd sg13cmos5l_decap_8
XFILLER_0_2744 vccd vssd sg13cmos5l_decap_8
XFILLER_36_2123 vccd vssd sg13cmos5l_decap_8
XFILLER_34_28 vccd vssd sg13cmos5l_decap_8
XFILLER_24_546 vccd vssd sg13cmos5l_decap_8
XFILLER_32_2009 vccd vssd sg13cmos5l_decap_8
XFILLER_18_2590 vccd vssd sg13cmos5l_decap_8
XFILLER_14_2421 vccd vssd sg13cmos5l_decap_8
Xclkload5 clkload5/Y clkload5/A vccd vssd sg13cmos5l_inv_1
XFILLER_36_1499 vccd vssd sg13cmos5l_decap_8
XFILLER_20_763 vccd vssd sg13cmos5l_decap_8
XFILLER_10_1617 vccd vssd sg13cmos5l_decap_8
XFILLER_14_1764 vccd vssd sg13cmos5l_decap_8
XFILLER_14_2498 vccd vssd sg13cmos5l_decap_8
XFILLER_30_1054 vccd vssd sg13cmos5l_decap_8
XFILLER_3_406 vccd vssd sg13cmos5l_decap_8
XFILLER_43_2105 vccd vssd sg13cmos5l_decap_8
XFILLER_1_7 vccd vssd sg13cmos5l_decap_8
XFILLER_8_1022 vccd vssd sg13cmos5l_decap_8
XFILLER_5_2633 vccd vssd sg13cmos5l_decap_8
XFILLER_25_2594 vccd vssd sg13cmos5l_decap_8
XFILLER_21_2447 vccd vssd sg13cmos5l_decap_8
XFILLER_19_329 vccd vssd sg13cmos5l_decap_8
XFILLER_5_1932 vccd vssd sg13cmos5l_decap_8
XFILLER_8_1099 vccd vssd sg13cmos5l_decap_8
XFILLER_41_1150 vccd vssd sg13cmos5l_decap_8
XFILLER_21_1746 vccd vssd sg13cmos5l_decap_4
XFILLER_21_1768 vccd vssd sg13cmos5l_decap_8
XFILLER_19_2310 vccd vssd sg13cmos5l_decap_8
XFILLER_42_354 vccd vssd sg13cmos5l_decap_4
XFILLER_19_1631 vccd vssd sg13cmos5l_decap_8
XFILLER_15_546 vccd vssd sg13cmos5l_decap_8
XFILLER_11_763 vccd vssd sg13cmos5l_decap_8
XFILLER_32_1864 vccd vssd sg13cmos5l_decap_8
XFILLER_7_756 vccd vssd sg13cmos5l_decap_8
XFILLER_10_273 vccd vssd sg13cmos5l_decap_8
XFILLER_6_266 vccd vssd sg13cmos5l_decap_8
XFILLER_13_1274 vccd vssd sg13cmos5l_decap_8
XFILLER_26_2336 vccd vssd sg13cmos5l_decap_8
XFILLER_3_973 vccd vssd sg13cmos5l_decap_8
XFILLER_6_2408 vccd vssd sg13cmos5l_decap_8
XFILLER_34_7 vccd vssd sg13cmos5l_decap_8
XFILLER_2_483 vccd vssd sg13cmos5l_decap_8
XFILLER_43_2672 vccd vssd sg13cmos5l_decap_8
X_1210_ _1210_/Y mask_rev_in[4] _1210_/B vccd vssd sg13cmos5l_nand2_1
XFILLER_4_2121 vccd vssd sg13cmos5l_decap_8
XFILLER_6_1729 vccd vssd sg13cmos5l_decap_8
X_1141_ _1141_/X status[45] _1361_/B _1142_/B vccd vssd sg13cmos5l_a21o_1
XFILLER_24_2071 vccd vssd sg13cmos5l_decap_8
XFILLER_1_21 vccd vssd sg13cmos5l_decap_8
XFILLER_37_126 vccd vssd sg13cmos5l_decap_8
XFILLER_4_1442 vccd vssd sg13cmos5l_decap_8
XFILLER_4_2198 vccd vssd sg13cmos5l_decap_8
XFILLER_34_800 vccd vssd sg13cmos5l_decap_8
XFILLER_1_98 vccd vssd sg13cmos5l_decap_8
X_1072_ _1072_/Y _1197_/C _1077_/B vccd vssd sg13cmos5l_nor2_1
XFILLER_20_1267 vccd vssd sg13cmos5l_decap_8
XFILLER_19_896 vccd vssd sg13cmos5l_decap_8
XFILLER_34_855 vccd vssd sg13cmos5l_decap_8
XFILLER_33_343 vccd vssd sg13cmos5l_decap_8
XFILLER_37_2476 vccd vssd sg13cmos5l_decap_8
XFILLER_37_1731 vccd vssd sg13cmos5l_decap_8
XFILLER_18_1141 vccd vssd sg13cmos5l_decap_8
X_0925_ _0926_/B _0957_/S _0908_/B _0936_/B vccd vssd sg13cmos5l_o21ai_1
XFILLER_31_2086 vccd vssd sg13cmos5l_decap_8
XFILLER_11_1904 vccd vssd sg13cmos5l_decap_8
X_0856_ _0856_/Y status[83] vccd vssd sg13cmos5l_inv_1
Xoutbuffers\[74\] control[74] _1742_/Q vccd vssd sg13cmos5l_buf_8
XFILLER_44_2436 vccd vssd sg13cmos5l_decap_8
XFILLER_29_1270 vccd vssd sg13cmos5l_decap_4
XFILLER_9_2065 vccd vssd sg13cmos5l_decap_8
XFILLER_44_1735 vccd vssd sg13cmos5l_decap_8
XFILLER_29_28 vccd vssd sg13cmos5l_decap_8
X_1408_ _1408_/Y _1407_/A _1394_/B _1407_/B vccd vssd sg13cmos5l_o21ai_1
XFILLER_44_1779 vccd vssd sg13cmos5l_decap_8
XFILLER_5_1239 vccd vssd sg13cmos5l_decap_8
XFILLER_9_1386 vccd vssd sg13cmos5l_decap_8
X_1339_ _1339_/Y _1701_/Q _1463_/B vccd vssd sg13cmos5l_nor2b_1
XFILLER_28_126 vccd vssd sg13cmos5l_decap_8
XFILLER_25_1189 vccd vssd sg13cmos5l_decap_8
XFILLER_22_2767 vccd vssd sg13cmos5l_decap_8
XFILLER_38_2218 vccd vssd sg13cmos5l_decap_8
XFILLER_0_2541 vccd vssd sg13cmos5l_decap_8
XFILLER_45_49 vccd vssd sg13cmos5l_decap_8
XFILLER_25_822 vccd vssd sg13cmos5l_decap_8
XFILLER_24_343 vccd vssd sg13cmos5l_decap_8
XFILLER_0_1862 vccd vssd sg13cmos5l_decap_8
XFILLER_40_825 vccd vssd sg13cmos5l_decap_8
XFILLER_25_899 vccd vssd sg13cmos5l_decap_8
XFILLER_32_1127 vccd vssd sg13cmos5l_decap_8
XFILLER_20_560 vccd vssd sg13cmos5l_decap_8
XFILLER_16_1848 vccd vssd sg13cmos5l_decap_8
XFILLER_14_1561 vccd vssd sg13cmos5l_decap_8
XFILLER_10_1414 vccd vssd sg13cmos5l_decap_8
XFILLER_3_203 vccd vssd sg13cmos5l_decap_8
XFILLER_27_2623 vccd vssd sg13cmos5l_decap_8
XFILLER_10_63 vccd vssd sg13cmos5l_decap_8
XFILLER_27_1911 vccd vssd sg13cmos5l_decap_8
XFILLER_0_910 vccd vssd sg13cmos5l_decap_8
XFILLER_43_1201 vccd vssd sg13cmos5l_decap_4
XFILLER_27_1988 vccd vssd sg13cmos5l_decap_8
XFILLER_21_2211 vccd vssd sg13cmos5l_decap_8
XFILLER_0_987 vccd vssd sg13cmos5l_decap_8
XFILLER_43_1289 vccd vssd sg13cmos5l_decap_8
XFILLER_19_126 vccd vssd sg13cmos5l_decap_8
XFILLER_1_2338 vccd vssd sg13cmos5l_decap_8
XFILLER_5_2485 vccd vssd sg13cmos5l_decap_8
XFILLER_21_1543 vccd vssd sg13cmos5l_decap_8
XFILLER_16_833 vccd vssd sg13cmos5l_decap_8
XFILLER_1_1659 vccd vssd sg13cmos5l_decap_8
XFILLER_38_2763 vccd vssd sg13cmos5l_decap_8
XFILLER_15_343 vccd vssd sg13cmos5l_decap_8
XFILLER_42_140 vccd vssd sg13cmos5l_decap_8
XFILLER_34_2616 vccd vssd sg13cmos5l_decap_8
XFILLER_42_184 vccd vssd sg13cmos5l_decap_8
XFILLER_31_858 vccd vssd sg13cmos5l_decap_8
XFILLER_19_2195 vccd vssd sg13cmos5l_decap_8
XFILLER_15_2037 vccd vssd sg13cmos5l_decap_8
XFILLER_32_2340 vccd vssd sg13cmos5l_decap_8
XFILLER_30_357 vccd vssd sg13cmos5l_decap_8
XFILLER_11_560 vccd vssd sg13cmos5l_decap_8
XFILLER_32_2395 vccd vssd sg13cmos5l_decap_8
XFILLER_15_1358 vccd vssd sg13cmos5l_decap_8
Xhold509 _1794_/D _1596_/X vccd vssd sg13cmos5l_dlygate4sd3_1
X_1690_ _1690_/Q _1697_/CLK _1690_/D fanout134/X vccd vssd sg13cmos5l_dfrbpq_1
XFILLER_7_553 vccd vssd sg13cmos5l_decap_8
XFILLER_13_1071 vccd vssd sg13cmos5l_decap_8
XFILLER_45_2723 vccd vssd sg13cmos5l_decap_8
XFILLER_10_1981 vccd vssd sg13cmos5l_decap_8
XFILLER_26_2144 vccd vssd sg13cmos5l_decap_8
XFILLER_3_770 vccd vssd sg13cmos5l_decap_8
XFILLER_6_2205 vccd vssd sg13cmos5l_decap_8
XFILLER_2_280 vccd vssd sg13cmos5l_decap_8
XFILLER_41_1908 vccd vssd sg13cmos5l_decap_8
XFILLER_38_413 vccd vssd sg13cmos5l_decap_8
XFILLER_26_2199 vccd vssd sg13cmos5l_decap_8
XFILLER_26_1454 vccd vssd sg13cmos5l_decap_8
XFILLER_6_1526 vccd vssd sg13cmos5l_decap_8
XFILLER_22_1329 vccd vssd sg13cmos5l_decap_8
X_1124_ _1124_/Y mask_rev_in[14] _1064_/Y _1348_/B vccd vssd sg13cmos5l_o21ai_1
XFILLER_39_2549 vccd vssd sg13cmos5l_decap_8
X_1055_ _1055_/Y _1055_/A _1077_/B vccd vssd sg13cmos5l_nor2_1
XFILLER_20_1064 vccd vssd sg13cmos5l_decap_8
XFILLER_19_693 vccd vssd sg13cmos5l_decap_8
XFILLER_34_652 vccd vssd sg13cmos5l_decap_8
XFILLER_0_1169 vccd vssd sg13cmos5l_decap_8
XFILLER_33_2104 vccd vssd sg13cmos5l_decap_8
XFILLER_33_140 vccd vssd sg13cmos5l_decap_8
XFILLER_37_1561 vccd vssd sg13cmos5l_decap_8
XFILLER_22_847 vccd vssd sg13cmos5l_decap_8
XFILLER_21_357 vccd vssd sg13cmos5l_decap_8
X_0908_ _0909_/C _1800_/Q _0908_/B vccd vssd sg13cmos5l_and2_1
XFILLER_11_1701 vccd vssd sg13cmos5l_decap_8
XFILLER_11_2457 vccd vssd sg13cmos5l_decap_8
XFILLER_11_2479 vccd vssd sg13cmos5l_decap_8
X_0839_ _0839_/Y mask_rev_in[16] vccd vssd sg13cmos5l_inv_1
XFILLER_1_707 vccd vssd sg13cmos5l_decap_8
XFILLER_11_1778 vccd vssd sg13cmos5l_decap_8
XFILLER_44_2222 vccd vssd sg13cmos5l_decap_8
XFILLER_0_217 vccd vssd sg13cmos5l_decap_8
XFILLER_44_1532 vccd vssd sg13cmos5l_decap_8
XFILLER_44_2299 vccd vssd sg13cmos5l_decap_8
XFILLER_9_1183 vccd vssd sg13cmos5l_decap_8
XFILLER_29_413 vccd vssd sg13cmos5l_decap_8
XFILLER_22_2564 vccd vssd sg13cmos5l_decap_8
XFILLER_2_2625 vccd vssd sg13cmos5l_decap_8
XFILLER_5_1036 vccd vssd sg13cmos5l_decap_8
XFILLER_6_2783 vccd vssd sg13cmos5l_decap_8
XFILLER_45_917 vccd vssd sg13cmos5l_decap_8
XFILLER_22_1874 vccd vssd sg13cmos5l_decap_8
XFILLER_2_1946 vccd vssd sg13cmos5l_decap_8
XFILLER_24_140 vccd vssd sg13cmos5l_decap_8
XFILLER_25_696 vccd vssd sg13cmos5l_decap_8
XFILLER_13_847 vccd vssd sg13cmos5l_decap_8
XFILLER_40_655 vccd vssd sg13cmos5l_decap_8
XFILLER_36_1060 vccd vssd sg13cmos5l_decap_8
XFILLER_16_1645 vccd vssd sg13cmos5l_decap_8
XFILLER_12_357 vccd vssd sg13cmos5l_decap_8
XFILLER_33_2671 vccd vssd sg13cmos5l_decap_8
XFILLER_33_1981 vccd vssd sg13cmos5l_decap_8
XFILLER_10_1211 vccd vssd sg13cmos5l_decap_8
XFILLER_21_84 vccd vssd sg13cmos5l_decap_8
XFILLER_4_567 vccd vssd sg13cmos5l_decap_8
XFILLER_10_1288 vccd vssd sg13cmos5l_decap_8
XFILLER_7_1813 vccd vssd sg13cmos5l_decap_8
XFILLER_43_1042 vccd vssd sg13cmos5l_decap_4
XFILLER_27_1774 vccd vssd sg13cmos5l_decap_8
XFILLER_40_2631 vccd vssd sg13cmos5l_decap_8
XFILLER_0_784 vccd vssd sg13cmos5l_decap_8
XFILLER_40_1941 vccd vssd sg13cmos5l_decap_8
XFILLER_21_2063 vccd vssd sg13cmos5l_decap_8
XFILLER_1_2135 vccd vssd sg13cmos5l_decap_8
XFILLER_5_2282 vccd vssd sg13cmos5l_decap_8
XFILLER_35_427 vccd vssd sg13cmos5l_decap_8
XFILLER_21_1351 vccd vssd sg13cmos5l_decap_8
XFILLER_35_449 vccd vssd sg13cmos5l_decap_8
XFILLER_28_490 vccd vssd sg13cmos5l_decap_8
XFILLER_16_630 vccd vssd sg13cmos5l_decap_8
XFILLER_1_1456 vccd vssd sg13cmos5l_decap_8
XFILLER_44_972 vccd vssd sg13cmos5l_decap_8
XFILLER_43_460 vccd vssd sg13cmos5l_decap_8
XFILLER_38_2560 vccd vssd sg13cmos5l_decap_8
XFILLER_34_2413 vccd vssd sg13cmos5l_decap_8
XFILLER_15_140 vccd vssd sg13cmos5l_decap_8
XFILLER_34_2468 vccd vssd sg13cmos5l_decap_8
XFILLER_31_655 vccd vssd sg13cmos5l_decap_8
XFILLER_30_154 vccd vssd sg13cmos5l_decap_8
XFILLER_34_1778 vccd vssd sg13cmos5l_decap_8
XFILLER_15_1155 vccd vssd sg13cmos5l_decap_8
XFILLER_8_840 vccd vssd sg13cmos5l_decap_8
XFILLER_12_2733 vccd vssd sg13cmos5l_decap_8
X_1742_ _1742_/Q clkload2/A _1742_/D fanout122/X vccd vssd sg13cmos5l_dfrbpq_1
XFILLER_7_42 vccd vssd sg13cmos5l_decap_8
XFILLER_7_350 vccd vssd sg13cmos5l_decap_8
XFILLER_11_1008 vccd vssd sg13cmos5l_decap_8
Xhold317 _1683_/D _1438_/X vccd vssd sg13cmos5l_dlygate4sd3_1
Xhold306 _1589_/A _1788_/Q vccd vssd sg13cmos5l_dlygate4sd3_1
X_1673_ _1673_/Q clkload9/A _1673_/D _1603_/B_N vccd vssd sg13cmos5l_dfrbpq_1
XFILLER_32_1491 vccd vssd sg13cmos5l_decap_8
Xhold339 _1673_/D _1426_/X vccd vssd sg13cmos5l_dlygate4sd3_1
XFILLER_28_2217 vccd vssd sg13cmos5l_decap_8
Xhold328 hold328/X _1669_/Q vccd vssd sg13cmos5l_dlygate4sd3_1
XFILLER_45_2520 vccd vssd sg13cmos5l_decap_8
XFILLER_6_2002 vccd vssd sg13cmos5l_decap_8
XFILLER_45_2597 vccd vssd sg13cmos5l_decap_8
XFILLER_45_1841 vccd vssd sg13cmos5l_decap_8
XFILLER_41_1705 vccd vssd sg13cmos5l_decap_8
Xclkbuf_5_6_0_SCK clkload4/A clkbuf_5_7_0_SCK/A vccd vssd sg13cmos5l_buf_8
XFILLER_23_0 vccd vssd sg13cmos5l_decap_8
XFILLER_38_210 vccd vssd sg13cmos5l_decap_8
XFILLER_6_1323 vccd vssd sg13cmos5l_decap_8
XFILLER_6_2079 vccd vssd sg13cmos5l_decap_8
Xoutbuffers\[37\] control[37] _1705_/Q vccd vssd sg13cmos5l_buf_8
XFILLER_22_1148 vccd vssd sg13cmos5l_decap_8
XFILLER_38_287 vccd vssd sg13cmos5l_decap_8
XFILLER_26_427 vccd vssd sg13cmos5l_decap_8
XFILLER_39_2346 vccd vssd sg13cmos5l_decap_4
XFILLER_39_1623 vccd vssd sg13cmos5l_decap_8
X_1107_ _1107_/X _0870_/Y _1544_/B _1155_/B vccd vssd sg13cmos5l_a21o_1
XFILLER_19_490 vccd vssd sg13cmos5l_decap_8
X_1038_ _1038_/Y _1198_/A vccd vssd sg13cmos5l_inv_1
XFILLER_22_644 vccd vssd sg13cmos5l_decap_8
XFILLER_42_28 vccd vssd sg13cmos5l_decap_8
XFILLER_21_154 vccd vssd sg13cmos5l_decap_8
XFILLER_17_2699 vccd vssd sg13cmos5l_decap_8
XFILLER_33_1233 vccd vssd sg13cmos5l_decap_8
XFILLER_17_1965 vccd vssd sg13cmos5l_decap_8
XFILLER_11_2221 vccd vssd sg13cmos5l_decap_8
XFILLER_11_1575 vccd vssd sg13cmos5l_decap_8
XFILLER_11_2298 vccd vssd sg13cmos5l_decap_8
XFILLER_1_504 vccd vssd sg13cmos5l_decap_8
XFILLER_28_2784 vccd vssd sg13cmos5l_decap_8
XFILLER_24_2615 vccd vssd sg13cmos5l_decap_8
XFILLER_4_2709 vccd vssd sg13cmos5l_decap_8
XFILLER_44_2096 vccd vssd sg13cmos5l_decap_8
XFILLER_29_210 vccd vssd sg13cmos5l_decap_8
XFILLER_22_2350 vccd vssd sg13cmos5l_decap_8
XFILLER_18_917 vccd vssd sg13cmos5l_decap_8
XFILLER_2_2422 vccd vssd sg13cmos5l_decap_8
XFILLER_45_714 vccd vssd sg13cmos5l_decap_8
XFILLER_44_213 vccd vssd sg13cmos5l_decap_8
XFILLER_29_287 vccd vssd sg13cmos5l_decap_8
XFILLER_17_427 vccd vssd sg13cmos5l_decap_8
XFILLER_2_1743 vccd vssd sg13cmos5l_decap_8
XFILLER_6_1890 vccd vssd sg13cmos5l_decap_8
XFILLER_33_909 vccd vssd sg13cmos5l_decap_8
XFILLER_2_2499 vccd vssd sg13cmos5l_decap_8
XFILLER_38_1100 vccd vssd sg13cmos5l_decap_8
XFILLER_35_2700 vccd vssd sg13cmos5l_decap_8
XFILLER_38_1155 vccd vssd sg13cmos5l_decap_8
XFILLER_18_1729 vccd vssd sg13cmos5l_decap_8
XFILLER_16_84 vccd vssd sg13cmos5l_decap_8
XFILLER_13_644 vccd vssd sg13cmos5l_decap_8
XFILLER_41_964 vccd vssd sg13cmos5l_decap_8
XFILLER_35_2777 vccd vssd sg13cmos5l_decap_8
XFILLER_31_2619 vccd vssd sg13cmos5l_decap_8
XFILLER_12_154 vccd vssd sg13cmos5l_decap_8
XFILLER_16_1442 vccd vssd sg13cmos5l_decap_8
XFILLER_9_637 vccd vssd sg13cmos5l_decap_8
XFILLER_33_2490 vccd vssd sg13cmos5l_decap_8
XFILLER_8_147 vccd vssd sg13cmos5l_decap_8
Xtiedowns\[73\] status[73] vccd vssd sg13cmos5l_antennanp
XFILLER_5_854 vccd vssd sg13cmos5l_decap_8
XFILLER_29_2559 vccd vssd sg13cmos5l_decap_8
XFILLER_4_364 vccd vssd sg13cmos5l_decap_8
XFILLER_10_1085 vccd vssd sg13cmos5l_decap_8
XFILLER_45_1148 vccd vssd sg13cmos5l_decap_8
XFILLER_42_2748 vccd vssd sg13cmos5l_decap_8
XFILLER_7_1610 vccd vssd sg13cmos5l_decap_8
XFILLER_7_2366 vccd vssd sg13cmos5l_decap_8
XFILLER_23_2169 vccd vssd sg13cmos5l_decap_8
XFILLER_3_2219 vccd vssd sg13cmos5l_decap_8
XFILLER_0_581 vccd vssd sg13cmos5l_decap_8
XFILLER_40_2450 vccd vssd sg13cmos5l_decap_8
XFILLER_23_1457 vccd vssd sg13cmos5l_decap_4
XFILLER_7_1687 vccd vssd sg13cmos5l_decap_8
XFILLER_40_1760 vccd vssd sg13cmos5l_decap_8
XFILLER_35_224 vccd vssd sg13cmos5l_decap_8
Xoutbuffers\[127\] control[127] _1795_/Q vccd vssd sg13cmos5l_buf_8
XFILLER_1_1253 vccd vssd sg13cmos5l_decap_8
XFILLER_44_791 vccd vssd sg13cmos5l_decap_4
XFILLER_34_2221 vccd vssd sg13cmos5l_decap_8
XFILLER_17_994 vccd vssd sg13cmos5l_decap_8
XFILLER_32_953 vccd vssd sg13cmos5l_decap_8
XFILLER_31_441 vccd vssd sg13cmos5l_decap_8
XFILLER_17_1239 vccd vssd sg13cmos5l_decap_8
XFILLER_30_2118 vccd vssd sg13cmos5l_decap_8
XFILLER_34_1597 vccd vssd sg13cmos5l_decap_8
X_1725_ _1725_/Q clkload3/A _1725_/D fanout125/X vccd vssd sg13cmos5l_dfrbpq_1
XFILLER_12_2563 vccd vssd sg13cmos5l_decap_4
XFILLER_12_1862 vccd vssd sg13cmos5l_decap_8
XFILLER_12_2596 vccd vssd sg13cmos5l_decap_8
XFILLER_28_1302 vccd vssd sg13cmos5l_decap_8
X_1656_ _1656_/Q _1656_/CLK _1656_/D _1608_/Y vccd vssd sg13cmos5l_dfrbpq_1
X_1587_ _1587_/X _1542_/A hold458/X _1587_/S vccd vssd sg13cmos5l_mux2_1
XFILLER_8_1407 vccd vssd sg13cmos5l_decap_8
XFILLER_45_2394 vccd vssd sg13cmos5l_decap_8
XFILLER_41_2258 vccd vssd sg13cmos5l_decap_8
XFILLER_6_1120 vccd vssd sg13cmos5l_decap_8
XFILLER_37_28 vccd vssd sg13cmos5l_decap_8
XFILLER_3_2786 vccd vssd sg13cmos5l_decap_4
XFILLER_6_1197 vccd vssd sg13cmos5l_decap_8
XFILLER_39_2110 vccd vssd sg13cmos5l_decap_8
XFILLER_27_747 vccd vssd sg13cmos5l_decap_8
XFILLER_26_224 vccd vssd sg13cmos5l_decap_8
XFILLER_19_2706 vccd vssd sg13cmos5l_decap_8
XFILLER_39_2176 vccd vssd sg13cmos5l_decap_8
XFILLER_42_739 vccd vssd sg13cmos5l_decap_8
XFILLER_41_238 vccd vssd sg13cmos5l_decap_8
XFILLER_23_931 vccd vssd sg13cmos5l_decap_8
XFILLER_22_441 vccd vssd sg13cmos5l_decap_8
XFILLER_17_2441 vccd vssd sg13cmos5l_decap_8
XFILLER_10_658 vccd vssd sg13cmos5l_decap_8
XFILLER_13_2349 vccd vssd sg13cmos5l_decap_8
XFILLER_30_2652 vccd vssd sg13cmos5l_decap_8
XFILLER_11_2051 vccd vssd sg13cmos5l_decap_8
XFILLER_13_1659 vccd vssd sg13cmos5l_decap_8
XFILLER_30_1973 vccd vssd sg13cmos5l_decap_8
XFILLER_1_301 vccd vssd sg13cmos5l_decap_8
XFILLER_11_1372 vccd vssd sg13cmos5l_decap_8
XFILLER_24_2412 vccd vssd sg13cmos5l_decap_8
XFILLER_2_868 vccd vssd sg13cmos5l_decap_8
XFILLER_8_2642 vccd vssd sg13cmos5l_decap_8
XFILLER_24_1722 vccd vssd sg13cmos5l_decap_8
XFILLER_1_378 vccd vssd sg13cmos5l_decap_8
XFILLER_4_2506 vccd vssd sg13cmos5l_decap_8
XFILLER_8_2697 vccd vssd sg13cmos5l_decap_8
XFILLER_4_1827 vccd vssd sg13cmos5l_decap_8
XFILLER_8_1974 vccd vssd sg13cmos5l_decap_8
XFILLER_45_511 vccd vssd sg13cmos5l_decap_8
XFILLER_40_1045 vccd vssd sg13cmos5l_decap_8
XFILLER_24_1777 vccd vssd sg13cmos5l_decap_8
XFILLER_20_1619 vccd vssd sg13cmos5l_decap_8
XFILLER_18_714 vccd vssd sg13cmos5l_decap_8
XFILLER_17_224 vccd vssd sg13cmos5l_decap_8
XFILLER_2_2296 vccd vssd sg13cmos5l_decap_8
XFILLER_2_1540 vccd vssd sg13cmos5l_decap_8
XFILLER_45_588 vccd vssd sg13cmos5l_decap_8
XFILLER_32_238 vccd vssd sg13cmos5l_decap_8
XFILLER_26_780 vccd vssd sg13cmos5l_decap_8
XFILLER_18_2227 vccd vssd sg13cmos5l_decap_8
XFILLER_14_931 vccd vssd sg13cmos5l_decap_8
XFILLER_41_761 vccd vssd sg13cmos5l_decap_8
XFILLER_18_1526 vccd vssd sg13cmos5l_decap_8
XFILLER_13_441 vccd vssd sg13cmos5l_decap_8
XFILLER_43_71 vccd vssd sg13cmos5l_decap_4
XFILLER_35_2574 vccd vssd sg13cmos5l_decap_8
XFILLER_9_434 vccd vssd sg13cmos5l_decap_8
XFILLER_31_1748 vccd vssd sg13cmos5l_decap_8
XFILLER_12_1169 vccd vssd sg13cmos5l_decap_8
X_1510_ _1519_/S _1520_/A _1510_/B vccd vssd sg13cmos5l_nand2_1
XFILLER_5_651 vccd vssd sg13cmos5l_decap_8
X_1441_ _1684_/D _1600_/A1 _1449_/B hold215/X vccd vssd sg13cmos5l_o21ai_1
XFILLER_29_1622 vccd vssd sg13cmos5l_decap_8
XFILLER_4_21 vccd vssd sg13cmos5l_decap_8
XFILLER_4_161 vccd vssd sg13cmos5l_decap_8
XFILLER_42_2545 vccd vssd sg13cmos5l_decap_8
X_1372_ _1374_/C _1748_/Q _1531_/B _1372_/B1 vccd vssd sg13cmos5l_a21oi_1
XFILLER_27_2080 vccd vssd sg13cmos5l_decap_8
XFILLER_25_1519 vccd vssd sg13cmos5l_decap_8
XFILLER_4_98 vccd vssd sg13cmos5l_decap_8
XFILLER_7_2163 vccd vssd sg13cmos5l_decap_8
XFILLER_3_2016 vccd vssd sg13cmos5l_decap_8
Xtiedowns\[117\] status[117] vccd vssd sg13cmos5l_antennanp
XFILLER_23_1254 vccd vssd sg13cmos5l_decap_8
XFILLER_3_1337 vccd vssd sg13cmos5l_decap_8
XFILLER_7_1484 vccd vssd sg13cmos5l_decap_8
XFILLER_24_728 vccd vssd sg13cmos5l_decap_8
XFILLER_1_1050 vccd vssd sg13cmos5l_decap_8
XFILLER_36_2349 vccd vssd sg13cmos5l_decap_8
XFILLER_23_238 vccd vssd sg13cmos5l_decap_8
XFILLER_17_791 vccd vssd sg13cmos5l_decap_8
XFILLER_36_1626 vccd vssd sg13cmos5l_decap_8
XFILLER_18_2750 vccd vssd sg13cmos5l_decap_8
XFILLER_34_2062 vccd vssd sg13cmos5l_decap_8
Xoutbuffers\[0\] control[0] _1668_/Q vccd vssd sg13cmos5l_buf_8
XFILLER_32_783 vccd vssd sg13cmos5l_decap_8
XFILLER_17_1036 vccd vssd sg13cmos5l_decap_8
XFILLER_14_2614 vccd vssd sg13cmos5l_decap_8
XFILLER_34_1350 vccd vssd sg13cmos5l_decap_8
XFILLER_20_945 vccd vssd sg13cmos5l_decap_8
XFILLER_14_1946 vccd vssd sg13cmos5l_decap_8
XFILLER_30_1236 vccd vssd sg13cmos5l_decap_8
X_1708_ _1708_/Q _1713_/CLK _1708_/D fanout130/X vccd vssd sg13cmos5l_dfrbpq_1
X_1639_ _1639_/Y _1639_/A _1639_/B_N vccd vssd sg13cmos5l_nor2b_1
XFILLER_25_2721 vccd vssd sg13cmos5l_decap_8
XFILLER_8_1204 vccd vssd sg13cmos5l_decap_8
XFILLER_45_2191 vccd vssd sg13cmos5l_decap_8
XFILLER_28_1176 vccd vssd sg13cmos5l_decap_8
XFILLER_41_2055 vccd vssd sg13cmos5l_decap_8
XFILLER_21_2629 vccd vssd sg13cmos5l_decap_8
XFILLER_41_1332 vccd vssd sg13cmos5l_decap_8
XFILLER_27_511 vccd vssd sg13cmos5l_decap_8
XFILLER_41_1398 vccd vssd sg13cmos5l_decap_8
XFILLER_3_2583 vccd vssd sg13cmos5l_decap_8
XFILLER_19_2525 vccd vssd sg13cmos5l_decap_8
XFILLER_15_728 vccd vssd sg13cmos5l_decap_8
XFILLER_42_536 vccd vssd sg13cmos5l_decap_8
XFILLER_19_1802 vccd vssd sg13cmos5l_decap_8
XFILLER_14_238 vccd vssd sg13cmos5l_decap_8
Xfanout31 _1463_/B _1046_/Y vccd vssd sg13cmos5l_buf_1
Xfanout20 _1389_/A2 _1070_/Y vccd vssd sg13cmos5l_buf_1
Xfanout53 _1232_/B _1010_/Y vccd vssd sg13cmos5l_buf_1
Xfanout64 _1362_/A2 _0992_/Y vccd vssd sg13cmos5l_buf_1
XFILLER_35_1125 vccd vssd sg13cmos5l_decap_8
XFILLER_32_2714 vccd vssd sg13cmos5l_decap_8
Xfanout42 _1155_/B _1531_/B vccd vssd sg13cmos5l_buf_1
Xfanout75 _1357_/C1 _1358_/A2 vccd vssd sg13cmos5l_buf_16
Xfanout86 _1588_/A _1520_/A vccd vssd sg13cmos5l_buf_1
Xfanout97 _1495_/A _1553_/A vccd vssd sg13cmos5l_buf_1
XFILLER_11_945 vccd vssd sg13cmos5l_decap_8
XFILLER_7_938 vccd vssd sg13cmos5l_decap_8
XFILLER_10_455 vccd vssd sg13cmos5l_decap_8
XFILLER_13_63 vccd vssd sg13cmos5l_decap_8
XFILLER_6_448 vccd vssd sg13cmos5l_decap_8
XFILLER_13_1456 vccd vssd sg13cmos5l_decap_8
XFILLER_26_1817 vccd vssd sg13cmos5l_decap_8
XFILLER_2_665 vccd vssd sg13cmos5l_decap_8
XFILLER_1_175 vccd vssd sg13cmos5l_decap_8
XFILLER_4_2303 vccd vssd sg13cmos5l_decap_8
XFILLER_8_2450 vccd vssd sg13cmos5l_decap_8
Xtiedowns\[36\] status[36] vccd vssd sg13cmos5l_antennanp
XFILLER_42_1118 vccd vssd sg13cmos5l_decap_8
XFILLER_8_1771 vccd vssd sg13cmos5l_decap_8
XFILLER_37_308 vccd vssd sg13cmos5l_decap_8
XFILLER_24_1574 vccd vssd sg13cmos5l_decap_8
XFILLER_24_1552 vccd vssd sg13cmos5l_decap_4
XFILLER_18_511 vccd vssd sg13cmos5l_decap_8
XFILLER_4_1624 vccd vssd sg13cmos5l_decap_8
XFILLER_2_2093 vccd vssd sg13cmos5l_decap_8
XFILLER_45_385 vccd vssd sg13cmos5l_decap_8
XFILLER_37_2625 vccd vssd sg13cmos5l_decap_8
XFILLER_33_514 vccd vssd sg13cmos5l_decap_8
X_1624__155 _1660_/CLK _1652_/CLK vccd vssd sg13cmos5l_inv_1
XFILLER_18_588 vccd vssd sg13cmos5l_decap_8
XFILLER_18_2046 vccd vssd sg13cmos5l_decap_8
XFILLER_18_1323 vccd vssd sg13cmos5l_decap_8
XFILLER_37_1968 vccd vssd sg13cmos5l_decap_8
XFILLER_35_2371 vccd vssd sg13cmos5l_decap_8
XFILLER_31_2202 vccd vssd sg13cmos5l_decap_8
X_0941_ _0942_/B SDI _0835_/A _0938_/B _0938_/C vccd vssd sg13cmos5l_a22oi_1
XFILLER_31_2235 vccd vssd sg13cmos5l_decap_8
XFILLER_31_1501 vccd vssd sg13cmos5l_decap_8
XFILLER_9_231 vccd vssd sg13cmos5l_decap_8
X_0872_ _0872_/Y status[62] vccd vssd sg13cmos5l_inv_1
XFILLER_35_1692 vccd vssd sg13cmos5l_decap_8
Xclkload12 clkload12/Y _1652_/CLK vccd vssd sg13cmos5l_inv_1
XFILLER_44_2618 vccd vssd sg13cmos5l_decap_8
XFILLER_25_2028 vccd vssd sg13cmos5l_decap_8
X_1631__159 _1667_/CLK _1631__159/A vccd vssd sg13cmos5l_inv_1
XFILLER_9_2247 vccd vssd sg13cmos5l_decap_8
X_1424_ _1424_/X _1445_/A hold302/X _1428_/S vccd vssd sg13cmos5l_mux2_1
X_1355_ _1380_/A _1692_/Q _1453_/B vccd vssd sg13cmos5l_nand2b_1
XFILLER_9_1568 vccd vssd sg13cmos5l_decap_8
XFILLER_42_1652 vccd vssd sg13cmos5l_decap_8
XFILLER_28_308 vccd vssd sg13cmos5l_decap_8
XFILLER_7_1281 vccd vssd sg13cmos5l_decap_8
XFILLER_37_831 vccd vssd sg13cmos5l_decap_8
X_1286_ _1288_/B _1742_/Q _1520_/B vccd vssd sg13cmos5l_nand2_1
XFILLER_3_1134 vccd vssd sg13cmos5l_decap_8
XFILLER_0_2723 vccd vssd sg13cmos5l_decap_8
XFILLER_23_1084 vccd vssd sg13cmos5l_decap_8
XFILLER_20_2695 vccd vssd sg13cmos5l_decap_8
XFILLER_36_385 vccd vssd sg13cmos5l_decap_8
XFILLER_24_525 vccd vssd sg13cmos5l_decap_8
XFILLER_20_1994 vccd vssd sg13cmos5l_decap_8
XFILLER_36_1412 vccd vssd sg13cmos5l_decap_8
XFILLER_14_2400 vccd vssd sg13cmos5l_decap_8
XFILLER_36_1478 vccd vssd sg13cmos5l_decap_8
XFILLER_20_742 vccd vssd sg13cmos5l_decap_8
Xclkload6 clkload6/Y clkload6/A vccd vssd sg13cmos5l_inv_1
XFILLER_14_1743 vccd vssd sg13cmos5l_decap_8
XFILLER_14_2477 vccd vssd sg13cmos5l_decap_8
XFILLER_31_2780 vccd vssd sg13cmos5l_decap_8
XFILLER_8_1001 vccd vssd sg13cmos5l_decap_8
XFILLER_9_2770 vccd vssd sg13cmos5l_decap_8
XFILLER_25_2573 vccd vssd sg13cmos5l_decap_8
XFILLER_5_1911 vccd vssd sg13cmos5l_decap_8
XFILLER_5_2623 vccd vssd sg13cmos5l_decap_4
XFILLER_21_2426 vccd vssd sg13cmos5l_decap_8
XFILLER_19_308 vccd vssd sg13cmos5l_decap_8
XFILLER_5_2689 vccd vssd sg13cmos5l_decap_8
XFILLER_8_1078 vccd vssd sg13cmos5l_decap_8
XFILLER_21_1725 vccd vssd sg13cmos5l_decap_8
XFILLER_3_2380 vccd vssd sg13cmos5l_decap_8
XFILLER_5_1988 vccd vssd sg13cmos5l_decap_8
XFILLER_27_385 vccd vssd sg13cmos5l_decap_8
XFILLER_15_525 vccd vssd sg13cmos5l_decap_8
XFILLER_37_1209 vccd vssd sg13cmos5l_decap_8
XFILLER_19_1610 vccd vssd sg13cmos5l_decap_8
XFILLER_43_889 vccd vssd sg13cmos5l_decap_8
XFILLER_39_1091 vccd vssd sg13cmos5l_decap_8
XFILLER_32_2500 vccd vssd sg13cmos5l_decap_8
XFILLER_19_2399 vccd vssd sg13cmos5l_decap_8
XFILLER_24_84 vccd vssd sg13cmos5l_decap_8
XFILLER_19_1687 vccd vssd sg13cmos5l_decap_8
XFILLER_11_742 vccd vssd sg13cmos5l_decap_8
XFILLER_10_252 vccd vssd sg13cmos5l_decap_8
XFILLER_32_2588 vccd vssd sg13cmos5l_decap_8
XFILLER_7_735 vccd vssd sg13cmos5l_decap_8
XFILLER_13_1253 vccd vssd sg13cmos5l_decap_8
XFILLER_6_245 vccd vssd sg13cmos5l_decap_8
XFILLER_26_2315 vccd vssd sg13cmos5l_decap_8
XFILLER_3_952 vccd vssd sg13cmos5l_decap_8
XFILLER_2_462 vccd vssd sg13cmos5l_decap_8
XFILLER_43_2662 vccd vssd sg13cmos5l_decap_8
XFILLER_26_1658 vccd vssd sg13cmos5l_decap_8
XFILLER_27_7 vccd vssd sg13cmos5l_decap_8
XFILLER_4_2100 vccd vssd sg13cmos5l_decap_8
XFILLER_6_1708 vccd vssd sg13cmos5l_decap_8
X_1140_ _1140_/Y _0864_/Y _1268_/B1 _1138_/X _1139_/Y _1317_/B1 vccd vssd sg13cmos5l_a221oi_1
XFILLER_38_617 vccd vssd sg13cmos5l_decap_8
XFILLER_37_105 vccd vssd sg13cmos5l_decap_8
XFILLER_43_1983 vccd vssd sg13cmos5l_decap_8
XFILLER_4_1421 vccd vssd sg13cmos5l_decap_8
XFILLER_4_2177 vccd vssd sg13cmos5l_decap_8
XFILLER_20_1246 vccd vssd sg13cmos5l_decap_8
XFILLER_19_875 vccd vssd sg13cmos5l_decap_8
XFILLER_1_77 vccd vssd sg13cmos5l_decap_8
X_1071_ _1071_/X mask_rev_in[23] _1347_/B1 _1350_/B vccd vssd sg13cmos5l_a21o_1
XFILLER_37_2411 vccd vssd sg13cmos5l_decap_8
XFILLER_18_385 vccd vssd sg13cmos5l_decap_8
XFILLER_4_1498 vccd vssd sg13cmos5l_decap_8
XFILLER_45_182 vccd vssd sg13cmos5l_decap_8
XFILLER_33_322 vccd vssd sg13cmos5l_decap_8
XFILLER_18_1120 vccd vssd sg13cmos5l_decap_8
XFILLER_37_1787 vccd vssd sg13cmos5l_decap_8
XFILLER_33_399 vccd vssd sg13cmos5l_decap_8
XFILLER_21_539 vccd vssd sg13cmos5l_decap_8
XFILLER_31_2021 vccd vssd sg13cmos5l_decap_4
X_0924_ _0924_/Y _0924_/A _0938_/B vccd vssd sg13cmos5l_nand2_1
XFILLER_18_1197 vccd vssd sg13cmos5l_decap_8
XFILLER_15_2786 vccd vssd sg13cmos5l_decap_4
X_0855_ _0855_/Y status[59] vccd vssd sg13cmos5l_inv_1
XFILLER_31_2065 vccd vssd sg13cmos5l_decap_8
XFILLER_31_1386 vccd vssd sg13cmos5l_decap_8
XFILLER_44_2415 vccd vssd sg13cmos5l_decap_8
XFILLER_44_1714 vccd vssd sg13cmos5l_decap_8
Xoutbuffers\[67\] control[67] _1735_/Q vccd vssd sg13cmos5l_buf_8
XFILLER_9_2044 vccd vssd sg13cmos5l_decap_8
X_1407_ _1412_/B _1407_/A _1407_/B vccd vssd sg13cmos5l_nand2_1
XFILLER_9_1365 vccd vssd sg13cmos5l_decap_8
XFILLER_28_105 vccd vssd sg13cmos5l_decap_8
XFILLER_25_1168 vccd vssd sg13cmos5l_decap_8
XFILLER_22_2746 vccd vssd sg13cmos5l_decap_8
XFILLER_5_1218 vccd vssd sg13cmos5l_decap_8
X_1338_ _1338_/Y _1709_/Q _1474_/B _1337_/Y _1336_/Y _1162_/B vccd vssd sg13cmos5l_a221oi_1
XFILLER_29_639 vccd vssd sg13cmos5l_decap_8
XFILLER_45_28 vccd vssd sg13cmos5l_decap_8
X_1269_ _1269_/Y _0848_/Y _1362_/B1 _1317_/B1 vccd vssd sg13cmos5l_a21oi_1
XFILLER_25_801 vccd vssd sg13cmos5l_decap_8
XFILLER_0_2520 vccd vssd sg13cmos5l_decap_8
XFILLER_43_108 vccd vssd sg13cmos5l_decap_4
XFILLER_20_2492 vccd vssd sg13cmos5l_decap_8
XFILLER_0_1841 vccd vssd sg13cmos5l_decap_8
XFILLER_36_182 vccd vssd sg13cmos5l_decap_8
XFILLER_25_878 vccd vssd sg13cmos5l_decap_8
XFILLER_24_322 vccd vssd sg13cmos5l_decap_8
XFILLER_20_1780 vccd vssd sg13cmos5l_decap_4
XFILLER_0_2597 vccd vssd sg13cmos5l_decap_8
XFILLER_40_804 vccd vssd sg13cmos5l_decap_8
XFILLER_40_859 vccd vssd sg13cmos5l_decap_8
XFILLER_36_1242 vccd vssd sg13cmos5l_decap_8
XFILLER_24_399 vccd vssd sg13cmos5l_decap_8
XFILLER_16_1827 vccd vssd sg13cmos5l_decap_8
XFILLER_12_539 vccd vssd sg13cmos5l_decap_8
XFILLER_32_1106 vccd vssd sg13cmos5l_decap_8
XFILLER_14_1540 vccd vssd sg13cmos5l_decap_8
XFILLER_14_2285 vccd vssd sg13cmos5l_decap_4
XFILLER_10_2149 vccd vssd sg13cmos5l_decap_8
XFILLER_27_2602 vccd vssd sg13cmos5l_decap_8
XFILLER_4_749 vccd vssd sg13cmos5l_decap_8
XFILLER_3_259 vccd vssd sg13cmos5l_decap_8
XFILLER_10_42 vccd vssd sg13cmos5l_decap_8
XFILLER_7_2729 vccd vssd sg13cmos5l_decap_8
XFILLER_27_2679 vccd vssd sg13cmos5l_decap_8
XFILLER_27_1967 vccd vssd sg13cmos5l_decap_8
XFILLER_0_966 vccd vssd sg13cmos5l_decap_8
XFILLER_25_2381 vccd vssd sg13cmos5l_decap_8
XFILLER_19_105 vccd vssd sg13cmos5l_decap_8
XFILLER_5_2464 vccd vssd sg13cmos5l_decap_8
XFILLER_21_1522 vccd vssd sg13cmos5l_decap_8
XFILLER_1_2317 vccd vssd sg13cmos5l_decap_8
XFILLER_21_2278 vccd vssd sg13cmos5l_decap_8
XFILLER_19_84 vccd vssd sg13cmos5l_decap_8
XFILLER_5_1785 vccd vssd sg13cmos5l_decap_8
XFILLER_34_119 vccd vssd sg13cmos5l_decap_8
XFILLER_16_812 vccd vssd sg13cmos5l_decap_8
XFILLER_1_1638 vccd vssd sg13cmos5l_decap_8
XFILLER_38_2742 vccd vssd sg13cmos5l_decap_8
XFILLER_27_182 vccd vssd sg13cmos5l_decap_8
XFILLER_21_1599 vccd vssd sg13cmos5l_decap_8
XFILLER_15_322 vccd vssd sg13cmos5l_decap_8
XFILLER_19_2163 vccd vssd sg13cmos5l_decap_8
XFILLER_16_889 vccd vssd sg13cmos5l_decap_8
XFILLER_15_2016 vccd vssd sg13cmos5l_decap_8
XFILLER_31_837 vccd vssd sg13cmos5l_decap_8
XFILLER_30_336 vccd vssd sg13cmos5l_decap_8
XFILLER_15_399 vccd vssd sg13cmos5l_decap_8
XFILLER_19_1484 vccd vssd sg13cmos5l_decap_8
XFILLER_15_1337 vccd vssd sg13cmos5l_decap_8
XFILLER_32_2374 vccd vssd sg13cmos5l_decap_8
XFILLER_7_532 vccd vssd sg13cmos5l_decap_8
XFILLER_13_1050 vccd vssd sg13cmos5l_decap_8
XFILLER_45_2702 vccd vssd sg13cmos5l_decap_8
XFILLER_10_1960 vccd vssd sg13cmos5l_decap_8
XFILLER_26_2123 vccd vssd sg13cmos5l_decap_8
XFILLER_45_2779 vccd vssd sg13cmos5l_decap_8
XFILLER_26_1433 vccd vssd sg13cmos5l_decap_8
XFILLER_6_1505 vccd vssd sg13cmos5l_decap_8
XFILLER_39_937 vccd vssd sg13cmos5l_decap_8
XFILLER_22_1308 vccd vssd sg13cmos5l_decap_8
X_1123_ _1123_/Y mask_rev_in[6] _1210_/B _1306_/B vccd vssd sg13cmos5l_a21oi_1
XFILLER_39_2528 vccd vssd sg13cmos5l_decap_8
XFILLER_39_1805 vccd vssd sg13cmos5l_decap_4
X_1054_ _1054_/Y _1051_/X _1049_/Y _1053_/Y vccd vssd sg13cmos5l_o21ai_1
XFILLER_25_119 vccd vssd sg13cmos5l_decap_8
XFILLER_20_1043 vccd vssd sg13cmos5l_decap_8
XFILLER_19_672 vccd vssd sg13cmos5l_decap_8
XFILLER_4_1295 vccd vssd sg13cmos5l_decap_8
XFILLER_34_620 vccd vssd sg13cmos5l_decap_8
XFILLER_18_182 vccd vssd sg13cmos5l_decap_8
XFILLER_0_1148 vccd vssd sg13cmos5l_decap_8
XFILLER_22_826 vccd vssd sg13cmos5l_decap_8
XFILLER_33_196 vccd vssd sg13cmos5l_decap_8
XFILLER_21_336 vccd vssd sg13cmos5l_decap_8
XFILLER_11_2403 vccd vssd sg13cmos5l_decap_8
XFILLER_33_1459 vccd vssd sg13cmos5l_decap_8
X_0907_ _0908_/B _0928_/A _0938_/A _0940_/A vccd vssd sg13cmos5l_and3_1
XFILLER_11_1757 vccd vssd sg13cmos5l_decap_8
X_0838_ _0838_/Y mask_rev_in[0] vccd vssd sg13cmos5l_inv_1
XFILLER_44_2201 vccd vssd sg13cmos5l_decap_8
XFILLER_44_1511 vccd vssd sg13cmos5l_decap_8
XFILLER_44_2278 vccd vssd sg13cmos5l_decap_8
XFILLER_40_2109 vccd vssd sg13cmos5l_decap_8
XFILLER_6_2762 vccd vssd sg13cmos5l_decap_8
XFILLER_9_1162 vccd vssd sg13cmos5l_decap_8
XFILLER_44_1588 vccd vssd sg13cmos5l_decap_8
XFILLER_22_2543 vccd vssd sg13cmos5l_decap_8
XFILLER_2_2604 vccd vssd sg13cmos5l_decap_8
XFILLER_5_1015 vccd vssd sg13cmos5l_decap_8
XFILLER_22_1853 vccd vssd sg13cmos5l_decap_8
XFILLER_17_609 vccd vssd sg13cmos5l_decap_8
XFILLER_2_1925 vccd vssd sg13cmos5l_decap_8
XFILLER_44_406 vccd vssd sg13cmos5l_decap_8
XFILLER_38_981 vccd vssd sg13cmos5l_decap_8
XFILLER_16_119 vccd vssd sg13cmos5l_decap_8
XFILLER_38_2049 vccd vssd sg13cmos5l_decap_8
XFILLER_0_2394 vccd vssd sg13cmos5l_decap_8
XFILLER_40_612 vccd vssd sg13cmos5l_decap_8
XFILLER_25_675 vccd vssd sg13cmos5l_decap_8
XFILLER_13_826 vccd vssd sg13cmos5l_decap_8
XFILLER_24_196 vccd vssd sg13cmos5l_decap_8
XFILLER_16_2325 vccd vssd sg13cmos5l_decap_4
XFILLER_12_336 vccd vssd sg13cmos5l_decap_8
XFILLER_33_2650 vccd vssd sg13cmos5l_decap_8
XFILLER_16_1624 vccd vssd sg13cmos5l_decap_8
XFILLER_9_819 vccd vssd sg13cmos5l_decap_8
XFILLER_8_329 vccd vssd sg13cmos5l_decap_8
XFILLER_33_1960 vccd vssd sg13cmos5l_decap_8
XFILLER_14_2093 vccd vssd sg13cmos5l_decap_8
XFILLER_21_63 vccd vssd sg13cmos5l_decap_8
XFILLER_45_2009 vccd vssd sg13cmos5l_decap_8
XFILLER_4_546 vccd vssd sg13cmos5l_decap_8
XFILLER_10_1267 vccd vssd sg13cmos5l_decap_8
XFILLER_27_2443 vccd vssd sg13cmos5l_decap_8
XFILLER_7_2548 vccd vssd sg13cmos5l_decap_8
XFILLER_40_2610 vccd vssd sg13cmos5l_decap_8
XFILLER_0_763 vccd vssd sg13cmos5l_decap_8
XFILLER_5_2261 vccd vssd sg13cmos5l_decap_8
XFILLER_7_1869 vccd vssd sg13cmos5l_decap_8
XFILLER_40_2687 vccd vssd sg13cmos5l_decap_8
XFILLER_21_1330 vccd vssd sg13cmos5l_decap_8
XFILLER_1_2114 vccd vssd sg13cmos5l_decap_8
XFILLER_35_406 vccd vssd sg13cmos5l_decap_8
XFILLER_1_1435 vccd vssd sg13cmos5l_decap_8
XFILLER_5_1582 vccd vssd sg13cmos5l_decap_8
XFILLER_44_951 vccd vssd sg13cmos5l_decap_8
XFILLER_40_1997 vccd vssd sg13cmos5l_decap_8
XFILLER_16_686 vccd vssd sg13cmos5l_decap_8
XFILLER_15_196 vccd vssd sg13cmos5l_decap_8
XFILLER_30_133 vccd vssd sg13cmos5l_decap_8
XFILLER_19_1281 vccd vssd sg13cmos5l_decap_8
XFILLER_12_2701 vccd vssd sg13cmos5l_decap_8
XFILLER_34_1746 vccd vssd sg13cmos5l_decap_8
XFILLER_15_1134 vccd vssd sg13cmos5l_decap_8
XFILLER_7_21 vccd vssd sg13cmos5l_decap_8
X_1741_ _1741_/Q clkload2/A _1741_/D fanout122/X vccd vssd sg13cmos5l_dfrbpq_1
Xhold307 hold307/X _1589_/Y vccd vssd sg13cmos5l_dlygate4sd3_1
XFILLER_32_1470 vccd vssd sg13cmos5l_decap_8
X_1672_ _1672_/Q clkload9/A _1672_/D _1617_/B_N vccd vssd sg13cmos5l_dfrbpq_1
XFILLER_8_896 vccd vssd sg13cmos5l_decap_8
Xhold318 hold318/X _1679_/Q vccd vssd sg13cmos5l_dlygate4sd3_1
Xhold329 _1669_/D _1422_/X vccd vssd sg13cmos5l_dlygate4sd3_1
XFILLER_7_98 vccd vssd sg13cmos5l_decap_8
XFILLER_10_2480 vccd vssd sg13cmos5l_decap_8
XFILLER_45_2576 vccd vssd sg13cmos5l_decap_8
XFILLER_45_1820 vccd vssd sg13cmos5l_decap_8
XFILLER_41_2429 vccd vssd sg13cmos5l_decap_8
XFILLER_6_1302 vccd vssd sg13cmos5l_decap_8
XFILLER_6_2058 vccd vssd sg13cmos5l_decap_8
XFILLER_45_1897 vccd vssd sg13cmos5l_decap_8
XFILLER_22_1127 vccd vssd sg13cmos5l_decap_8
XFILLER_16_0 vccd vssd sg13cmos5l_decap_8
XFILLER_6_1379 vccd vssd sg13cmos5l_decap_8
XFILLER_39_2325 vccd vssd sg13cmos5l_decap_8
XFILLER_38_266 vccd vssd sg13cmos5l_decap_8
X_1106_ _1106_/Y _1770_/Q _1152_/B _1104_/Y _1105_/Y _1544_/B vccd vssd sg13cmos5l_a221oi_1
XFILLER_26_406 vccd vssd sg13cmos5l_decap_8
XFILLER_1_2681 vccd vssd sg13cmos5l_decap_8
XFILLER_4_1092 vccd vssd sg13cmos5l_decap_8
XFILLER_35_984 vccd vssd sg13cmos5l_decap_8
X_1037_ _1037_/Y _1197_/B _1077_/A vccd vssd sg13cmos5l_nor2_1
XFILLER_39_1679 vccd vssd sg13cmos5l_decap_8
XFILLER_37_2082 vccd vssd sg13cmos5l_decap_8
XFILLER_22_623 vccd vssd sg13cmos5l_decap_8
XFILLER_37_1370 vccd vssd sg13cmos5l_decap_4
XFILLER_21_133 vccd vssd sg13cmos5l_decap_8
XFILLER_17_2678 vccd vssd sg13cmos5l_decap_8
XFILLER_17_1944 vccd vssd sg13cmos5l_decap_8
Xtiedowns\[2\] status[2] vccd vssd sg13cmos5l_antennanp
XFILLER_37_1392 vccd vssd sg13cmos5l_decap_8
XFILLER_33_1212 vccd vssd sg13cmos5l_decap_8
XFILLER_11_2200 vccd vssd sg13cmos5l_decap_8
XFILLER_11_2277 vccd vssd sg13cmos5l_decap_8
XFILLER_11_1554 vccd vssd sg13cmos5l_decap_8
XFILLER_28_2763 vccd vssd sg13cmos5l_decap_8
XFILLER_27_1005 vccd vssd sg13cmos5l_decap_8
XFILLER_44_2075 vccd vssd sg13cmos5l_decap_8
XFILLER_27_1038 vccd vssd sg13cmos5l_decap_8
XFILLER_2_2401 vccd vssd sg13cmos5l_decap_8
XFILLER_44_1385 vccd vssd sg13cmos5l_decap_8
XFILLER_40_1216 vccd vssd sg13cmos5l_decap_8
XFILLER_29_266 vccd vssd sg13cmos5l_decap_8
XFILLER_17_406 vccd vssd sg13cmos5l_decap_8
XFILLER_2_2478 vccd vssd sg13cmos5l_decap_8
XFILLER_2_1722 vccd vssd sg13cmos5l_decap_8
XFILLER_22_1683 vccd vssd sg13cmos5l_decap_8
XFILLER_44_269 vccd vssd sg13cmos5l_decap_8
XFILLER_2_1799 vccd vssd sg13cmos5l_decap_8
XFILLER_0_2191 vccd vssd sg13cmos5l_decap_8
XFILLER_41_943 vccd vssd sg13cmos5l_decap_8
XFILLER_40_420 vccd vssd sg13cmos5l_decap_8
XFILLER_25_483 vccd vssd sg13cmos5l_decap_8
XFILLER_18_1708 vccd vssd sg13cmos5l_decap_8
XFILLER_16_63 vccd vssd sg13cmos5l_decap_8
XFILLER_13_623 vccd vssd sg13cmos5l_decap_8
XFILLER_35_2756 vccd vssd sg13cmos5l_decap_8
XFILLER_16_1421 vccd vssd sg13cmos5l_decap_8
XFILLER_9_616 vccd vssd sg13cmos5l_decap_8
XFILLER_12_133 vccd vssd sg13cmos5l_decap_8
XFILLER_16_2188 vccd vssd sg13cmos5l_decap_8
XFILLER_8_126 vccd vssd sg13cmos5l_decap_8
XFILLER_40_497 vccd vssd sg13cmos5l_decap_8
XFILLER_32_84 vccd vssd sg13cmos5l_decap_8
XFILLER_16_1498 vccd vssd sg13cmos5l_decap_8
XFILLER_5_833 vccd vssd sg13cmos5l_decap_8
Xtiedowns\[66\] status[66] vccd vssd sg13cmos5l_antennanp
XFILLER_29_2538 vccd vssd sg13cmos5l_decap_8
XFILLER_4_343 vccd vssd sg13cmos5l_decap_8
XFILLER_29_1815 vccd vssd sg13cmos5l_decap_8
XFILLER_10_1064 vccd vssd sg13cmos5l_decap_8
XFILLER_45_1127 vccd vssd sg13cmos5l_decap_8
XFILLER_27_2251 vccd vssd sg13cmos5l_decap_8
XFILLER_42_2727 vccd vssd sg13cmos5l_decap_8
XFILLER_7_2345 vccd vssd sg13cmos5l_decap_8
XFILLER_23_2148 vccd vssd sg13cmos5l_decap_8
XFILLER_0_560 vccd vssd sg13cmos5l_decap_8
XFILLER_3_1519 vccd vssd sg13cmos5l_decap_8
XFILLER_7_1666 vccd vssd sg13cmos5l_decap_8
XFILLER_40_2484 vccd vssd sg13cmos5l_decap_8
XFILLER_35_203 vccd vssd sg13cmos5l_decap_8
XFILLER_36_748 vccd vssd sg13cmos5l_decap_4
XFILLER_1_1232 vccd vssd sg13cmos5l_decap_8
XFILLER_17_973 vccd vssd sg13cmos5l_decap_8
XFILLER_44_770 vccd vssd sg13cmos5l_decap_8
XFILLER_36_1808 vccd vssd sg13cmos5l_decap_4
XFILLER_32_932 vccd vssd sg13cmos5l_decap_8
XFILLER_31_420 vccd vssd sg13cmos5l_decap_8
XFILLER_16_483 vccd vssd sg13cmos5l_decap_8
XFILLER_17_1218 vccd vssd sg13cmos5l_decap_8
XFILLER_34_1576 vccd vssd sg13cmos5l_decap_8
XFILLER_12_2542 vccd vssd sg13cmos5l_decap_8
X_1724_ _1724_/Q _1736_/CLK _1724_/D fanout126/X vccd vssd sg13cmos5l_dfrbpq_1
XFILLER_12_1841 vccd vssd sg13cmos5l_decap_8
XFILLER_8_693 vccd vssd sg13cmos5l_decap_8
XFILLER_28_2015 vccd vssd sg13cmos5l_decap_8
X_1655_ _1655_/Q _1655_/CLK _1655_/D _1609_/Y vccd vssd sg13cmos5l_dfrbpq_1
X_1586_ _1586_/X _1528_/A hold504/X _1587_/S vccd vssd sg13cmos5l_mux2_1
XFILLER_28_2059 vccd vssd sg13cmos5l_decap_8
XFILLER_45_2373 vccd vssd sg13cmos5l_decap_8
XFILLER_41_2237 vccd vssd sg13cmos5l_decap_8
XFILLER_41_1503 vccd vssd sg13cmos5l_decap_8
XFILLER_45_1694 vccd vssd sg13cmos5l_decap_8
XFILLER_26_1082 vccd vssd sg13cmos5l_decap_8
XFILLER_26_203 vccd vssd sg13cmos5l_decap_8
XFILLER_2_1029 vccd vssd sg13cmos5l_decap_8
XFILLER_3_2765 vccd vssd sg13cmos5l_decap_8
XFILLER_6_1176 vccd vssd sg13cmos5l_decap_8
XFILLER_39_2155 vccd vssd sg13cmos5l_decap_8
XFILLER_41_217 vccd vssd sg13cmos5l_decap_8
XFILLER_35_2019 vccd vssd sg13cmos5l_decap_8
XFILLER_23_910 vccd vssd sg13cmos5l_decap_8
XFILLER_17_2420 vccd vssd sg13cmos5l_decap_8
XFILLER_34_280 vccd vssd sg13cmos5l_decap_8
XFILLER_22_420 vccd vssd sg13cmos5l_decap_8
XFILLER_23_987 vccd vssd sg13cmos5l_decap_8
XFILLER_17_2497 vccd vssd sg13cmos5l_decap_4
XFILLER_13_2328 vccd vssd sg13cmos5l_decap_8
XFILLER_33_1031 vccd vssd sg13cmos5l_decap_8
XFILLER_30_2631 vccd vssd sg13cmos5l_decap_8
XFILLER_22_497 vccd vssd sg13cmos5l_decap_8
XFILLER_17_1785 vccd vssd sg13cmos5l_decap_8
XFILLER_10_637 vccd vssd sg13cmos5l_decap_8
XFILLER_11_2030 vccd vssd sg13cmos5l_decap_8
XFILLER_13_1638 vccd vssd sg13cmos5l_decap_8
XFILLER_11_1351 vccd vssd sg13cmos5l_decap_8
XFILLER_2_847 vccd vssd sg13cmos5l_decap_8
XFILLER_8_2621 vccd vssd sg13cmos5l_decap_8
XFILLER_1_357 vccd vssd sg13cmos5l_decap_8
XFILLER_24_2457 vccd vssd sg13cmos5l_decap_4
XFILLER_24_1701 vccd vssd sg13cmos5l_decap_8
XFILLER_8_1953 vccd vssd sg13cmos5l_decap_8
XFILLER_8_2676 vccd vssd sg13cmos5l_decap_8
XFILLER_44_1182 vccd vssd sg13cmos5l_decap_8
XFILLER_24_1756 vccd vssd sg13cmos5l_decap_8
XFILLER_4_1806 vccd vssd sg13cmos5l_decap_8
XFILLER_41_2782 vccd vssd sg13cmos5l_decap_8
XFILLER_40_1024 vccd vssd sg13cmos5l_decap_8
XFILLER_22_2181 vccd vssd sg13cmos5l_decap_8
XFILLER_17_203 vccd vssd sg13cmos5l_decap_8
XFILLER_2_2275 vccd vssd sg13cmos5l_decap_8
XFILLER_45_567 vccd vssd sg13cmos5l_decap_8
XFILLER_33_729 vccd vssd sg13cmos5l_decap_4
XFILLER_27_84 vccd vssd sg13cmos5l_decap_8
XFILLER_32_217 vccd vssd sg13cmos5l_decap_8
XFILLER_18_1505 vccd vssd sg13cmos5l_decap_8
XFILLER_2_1596 vccd vssd sg13cmos5l_decap_8
XFILLER_14_910 vccd vssd sg13cmos5l_decap_8
XFILLER_41_740 vccd vssd sg13cmos5l_decap_8
XFILLER_35_2553 vccd vssd sg13cmos5l_decap_8
XFILLER_25_280 vccd vssd sg13cmos5l_decap_8
XFILLER_13_420 vccd vssd sg13cmos5l_decap_8
XFILLER_31_2417 vccd vssd sg13cmos5l_decap_8
XFILLER_9_413 vccd vssd sg13cmos5l_decap_8
XFILLER_14_987 vccd vssd sg13cmos5l_decap_8
XFILLER_40_294 vccd vssd sg13cmos5l_decap_8
Xclkbuf_5_5_0_SCK clkload3/A clkbuf_5_7_0_SCK/A vccd vssd sg13cmos5l_buf_8
XFILLER_31_2439 vccd vssd sg13cmos5l_decap_8
XFILLER_13_497 vccd vssd sg13cmos5l_decap_8
XFILLER_31_1727 vccd vssd sg13cmos5l_decap_8
XFILLER_16_1295 vccd vssd sg13cmos5l_decap_8
XFILLER_5_630 vccd vssd sg13cmos5l_decap_8
XFILLER_12_1148 vccd vssd sg13cmos5l_decap_8
XFILLER_29_2324 vccd vssd sg13cmos5l_decap_8
XFILLER_4_140 vccd vssd sg13cmos5l_decap_8
X_1440_ _1440_/Y _1440_/A _1449_/B vccd vssd sg13cmos5l_nand2_1
XFILLER_9_2429 vccd vssd sg13cmos5l_decap_8
X_1371_ _1374_/B _1756_/Q _1371_/B vccd vssd sg13cmos5l_nand2_1
XFILLER_4_77 vccd vssd sg13cmos5l_decap_8
XFILLER_42_2535 vccd vssd sg13cmos5l_decap_4
XFILLER_7_2142 vccd vssd sg13cmos5l_decap_8
XFILLER_42_1823 vccd vssd sg13cmos5l_decap_8
XFILLER_23_1200 vccd vssd sg13cmos5l_decap_8
XFILLER_7_1463 vccd vssd sg13cmos5l_decap_8
XFILLER_3_1316 vccd vssd sg13cmos5l_decap_8
XFILLER_36_534 vccd vssd sg13cmos5l_decap_8
XFILLER_24_707 vccd vssd sg13cmos5l_decap_8
XFILLER_36_2328 vccd vssd sg13cmos5l_decap_8
XFILLER_23_217 vccd vssd sg13cmos5l_decap_8
XFILLER_17_770 vccd vssd sg13cmos5l_decap_8
XFILLER_36_1605 vccd vssd sg13cmos5l_decap_8
XFILLER_17_1015 vccd vssd sg13cmos5l_decap_8
XFILLER_16_280 vccd vssd sg13cmos5l_decap_8
XFILLER_20_924 vccd vssd sg13cmos5l_decap_8
XFILLER_31_294 vccd vssd sg13cmos5l_decap_8
XFILLER_14_1925 vccd vssd sg13cmos5l_decap_8
XFILLER_9_980 vccd vssd sg13cmos5l_decap_8
Xoutbuffers\[97\] control[97] _1765_/Q vccd vssd sg13cmos5l_buf_8
XFILLER_30_1259 vccd vssd sg13cmos5l_decap_8
XFILLER_8_490 vccd vssd sg13cmos5l_decap_8
X_1707_ _1707_/Q _1707_/CLK _1707_/D fanout130/X vccd vssd sg13cmos5l_dfrbpq_1
X_1638_ _1638_/Y _1641_/A _1638_/B_N vccd vssd sg13cmos5l_nor2b_1
XFILLER_28_1133 vccd vssd sg13cmos5l_decap_8
XFILLER_25_2700 vccd vssd sg13cmos5l_decap_8
XFILLER_45_2170 vccd vssd sg13cmos5l_decap_8
X_1569_ _1569_/Y _1569_/A _1577_/S vccd vssd sg13cmos5l_nand2_1
XFILLER_24_1008 vccd vssd sg13cmos5l_decap_8
XFILLER_45_1491 vccd vssd sg13cmos5l_decap_8
XFILLER_41_2034 vccd vssd sg13cmos5l_decap_8
XFILLER_41_1311 vccd vssd sg13cmos5l_decap_8
XFILLER_28_1188 vccd vssd sg13cmos5l_decap_8
XFILLER_25_2777 vccd vssd sg13cmos5l_decap_8
XFILLER_21_2608 vccd vssd sg13cmos5l_decap_8
XFILLER_39_350 vccd vssd sg13cmos5l_decap_4
XFILLER_21_1918 vccd vssd sg13cmos5l_decap_8
XFILLER_41_1377 vccd vssd sg13cmos5l_decap_8
XFILLER_39_394 vccd vssd sg13cmos5l_decap_8
XFILLER_3_2562 vccd vssd sg13cmos5l_decap_8
XFILLER_42_504 vccd vssd sg13cmos5l_decap_4
XFILLER_19_2504 vccd vssd sg13cmos5l_decap_8
XFILLER_15_707 vccd vssd sg13cmos5l_decap_8
XFILLER_3_1883 vccd vssd sg13cmos5l_decap_8
XFILLER_14_217 vccd vssd sg13cmos5l_decap_8
XFILLER_35_1104 vccd vssd sg13cmos5l_decap_8
Xfanout10 _1508_/S _1509_/S vccd vssd sg13cmos5l_buf_1
XFILLER_19_2559 vccd vssd sg13cmos5l_decap_8
Xfanout21 _1347_/B1 _1066_/X vccd vssd sg13cmos5l_buf_1
Xfanout54 _1144_/B _1007_/X vccd vssd sg13cmos5l_buf_1
Xfanout65 _1314_/B _0974_/Y vccd vssd sg13cmos5l_buf_1
Xfanout32 _1114_/B _1045_/Y vccd vssd sg13cmos5l_buf_1
Xfanout43 _1531_/B _1031_/X vccd vssd sg13cmos5l_buf_1
XFILLER_23_784 vccd vssd sg13cmos5l_decap_8
XFILLER_11_924 vccd vssd sg13cmos5l_decap_8
Xfanout76 _1135_/B _0982_/Y vccd vssd sg13cmos5l_buf_8
Xfanout98 _1553_/A _1653_/Q vccd vssd sg13cmos5l_buf_1
Xfanout87 _1520_/A hold529/X vccd vssd sg13cmos5l_buf_1
XFILLER_22_294 vccd vssd sg13cmos5l_decap_8
XFILLER_7_917 vccd vssd sg13cmos5l_decap_8
XFILLER_10_434 vccd vssd sg13cmos5l_decap_8
XFILLER_13_42 vccd vssd sg13cmos5l_decap_8
XFILLER_13_2114 vccd vssd sg13cmos5l_decap_8
XFILLER_17_1582 vccd vssd sg13cmos5l_decap_8
XFILLER_6_427 vccd vssd sg13cmos5l_decap_8
XFILLER_13_1435 vccd vssd sg13cmos5l_decap_8
XFILLER_30_2483 vccd vssd sg13cmos5l_decap_8
Xhold490 hold490/X _1770_/Q vccd vssd sg13cmos5l_dlygate4sd3_1
XFILLER_2_644 vccd vssd sg13cmos5l_decap_8
XFILLER_1_154 vccd vssd sg13cmos5l_decap_8
XFILLER_4_1603 vccd vssd sg13cmos5l_decap_8
XFILLER_8_1750 vccd vssd sg13cmos5l_decap_8
Xtiedowns\[29\] status[29] vccd vssd sg13cmos5l_antennanp
XFILLER_4_2359 vccd vssd sg13cmos5l_decap_8
XFILLER_20_1428 vccd vssd sg13cmos5l_decap_8
XFILLER_37_2604 vccd vssd sg13cmos5l_decap_8
XFILLER_18_567 vccd vssd sg13cmos5l_decap_8
XFILLER_2_2072 vccd vssd sg13cmos5l_decap_8
XFILLER_45_364 vccd vssd sg13cmos5l_decap_8
XFILLER_2_1393 vccd vssd sg13cmos5l_decap_8
XFILLER_37_1925 vccd vssd sg13cmos5l_decap_8
XFILLER_18_1302 vccd vssd sg13cmos5l_decap_8
X_0940_ _0940_/Y _0940_/A _0940_/B vccd vssd sg13cmos5l_nor2_1
XFILLER_14_784 vccd vssd sg13cmos5l_decap_8
XFILLER_18_1379 vccd vssd sg13cmos5l_decap_8
XFILLER_9_210 vccd vssd sg13cmos5l_decap_8
XFILLER_13_294 vccd vssd sg13cmos5l_decap_8
X_0871_ _0871_/Y status[46] vccd vssd sg13cmos5l_inv_1
XFILLER_31_1557 vccd vssd sg13cmos5l_decap_8
Xclkload13 clkload13/Y _1807_/CLK vccd vssd sg13cmos5l_inv_1
XFILLER_16_1092 vccd vssd sg13cmos5l_decap_8
XFILLER_9_287 vccd vssd sg13cmos5l_decap_8
XFILLER_13_2681 vccd vssd sg13cmos5l_decap_8
XFILLER_6_994 vccd vssd sg13cmos5l_decap_8
XFILLER_9_2226 vccd vssd sg13cmos5l_decap_8
X_1423_ _1423_/X _1478_/A hold312/X _1428_/S vccd vssd sg13cmos5l_mux2_1
XFILLER_42_2332 vccd vssd sg13cmos5l_decap_8
XFILLER_29_2198 vccd vssd sg13cmos5l_decap_8
XFILLER_9_1547 vccd vssd sg13cmos5l_decap_8
X_1354_ _1657_/D hold190/X _1391_/A2 _1353_/Y _1352_/Y vccd vssd sg13cmos5l_a22oi_1
XFILLER_42_2398 vccd vssd sg13cmos5l_decap_8
XFILLER_42_2376 vccd vssd sg13cmos5l_decap_8
XFILLER_37_810 vccd vssd sg13cmos5l_decap_8
X_1285_ _1288_/A _1282_/Y _1283_/X _1284_/Y vccd vssd sg13cmos5l_o21ai_1
XFILLER_7_1260 vccd vssd sg13cmos5l_decap_8
XFILLER_23_1063 vccd vssd sg13cmos5l_decap_8
XFILLER_3_1113 vccd vssd sg13cmos5l_decap_8
XFILLER_0_2702 vccd vssd sg13cmos5l_decap_8
XFILLER_20_2674 vccd vssd sg13cmos5l_decap_8
XFILLER_37_887 vccd vssd sg13cmos5l_decap_8
XFILLER_36_364 vccd vssd sg13cmos5l_decap_8
XFILLER_24_504 vccd vssd sg13cmos5l_decap_8
XFILLER_20_1973 vccd vssd sg13cmos5l_decap_8
XFILLER_0_2779 vccd vssd sg13cmos5l_decap_8
Xoutbuffers\[12\] control[12] _1680_/Q vccd vssd sg13cmos5l_buf_8
XFILLER_36_2158 vccd vssd sg13cmos5l_decap_8
XFILLER_32_581 vccd vssd sg13cmos5l_decap_8
XFILLER_20_721 vccd vssd sg13cmos5l_decap_8
Xclkload7 clkload7/Y clkload7/A vccd vssd sg13cmos5l_inv_1
XFILLER_14_1722 vccd vssd sg13cmos5l_decap_8
XFILLER_20_798 vccd vssd sg13cmos5l_decap_8
XFILLER_12_2180 vccd vssd sg13cmos5l_decap_8
XFILLER_14_1799 vccd vssd sg13cmos5l_decap_8
XFILLER_30_1089 vccd vssd sg13cmos5l_decap_8
XFILLER_5_2602 vccd vssd sg13cmos5l_decap_8
XFILLER_43_1439 vccd vssd sg13cmos5l_decap_8
XFILLER_25_2552 vccd vssd sg13cmos5l_decap_8
XFILLER_21_2405 vccd vssd sg13cmos5l_decap_8
XFILLER_8_1057 vccd vssd sg13cmos5l_decap_8
XFILLER_21_1704 vccd vssd sg13cmos5l_decap_8
XFILLER_5_2668 vccd vssd sg13cmos5l_decap_8
XFILLER_28_843 vccd vssd sg13cmos5l_decap_8
XFILLER_25_1884 vccd vssd sg13cmos5l_decap_8
XFILLER_5_1967 vccd vssd sg13cmos5l_decap_8
XFILLER_41_1185 vccd vssd sg13cmos5l_decap_8
XFILLER_27_364 vccd vssd sg13cmos5l_decap_8
XFILLER_3_1680 vccd vssd sg13cmos5l_decap_8
XFILLER_15_504 vccd vssd sg13cmos5l_decap_8
XFILLER_42_334 vccd vssd sg13cmos5l_decap_8
XFILLER_19_2345 vccd vssd sg13cmos5l_decap_8
XFILLER_39_1070 vccd vssd sg13cmos5l_decap_8
XFILLER_30_529 vccd vssd sg13cmos5l_decap_8
XFILLER_24_63 vccd vssd sg13cmos5l_decap_8
XFILLER_23_581 vccd vssd sg13cmos5l_decap_8
XFILLER_19_1666 vccd vssd sg13cmos5l_decap_8
XFILLER_15_1519 vccd vssd sg13cmos5l_decap_8
XFILLER_11_721 vccd vssd sg13cmos5l_decap_8
XFILLER_36_1980 vccd vssd sg13cmos5l_decap_8
XFILLER_32_2567 vccd vssd sg13cmos5l_decap_8
XFILLER_32_1811 vccd vssd sg13cmos5l_decap_8
XFILLER_7_714 vccd vssd sg13cmos5l_decap_8
XFILLER_10_231 vccd vssd sg13cmos5l_decap_8
XFILLER_6_224 vccd vssd sg13cmos5l_decap_8
XFILLER_11_798 vccd vssd sg13cmos5l_decap_8
XFILLER_13_1232 vccd vssd sg13cmos5l_decap_8
XFILLER_32_1899 vccd vssd sg13cmos5l_decap_8
XFILLER_40_84 vccd vssd sg13cmos5l_decap_8
XFILLER_3_931 vccd vssd sg13cmos5l_decap_8
XFILLER_2_441 vccd vssd sg13cmos5l_decap_8
XFILLER_4_1400 vccd vssd sg13cmos5l_decap_8
XFILLER_4_2156 vccd vssd sg13cmos5l_decap_8
XFILLER_0_2009 vccd vssd sg13cmos5l_decap_8
XFILLER_1_56 vccd vssd sg13cmos5l_decap_8
X_1070_ _1070_/Y _1070_/A _1070_/B _1070_/C vccd vssd sg13cmos5l_nor3_1
XFILLER_20_1225 vccd vssd sg13cmos5l_decap_8
XFILLER_19_854 vccd vssd sg13cmos5l_decap_8
XFILLER_4_1477 vccd vssd sg13cmos5l_decap_8
XFILLER_45_161 vccd vssd sg13cmos5l_decap_8
XFILLER_33_301 vccd vssd sg13cmos5l_decap_8
XFILLER_18_364 vccd vssd sg13cmos5l_decap_8
XFILLER_2_1190 vccd vssd sg13cmos5l_decap_8
XFILLER_33_2309 vccd vssd sg13cmos5l_decap_8
XFILLER_33_378 vccd vssd sg13cmos5l_decap_8
XFILLER_21_518 vccd vssd sg13cmos5l_decap_8
Xoutbuffers\[102\] control[102] _1770_/Q vccd vssd sg13cmos5l_buf_8
XFILLER_37_1766 vccd vssd sg13cmos5l_decap_8
XFILLER_31_2000 vccd vssd sg13cmos5l_decap_8
XFILLER_14_581 vccd vssd sg13cmos5l_decap_8
XFILLER_31_2044 vccd vssd sg13cmos5l_decap_8
X_0923_ _0923_/Y _0936_/B _0922_/Y hold199/X vccd vssd sg13cmos5l_a21oi_1
XFILLER_18_1176 vccd vssd sg13cmos5l_decap_8
XFILLER_14_1029 vccd vssd sg13cmos5l_decap_8
X_0854_ _0854_/Y _0854_/A vccd vssd sg13cmos5l_inv_1
XFILLER_11_2629 vccd vssd sg13cmos5l_decap_8
XFILLER_31_1365 vccd vssd sg13cmos5l_decap_8
XFILLER_11_1939 vccd vssd sg13cmos5l_decap_8
XFILLER_6_791 vccd vssd sg13cmos5l_decap_8
XFILLER_9_2023 vccd vssd sg13cmos5l_decap_8
XFILLER_29_1283 vccd vssd sg13cmos5l_decap_8
X_1406_ _1407_/B _1406_/A _1406_/B vccd vssd sg13cmos5l_nor2_1
XFILLER_9_1344 vccd vssd sg13cmos5l_decap_8
XFILLER_42_2173 vccd vssd sg13cmos5l_decap_8
X_1337_ _1337_/Y _1717_/Q _1337_/B vccd vssd sg13cmos5l_nand2b_1
XFILLER_29_618 vccd vssd sg13cmos5l_decap_8
XFILLER_29_607 vccd vssd sg13cmos5l_decap_8
XFILLER_25_1147 vccd vssd sg13cmos5l_decap_8
XFILLER_22_2725 vccd vssd sg13cmos5l_decap_8
XFILLER_42_1472 vccd vssd sg13cmos5l_decap_4
X_1268_ _1268_/X status[58] _1360_/B1 _1268_/B1 vccd vssd sg13cmos5l_a21o_1
XFILLER_20_2471 vccd vssd sg13cmos5l_decap_8
XFILLER_37_684 vccd vssd sg13cmos5l_decap_8
XFILLER_36_161 vccd vssd sg13cmos5l_decap_8
X_1199_ _1199_/Y _1736_/Q _1510_/B _1372_/B1 vccd vssd sg13cmos5l_a21oi_1
XFILLER_24_301 vccd vssd sg13cmos5l_decap_8
XFILLER_0_2576 vccd vssd sg13cmos5l_decap_8
XFILLER_0_1820 vccd vssd sg13cmos5l_decap_8
XFILLER_25_857 vccd vssd sg13cmos5l_decap_8
XFILLER_36_1221 vccd vssd sg13cmos5l_decap_8
XFILLER_24_378 vccd vssd sg13cmos5l_decap_8
XFILLER_0_1897 vccd vssd sg13cmos5l_decap_8
XFILLER_12_518 vccd vssd sg13cmos5l_decap_8
XFILLER_16_1806 vccd vssd sg13cmos5l_decap_8
XFILLER_36_1287 vccd vssd sg13cmos5l_decap_8
XFILLER_10_2128 vccd vssd sg13cmos5l_decap_8
XFILLER_20_595 vccd vssd sg13cmos5l_decap_8
XFILLER_4_728 vccd vssd sg13cmos5l_decap_8
XFILLER_10_21 vccd vssd sg13cmos5l_decap_8
XFILLER_10_1449 vccd vssd sg13cmos5l_decap_8
XFILLER_14_1596 vccd vssd sg13cmos5l_decap_8
XFILLER_3_238 vccd vssd sg13cmos5l_decap_8
XFILLER_27_2658 vccd vssd sg13cmos5l_decap_8
XFILLER_27_1946 vccd vssd sg13cmos5l_decap_8
XFILLER_0_945 vccd vssd sg13cmos5l_decap_8
XFILLER_10_98 vccd vssd sg13cmos5l_decap_8
XFILLER_5_2443 vccd vssd sg13cmos5l_decap_8
XFILLER_21_2257 vccd vssd sg13cmos5l_decap_8
XFILLER_21_1501 vccd vssd sg13cmos5l_decap_8
XFILLER_19_63 vccd vssd sg13cmos5l_decap_8
XFILLER_28_651 vccd vssd sg13cmos5l_decap_8
XFILLER_1_1617 vccd vssd sg13cmos5l_decap_8
XFILLER_5_1764 vccd vssd sg13cmos5l_decap_8
XFILLER_38_2721 vccd vssd sg13cmos5l_decap_8
XFILLER_27_161 vccd vssd sg13cmos5l_decap_8
XFILLER_21_1578 vccd vssd sg13cmos5l_decap_8
XFILLER_15_301 vccd vssd sg13cmos5l_decap_8
XFILLER_43_643 vccd vssd sg13cmos5l_decap_4
XFILLER_16_868 vccd vssd sg13cmos5l_decap_8
XFILLER_37_1018 vccd vssd sg13cmos5l_decap_8
XFILLER_35_84 vccd vssd sg13cmos5l_decap_8
XFILLER_31_816 vccd vssd sg13cmos5l_decap_8
XFILLER_15_378 vccd vssd sg13cmos5l_decap_8
XFILLER_30_315 vccd vssd sg13cmos5l_decap_8
XFILLER_19_1463 vccd vssd sg13cmos5l_decap_8
Xtiedowns\[96\] status[96] vccd vssd sg13cmos5l_antennanp
XFILLER_15_1316 vccd vssd sg13cmos5l_decap_8
XFILLER_7_511 vccd vssd sg13cmos5l_decap_8
XFILLER_32_1674 vccd vssd sg13cmos5l_decap_8
XFILLER_11_595 vccd vssd sg13cmos5l_decap_8
XFILLER_7_588 vccd vssd sg13cmos5l_decap_8
XFILLER_10_2684 vccd vssd sg13cmos5l_decap_8
XFILLER_45_2758 vccd vssd sg13cmos5l_decap_8
XFILLER_26_1412 vccd vssd sg13cmos5l_decap_8
XFILLER_39_916 vccd vssd sg13cmos5l_decap_8
XFILLER_26_2179 vccd vssd sg13cmos5l_decap_8
XFILLER_39_2507 vccd vssd sg13cmos5l_decap_8
X_1122_ _1122_/X _1119_/X _1120_/Y _1121_/Y vccd vssd sg13cmos5l_a21o_1
XFILLER_20_1022 vccd vssd sg13cmos5l_decap_8
XFILLER_19_651 vccd vssd sg13cmos5l_decap_8
X_1053_ _1053_/Y _0874_/Y _1342_/B _1429_/B vccd vssd sg13cmos5l_a21oi_1
XFILLER_18_161 vccd vssd sg13cmos5l_decap_8
XFILLER_0_1127 vccd vssd sg13cmos5l_decap_8
XFILLER_4_1274 vccd vssd sg13cmos5l_decap_8
XFILLER_39_1839 vccd vssd sg13cmos5l_decap_8
XFILLER_22_805 vccd vssd sg13cmos5l_decap_8
XFILLER_20_1099 vccd vssd sg13cmos5l_decap_8
XFILLER_37_2297 vccd vssd sg13cmos5l_decap_8
XFILLER_33_175 vccd vssd sg13cmos5l_decap_8
XFILLER_21_315 vccd vssd sg13cmos5l_decap_8
XFILLER_37_1596 vccd vssd sg13cmos5l_decap_8
XFILLER_33_1438 vccd vssd sg13cmos5l_decap_8
X_0906_ _0906_/Y _0938_/A _1797_/Q vccd vssd sg13cmos5l_nand2_1
XFILLER_15_1883 vccd vssd sg13cmos5l_decap_8
XFILLER_31_1173 vccd vssd sg13cmos5l_decap_8
X_0837_ _0837_/Y _0837_/A vccd vssd sg13cmos5l_inv_1
XFILLER_11_1736 vccd vssd sg13cmos5l_decap_8
XFILLER_44_2257 vccd vssd sg13cmos5l_decap_8
XFILLER_26_2691 vccd vssd sg13cmos5l_decap_8
XFILLER_22_2522 vccd vssd sg13cmos5l_decap_8
XFILLER_9_1141 vccd vssd sg13cmos5l_decap_8
XFILLER_44_1567 vccd vssd sg13cmos5l_decap_8
XFILLER_40_1409 vccd vssd sg13cmos5l_decap_8
XFILLER_38_960 vccd vssd sg13cmos5l_decap_8
XFILLER_29_448 vccd vssd sg13cmos5l_decap_8
XFILLER_22_2599 vccd vssd sg13cmos5l_decap_8
XFILLER_2_1904 vccd vssd sg13cmos5l_decap_8
XFILLER_42_1291 vccd vssd sg13cmos5l_decap_8
XFILLER_38_2028 vccd vssd sg13cmos5l_decap_8
XFILLER_0_2373 vccd vssd sg13cmos5l_decap_8
XFILLER_38_1327 vccd vssd sg13cmos5l_decap_8
XFILLER_25_654 vccd vssd sg13cmos5l_decap_8
XFILLER_13_805 vccd vssd sg13cmos5l_decap_8
XFILLER_24_175 vccd vssd sg13cmos5l_decap_8
XFILLER_16_1603 vccd vssd sg13cmos5l_decap_8
XFILLER_0_1694 vccd vssd sg13cmos5l_decap_8
XFILLER_12_315 vccd vssd sg13cmos5l_decap_8
XFILLER_8_308 vccd vssd sg13cmos5l_decap_8
XFILLER_36_1095 vccd vssd sg13cmos5l_decap_8
XFILLER_21_882 vccd vssd sg13cmos5l_decap_8
XFILLER_14_2072 vccd vssd sg13cmos5l_decap_8
XFILLER_20_392 vccd vssd sg13cmos5l_decap_8
XFILLER_21_42 vccd vssd sg13cmos5l_decap_8
XFILLER_4_525 vccd vssd sg13cmos5l_decap_8
XFILLER_14_1393 vccd vssd sg13cmos5l_decap_8
XFILLER_10_1246 vccd vssd sg13cmos5l_decap_8
XFILLER_45_1309 vccd vssd sg13cmos5l_decap_8
XFILLER_27_2422 vccd vssd sg13cmos5l_decap_8
XFILLER_7_2527 vccd vssd sg13cmos5l_decap_8
XFILLER_0_742 vccd vssd sg13cmos5l_decap_8
XFILLER_23_1618 vccd vssd sg13cmos5l_decap_8
XFILLER_5_2240 vccd vssd sg13cmos5l_decap_8
XFILLER_7_1848 vccd vssd sg13cmos5l_decap_8
XFILLER_40_2666 vccd vssd sg13cmos5l_decap_8
XFILLER_36_919 vccd vssd sg13cmos5l_decap_8
XFILLER_5_1561 vccd vssd sg13cmos5l_decap_8
Xtiedowns\[11\] status[11] vccd vssd sg13cmos5l_antennanp
XFILLER_40_1976 vccd vssd sg13cmos5l_decap_8
XFILLER_29_993 vccd vssd sg13cmos5l_decap_8
XFILLER_1_1414 vccd vssd sg13cmos5l_decap_8
XFILLER_21_1386 vccd vssd sg13cmos5l_decap_8
XFILLER_16_665 vccd vssd sg13cmos5l_decap_8
XFILLER_43_484 vccd vssd sg13cmos5l_decap_8
XFILLER_38_2595 vccd vssd sg13cmos5l_decap_8
XFILLER_31_613 vccd vssd sg13cmos5l_decap_4
XFILLER_30_112 vccd vssd sg13cmos5l_decap_8
XFILLER_15_175 vccd vssd sg13cmos5l_decap_8
XFILLER_38_1894 vccd vssd sg13cmos5l_decap_8
XFILLER_34_1725 vccd vssd sg13cmos5l_decap_8
XFILLER_19_1260 vccd vssd sg13cmos5l_decap_8
XFILLER_15_1113 vccd vssd sg13cmos5l_decap_8
XFILLER_12_882 vccd vssd sg13cmos5l_decap_8
XFILLER_32_2194 vccd vssd sg13cmos5l_decap_8
XFILLER_30_189 vccd vssd sg13cmos5l_decap_8
X_1740_ _1740_/Q clkload2/A _1740_/D fanout122/X vccd vssd sg13cmos5l_dfrbpq_1
XFILLER_11_392 vccd vssd sg13cmos5l_decap_8
XFILLER_12_2768 vccd vssd sg13cmos5l_decap_8
Xhold308 hold308/X _1678_/Q vccd vssd sg13cmos5l_dlygate4sd3_1
X_1671_ _1671_/Q clkload9/A _1671_/D _1617_/B_N vccd vssd sg13cmos5l_dfrbpq_1
XFILLER_7_77 vccd vssd sg13cmos5l_decap_8
XFILLER_8_875 vccd vssd sg13cmos5l_decap_8
Xhold319 _1679_/D _1434_/X vccd vssd sg13cmos5l_dlygate4sd3_1
XFILLER_7_385 vccd vssd sg13cmos5l_decap_8
XFILLER_45_2555 vccd vssd sg13cmos5l_decap_8
XFILLER_28_1529 vccd vssd sg13cmos5l_decap_8
XFILLER_41_2408 vccd vssd sg13cmos5l_decap_8
XFILLER_6_2037 vccd vssd sg13cmos5l_decap_8
XFILLER_45_1876 vccd vssd sg13cmos5l_decap_8
XFILLER_22_1106 vccd vssd sg13cmos5l_decap_8
XFILLER_38_245 vccd vssd sg13cmos5l_decap_8
XFILLER_6_1358 vccd vssd sg13cmos5l_decap_8
X_1105_ _1105_/Y _1778_/Q _1151_/B vccd vssd sg13cmos5l_nand2b_1
XFILLER_1_2660 vccd vssd sg13cmos5l_decap_8
XFILLER_4_1071 vccd vssd sg13cmos5l_decap_8
X_1036_ _1036_/Y _1036_/A _1036_/B vccd vssd sg13cmos5l_nand2_1
XFILLER_34_440 vccd vssd sg13cmos5l_decap_8
XFILLER_22_602 vccd vssd sg13cmos5l_decap_8
XFILLER_17_2602 vccd vssd sg13cmos5l_decap_8
XFILLER_1_1981 vccd vssd sg13cmos5l_decap_8
XFILLER_39_1658 vccd vssd sg13cmos5l_decap_8
XFILLER_37_2061 vccd vssd sg13cmos5l_decap_8
XFILLER_21_112 vccd vssd sg13cmos5l_decap_8
XFILLER_17_2657 vccd vssd sg13cmos5l_decap_8
XFILLER_22_679 vccd vssd sg13cmos5l_decap_8
XFILLER_10_819 vccd vssd sg13cmos5l_decap_8
XFILLER_21_189 vccd vssd sg13cmos5l_decap_8
XFILLER_15_2381 vccd vssd sg13cmos5l_decap_8
XFILLER_15_1680 vccd vssd sg13cmos5l_decap_8
XFILLER_11_1533 vccd vssd sg13cmos5l_decap_8
XFILLER_11_2256 vccd vssd sg13cmos5l_decap_8
XFILLER_28_2742 vccd vssd sg13cmos5l_decap_8
XFILLER_1_539 vccd vssd sg13cmos5l_decap_8
XFILLER_44_2054 vccd vssd sg13cmos5l_decap_8
XFILLER_44_1364 vccd vssd sg13cmos5l_decap_8
XFILLER_29_245 vccd vssd sg13cmos5l_decap_8
XFILLER_22_2396 vccd vssd sg13cmos5l_decap_8
XFILLER_22_1662 vccd vssd sg13cmos5l_decap_8
XFILLER_2_2457 vccd vssd sg13cmos5l_decap_8
XFILLER_2_1701 vccd vssd sg13cmos5l_decap_8
XFILLER_45_749 vccd vssd sg13cmos5l_decap_8
XFILLER_44_248 vccd vssd sg13cmos5l_decap_8
XFILLER_26_985 vccd vssd sg13cmos5l_decap_8
XFILLER_26_952 vccd vssd sg13cmos5l_decap_4
XFILLER_16_42 vccd vssd sg13cmos5l_decap_8
XFILLER_2_1778 vccd vssd sg13cmos5l_decap_8
XFILLER_0_2170 vccd vssd sg13cmos5l_decap_8
XFILLER_41_922 vccd vssd sg13cmos5l_decap_8
XFILLER_35_2735 vccd vssd sg13cmos5l_decap_8
XFILLER_25_462 vccd vssd sg13cmos5l_decap_8
XFILLER_0_1491 vccd vssd sg13cmos5l_decap_8
XFILLER_13_602 vccd vssd sg13cmos5l_decap_8
XFILLER_16_1400 vccd vssd sg13cmos5l_decap_8
XFILLER_12_112 vccd vssd sg13cmos5l_decap_8
XFILLER_41_999 vccd vssd sg13cmos5l_decap_8
XFILLER_40_476 vccd vssd sg13cmos5l_decap_8
XFILLER_8_105 vccd vssd sg13cmos5l_decap_8
XFILLER_12_2009 vccd vssd sg13cmos5l_decap_8
XFILLER_13_679 vccd vssd sg13cmos5l_decap_8
XFILLER_32_63 vccd vssd sg13cmos5l_decap_8
XFILLER_16_1477 vccd vssd sg13cmos5l_decap_8
XFILLER_12_189 vccd vssd sg13cmos5l_decap_8
XFILLER_5_812 vccd vssd sg13cmos5l_decap_8
XFILLER_29_2528 vccd vssd sg13cmos5l_decap_4
XFILLER_4_322 vccd vssd sg13cmos5l_decap_8
XFILLER_10_1043 vccd vssd sg13cmos5l_decap_8
XFILLER_14_1190 vccd vssd sg13cmos5l_decap_8
XFILLER_5_889 vccd vssd sg13cmos5l_decap_8
XFILLER_45_1106 vccd vssd sg13cmos5l_decap_8
Xtiedowns\[59\] status[59] vccd vssd sg13cmos5l_antennanp
XFILLER_42_2706 vccd vssd sg13cmos5l_decap_8
XFILLER_27_2230 vccd vssd sg13cmos5l_decap_8
XFILLER_4_399 vccd vssd sg13cmos5l_decap_8
XFILLER_7_2324 vccd vssd sg13cmos5l_decap_8
XFILLER_27_1584 vccd vssd sg13cmos5l_decap_8
XFILLER_23_2127 vccd vssd sg13cmos5l_decap_8
XFILLER_7_1645 vccd vssd sg13cmos5l_decap_8
XFILLER_40_2463 vccd vssd sg13cmos5l_decap_8
XFILLER_36_716 vccd vssd sg13cmos5l_decap_8
XFILLER_1_1211 vccd vssd sg13cmos5l_decap_8
XFILLER_35_259 vccd vssd sg13cmos5l_decap_8
XFILLER_21_1183 vccd vssd sg13cmos5l_decap_8
XFILLER_17_952 vccd vssd sg13cmos5l_decap_8
XFILLER_16_462 vccd vssd sg13cmos5l_decap_8
XFILLER_1_1288 vccd vssd sg13cmos5l_decap_8
XFILLER_34_2256 vccd vssd sg13cmos5l_decap_8
XFILLER_32_988 vccd vssd sg13cmos5l_decap_8
XFILLER_31_487 vccd vssd sg13cmos5l_decap_8
XFILLER_12_2521 vccd vssd sg13cmos5l_decap_8
X_1723_ _1723_/Q clkload5/A _1723_/D fanout128/X vccd vssd sg13cmos5l_dfrbpq_1
XFILLER_30_1419 vccd vssd sg13cmos5l_decap_8
XFILLER_8_672 vccd vssd sg13cmos5l_decap_8
XFILLER_12_1820 vccd vssd sg13cmos5l_decap_8
XFILLER_7_182 vccd vssd sg13cmos5l_decap_8
X_1654_ _1654_/Q _1682_/CLK _1654_/D _1619_/Y vccd vssd sg13cmos5l_dfrbpq_1
XFILLER_12_1897 vccd vssd sg13cmos5l_decap_8
X_1585_ _1585_/X _1595_/A0 hold484/X _1585_/S vccd vssd sg13cmos5l_mux2_1
XFILLER_45_2352 vccd vssd sg13cmos5l_decap_8
XFILLER_41_2216 vccd vssd sg13cmos5l_decap_8
XFILLER_28_1337 vccd vssd sg13cmos5l_decap_8
XFILLER_45_1673 vccd vssd sg13cmos5l_decap_8
Xoutbuffers\[42\] control[42] _1710_/Q vccd vssd sg13cmos5l_buf_8
XFILLER_39_543 vccd vssd sg13cmos5l_decap_8
XFILLER_26_1061 vccd vssd sg13cmos5l_decap_8
XFILLER_3_2744 vccd vssd sg13cmos5l_decap_8
XFILLER_6_1155 vccd vssd sg13cmos5l_decap_8
XFILLER_23_2683 vccd vssd sg13cmos5l_decap_8
XFILLER_2_1008 vccd vssd sg13cmos5l_decap_8
XFILLER_39_2134 vccd vssd sg13cmos5l_decap_8
XFILLER_42_719 vccd vssd sg13cmos5l_decap_8
XFILLER_26_259 vccd vssd sg13cmos5l_decap_8
X_1019_ _1019_/Y status[15] _1147_/B _1013_/Y _1016_/Y _1366_/B1 vccd vssd sg13cmos5l_a221oi_1
XFILLER_39_1444 vccd vssd sg13cmos5l_decap_8
XFILLER_35_1319 vccd vssd sg13cmos5l_decap_8
XFILLER_23_966 vccd vssd sg13cmos5l_decap_8
XFILLER_22_476 vccd vssd sg13cmos5l_decap_8
XFILLER_17_2476 vccd vssd sg13cmos5l_decap_8
XFILLER_10_616 vccd vssd sg13cmos5l_decap_8
XFILLER_13_2307 vccd vssd sg13cmos5l_decap_8
XFILLER_30_2610 vccd vssd sg13cmos5l_decap_8
XFILLER_17_1764 vccd vssd sg13cmos5l_decap_8
XFILLER_6_609 vccd vssd sg13cmos5l_decap_8
XFILLER_13_1617 vccd vssd sg13cmos5l_decap_8
XFILLER_5_119 vccd vssd sg13cmos5l_decap_8
XFILLER_30_2687 vccd vssd sg13cmos5l_decap_8
XFILLER_11_1330 vccd vssd sg13cmos5l_decap_8
XFILLER_11_2086 vccd vssd sg13cmos5l_decap_8
XFILLER_2_826 vccd vssd sg13cmos5l_decap_8
XFILLER_1_336 vccd vssd sg13cmos5l_decap_8
XFILLER_28_1882 vccd vssd sg13cmos5l_decap_8
XFILLER_8_1932 vccd vssd sg13cmos5l_decap_8
XFILLER_44_1161 vccd vssd sg13cmos5l_decap_8
XFILLER_41_2761 vccd vssd sg13cmos5l_decap_8
XFILLER_40_1003 vccd vssd sg13cmos5l_decap_8
XFILLER_45_546 vccd vssd sg13cmos5l_decap_8
XFILLER_27_63 vccd vssd sg13cmos5l_decap_8
XFILLER_18_749 vccd vssd sg13cmos5l_decap_8
XFILLER_2_2254 vccd vssd sg13cmos5l_decap_8
XFILLER_22_1492 vccd vssd sg13cmos5l_decap_8
XFILLER_17_259 vccd vssd sg13cmos5l_decap_8
XFILLER_2_1575 vccd vssd sg13cmos5l_decap_8
XFILLER_43_40 vccd vssd sg13cmos5l_decap_8
XFILLER_35_2532 vccd vssd sg13cmos5l_decap_8
XFILLER_14_966 vccd vssd sg13cmos5l_decap_8
XFILLER_43_62 vccd vssd sg13cmos5l_decap_4
XFILLER_13_476 vccd vssd sg13cmos5l_decap_8
XFILLER_41_796 vccd vssd sg13cmos5l_decap_8
XFILLER_40_273 vccd vssd sg13cmos5l_decap_8
XFILLER_31_1706 vccd vssd sg13cmos5l_decap_8
XFILLER_16_1274 vccd vssd sg13cmos5l_decap_8
XFILLER_9_469 vccd vssd sg13cmos5l_decap_8
XFILLER_12_1127 vccd vssd sg13cmos5l_decap_8
XFILLER_29_2303 vccd vssd sg13cmos5l_decap_8
XFILLER_9_2408 vccd vssd sg13cmos5l_decap_8
XFILLER_29_2369 vccd vssd sg13cmos5l_decap_4
XFILLER_5_686 vccd vssd sg13cmos5l_decap_8
XFILLER_42_2514 vccd vssd sg13cmos5l_decap_8
X_1370_ _1374_/A _1764_/Q _0961_/Y _1369_/Y vccd vssd sg13cmos5l_o21ai_1
XFILLER_4_56 vccd vssd sg13cmos5l_decap_8
XFILLER_4_196 vccd vssd sg13cmos5l_decap_8
XFILLER_7_2121 vccd vssd sg13cmos5l_decap_8
XFILLER_9_1729 vccd vssd sg13cmos5l_decap_8
XFILLER_42_1802 vccd vssd sg13cmos5l_decap_8
XFILLER_7_1442 vccd vssd sg13cmos5l_decap_8
XFILLER_7_2198 vccd vssd sg13cmos5l_decap_8
XFILLER_42_1857 vccd vssd sg13cmos5l_decap_8
XFILLER_40_2282 vccd vssd sg13cmos5l_decap_8
XFILLER_36_513 vccd vssd sg13cmos5l_decap_8
XFILLER_40_1592 vccd vssd sg13cmos5l_decap_8
XFILLER_36_2307 vccd vssd sg13cmos5l_decap_8
XFILLER_1_1085 vccd vssd sg13cmos5l_decap_8
XFILLER_32_763 vccd vssd sg13cmos5l_decap_8
XFILLER_20_903 vccd vssd sg13cmos5l_decap_8
XFILLER_18_2785 vccd vssd sg13cmos5l_decap_4
XFILLER_34_2097 vccd vssd sg13cmos5l_decap_8
XFILLER_31_273 vccd vssd sg13cmos5l_decap_8
XFILLER_14_1904 vccd vssd sg13cmos5l_decap_8
XFILLER_14_2649 vccd vssd sg13cmos5l_decap_8
XFILLER_34_1385 vccd vssd sg13cmos5l_decap_4
XFILLER_34_1396 vccd vssd sg13cmos5l_decap_4
XFILLER_12_2384 vccd vssd sg13cmos5l_decap_8
X_1706_ _1706_/Q _1713_/CLK _1706_/D fanout130/X vccd vssd sg13cmos5l_dfrbpq_1
X_1637_ _1637_/Y _1641_/A _1638_/B_N vccd vssd sg13cmos5l_nor2b_1
XFILLER_12_1694 vccd vssd sg13cmos5l_decap_8
XFILLER_41_2013 vccd vssd sg13cmos5l_decap_8
X_1568_ _1575_/S _1588_/A _1568_/B vccd vssd sg13cmos5l_nand2_1
XFILLER_25_2756 vccd vssd sg13cmos5l_decap_8
XFILLER_8_1239 vccd vssd sg13cmos5l_decap_8
XFILLER_45_1470 vccd vssd sg13cmos5l_decap_8
X_1499_ _1499_/Y SDI _1508_/S vccd vssd sg13cmos5l_nor2_1
XFILLER_23_2480 vccd vssd sg13cmos5l_decap_8
XFILLER_3_2541 vccd vssd sg13cmos5l_decap_8
XFILLER_23_1790 vccd vssd sg13cmos5l_decap_8
XFILLER_3_1862 vccd vssd sg13cmos5l_decap_8
Xfanout11 _1495_/B _1497_/S vccd vssd sg13cmos5l_buf_1
Xfanout22 _1306_/B _1063_/X vccd vssd sg13cmos5l_buf_1
Xfanout55 _1142_/B _1003_/Y vccd vssd sg13cmos5l_buf_1
XFILLER_39_1285 vccd vssd sg13cmos5l_decap_8
Xfanout33 _1474_/B _1045_/Y vccd vssd sg13cmos5l_buf_1
Xfanout44 _1544_/B _1029_/Y vccd vssd sg13cmos5l_buf_1
XFILLER_23_763 vccd vssd sg13cmos5l_decap_8
XFILLER_11_903 vccd vssd sg13cmos5l_decap_8
Xfanout77 _1357_/A2 wire78/X vccd vssd sg13cmos5l_buf_1
Xfanout66 _1588_/B _0966_/Y vccd vssd sg13cmos5l_buf_2
XFILLER_32_2749 vccd vssd sg13cmos5l_decap_8
Xfanout99 _1595_/A0 _1506_/A vccd vssd sg13cmos5l_buf_1
XFILLER_22_273 vccd vssd sg13cmos5l_decap_8
XFILLER_17_1561 vccd vssd sg13cmos5l_decap_8
XFILLER_10_413 vccd vssd sg13cmos5l_decap_8
Xfanout88 _1391_/A2 _1390_/A vccd vssd sg13cmos5l_buf_1
XFILLER_13_21 vccd vssd sg13cmos5l_decap_8
XFILLER_6_406 vccd vssd sg13cmos5l_decap_8
XFILLER_13_1414 vccd vssd sg13cmos5l_decap_8
XFILLER_30_2462 vccd vssd sg13cmos5l_decap_8
XFILLER_13_98 vccd vssd sg13cmos5l_decap_8
XFILLER_30_1772 vccd vssd sg13cmos5l_decap_8
XFILLER_2_623 vccd vssd sg13cmos5l_decap_8
Xhold480 hold480/X _1779_/Q vccd vssd sg13cmos5l_dlygate4sd3_1
XFILLER_1_133 vccd vssd sg13cmos5l_decap_8
Xhold491 _1770_/D _1566_/X vccd vssd sg13cmos5l_dlygate4sd3_1
XFILLER_24_2266 vccd vssd sg13cmos5l_decap_8
XFILLER_24_2244 vccd vssd sg13cmos5l_decap_4
XFILLER_24_1510 vccd vssd sg13cmos5l_decap_8
XFILLER_4_2338 vccd vssd sg13cmos5l_decap_8
XFILLER_8_2485 vccd vssd sg13cmos5l_decap_8
XFILLER_24_2288 vccd vssd sg13cmos5l_decap_8
XFILLER_38_84 vccd vssd sg13cmos5l_decap_8
XFILLER_20_1407 vccd vssd sg13cmos5l_decap_8
XFILLER_2_2051 vccd vssd sg13cmos5l_decap_8
XFILLER_4_1659 vccd vssd sg13cmos5l_decap_8
XFILLER_45_343 vccd vssd sg13cmos5l_decap_8
XFILLER_18_546 vccd vssd sg13cmos5l_decap_8
XFILLER_2_1372 vccd vssd sg13cmos5l_decap_8
XFILLER_37_1904 vccd vssd sg13cmos5l_decap_8
XFILLER_33_549 vccd vssd sg13cmos5l_decap_8
XFILLER_26_590 vccd vssd sg13cmos5l_decap_8
XFILLER_18_2026 vccd vssd sg13cmos5l_decap_8
XFILLER_14_763 vccd vssd sg13cmos5l_decap_8
XFILLER_41_593 vccd vssd sg13cmos5l_decap_8
XFILLER_18_1358 vccd vssd sg13cmos5l_decap_8
XFILLER_13_273 vccd vssd sg13cmos5l_decap_8
XFILLER_35_1661 vccd vssd sg13cmos5l_decap_8
X_0870_ _0870_/Y _0870_/A vccd vssd sg13cmos5l_inv_1
XFILLER_16_1071 vccd vssd sg13cmos5l_decap_8
XFILLER_9_266 vccd vssd sg13cmos5l_decap_8
XFILLER_13_2660 vccd vssd sg13cmos5l_decap_8
XFILLER_31_1536 vccd vssd sg13cmos5l_decap_8
Xclkload14 clkload14/Y _1809_/CLK vccd vssd sg13cmos5l_inv_1
XFILLER_10_980 vccd vssd sg13cmos5l_decap_8
XFILLER_6_973 vccd vssd sg13cmos5l_decap_8
XFILLER_13_1981 vccd vssd sg13cmos5l_decap_8
XFILLER_5_483 vccd vssd sg13cmos5l_decap_8
XFILLER_9_2205 vccd vssd sg13cmos5l_decap_8
XFILLER_29_2166 vccd vssd sg13cmos5l_decap_8
X_1422_ _1422_/X _1401_/A hold328/X _1428_/S vccd vssd sg13cmos5l_mux2_1
XFILLER_44_1919 vccd vssd sg13cmos5l_decap_8
XFILLER_25_1307 vccd vssd sg13cmos5l_decap_8
XFILLER_9_1526 vccd vssd sg13cmos5l_decap_8
XFILLER_42_1610 vccd vssd sg13cmos5l_decap_8
X_1353_ _1353_/Y hold195/X _0888_/C _1391_/A2 vccd vssd sg13cmos5l_a21oi_1
Xtiedowns\[122\] status[122] vccd vssd sg13cmos5l_antennanp
X_1284_ _1284_/Y _0843_/Y _1531_/B _1284_/B1 vccd vssd sg13cmos5l_a21oi_1
XFILLER_23_1042 vccd vssd sg13cmos5l_decap_8
XFILLER_20_2653 vccd vssd sg13cmos5l_decap_8
XFILLER_37_866 vccd vssd sg13cmos5l_decap_8
XFILLER_36_343 vccd vssd sg13cmos5l_decap_8
XFILLER_3_1169 vccd vssd sg13cmos5l_decap_8
XFILLER_0_2758 vccd vssd sg13cmos5l_decap_8
XFILLER_36_2137 vccd vssd sg13cmos5l_decap_8
XFILLER_32_560 vccd vssd sg13cmos5l_decap_8
XFILLER_20_700 vccd vssd sg13cmos5l_decap_8
XFILLER_14_1701 vccd vssd sg13cmos5l_decap_8
XFILLER_14_2435 vccd vssd sg13cmos5l_decap_8
Xclkload8 clkload8/Y clkload8/A vccd vssd sg13cmos5l_inv_1
XFILLER_20_777 vccd vssd sg13cmos5l_decap_8
XFILLER_14_2457 vccd vssd sg13cmos5l_decap_8
X_0999_ _1000_/C status[63] _1315_/B1 _1268_/B1 vccd vssd sg13cmos5l_a21oi_1
XFILLER_30_1024 vccd vssd sg13cmos5l_decap_8
XFILLER_30_1002 vccd vssd sg13cmos5l_decap_8
XFILLER_30_1068 vccd vssd sg13cmos5l_decap_8
XFILLER_14_1778 vccd vssd sg13cmos5l_decap_8
XFILLER_12_1491 vccd vssd sg13cmos5l_decap_8
XFILLER_43_2119 vccd vssd sg13cmos5l_decap_8
XFILLER_25_2531 vccd vssd sg13cmos5l_decap_8
XFILLER_8_1036 vccd vssd sg13cmos5l_decap_8
XFILLER_41_1120 vccd vssd sg13cmos5l_decap_8
Xclkbuf_5_4_0_SCK _1757_/CLK clkbuf_5_7_0_SCK/A vccd vssd sg13cmos5l_buf_8
XFILLER_25_1863 vccd vssd sg13cmos5l_decap_8
XFILLER_5_2647 vccd vssd sg13cmos5l_decap_8
XFILLER_41_1164 vccd vssd sg13cmos5l_decap_8
XFILLER_28_822 vccd vssd sg13cmos5l_decap_8
XFILLER_5_1946 vccd vssd sg13cmos5l_decap_8
XFILLER_27_343 vccd vssd sg13cmos5l_decap_8
XFILLER_19_2324 vccd vssd sg13cmos5l_decap_8
XFILLER_43_869 vccd vssd sg13cmos5l_decap_4
XFILLER_42_313 vccd vssd sg13cmos5l_decap_8
XFILLER_30_508 vccd vssd sg13cmos5l_decap_8
XFILLER_24_42 vccd vssd sg13cmos5l_decap_8
XFILLER_23_560 vccd vssd sg13cmos5l_decap_8
XFILLER_19_1645 vccd vssd sg13cmos5l_decap_8
XFILLER_11_700 vccd vssd sg13cmos5l_decap_8
XFILLER_36_2693 vccd vssd sg13cmos5l_decap_8
XFILLER_17_2081 vccd vssd sg13cmos5l_decap_8
XFILLER_10_210 vccd vssd sg13cmos5l_decap_8
XFILLER_32_2546 vccd vssd sg13cmos5l_decap_8
XFILLER_13_1211 vccd vssd sg13cmos5l_decap_8
XFILLER_6_203 vccd vssd sg13cmos5l_decap_8
XFILLER_11_777 vccd vssd sg13cmos5l_decap_8
XFILLER_40_63 vccd vssd sg13cmos5l_decap_8
XFILLER_32_1878 vccd vssd sg13cmos5l_decap_8
XFILLER_10_287 vccd vssd sg13cmos5l_decap_8
XFILLER_3_910 vccd vssd sg13cmos5l_decap_8
XFILLER_13_1288 vccd vssd sg13cmos5l_decap_8
XFILLER_2_420 vccd vssd sg13cmos5l_decap_8
XFILLER_6_0 vccd vssd sg13cmos5l_decap_8
Xtiedowns\[41\] status[41] vccd vssd sg13cmos5l_antennanp
XFILLER_3_987 vccd vssd sg13cmos5l_decap_8
XFILLER_2_497 vccd vssd sg13cmos5l_decap_8
XFILLER_8_2282 vccd vssd sg13cmos5l_decap_8
XFILLER_43_2686 vccd vssd sg13cmos5l_decap_8
XFILLER_4_2135 vccd vssd sg13cmos5l_decap_8
XFILLER_24_2085 vccd vssd sg13cmos5l_decap_8
XFILLER_24_1362 vccd vssd sg13cmos5l_decap_8
XFILLER_20_1204 vccd vssd sg13cmos5l_decap_8
XFILLER_19_833 vccd vssd sg13cmos5l_decap_8
XFILLER_1_35 vccd vssd sg13cmos5l_decap_8
XFILLER_24_1384 vccd vssd sg13cmos5l_decap_8
XFILLER_18_343 vccd vssd sg13cmos5l_decap_8
XFILLER_0_1309 vccd vssd sg13cmos5l_decap_8
XFILLER_4_1456 vccd vssd sg13cmos5l_decap_8
XFILLER_45_140 vccd vssd sg13cmos5l_decap_8
XFILLER_34_814 vccd vssd sg13cmos5l_decap_8
XFILLER_34_869 vccd vssd sg13cmos5l_decap_8
XFILLER_37_1745 vccd vssd sg13cmos5l_decap_8
XFILLER_33_357 vccd vssd sg13cmos5l_decap_8
XFILLER_15_2711 vccd vssd sg13cmos5l_decap_8
XFILLER_42_891 vccd vssd sg13cmos5l_decap_8
XFILLER_18_1155 vccd vssd sg13cmos5l_decap_8
XFILLER_14_560 vccd vssd sg13cmos5l_decap_8
X_0922_ _0922_/Y _0924_/A _0922_/A2 _0911_/Y vccd vssd sg13cmos5l_a21oi_1
XFILLER_14_1008 vccd vssd sg13cmos5l_decap_8
X_0853_ _0853_/Y _0853_/A vccd vssd sg13cmos5l_inv_1
XFILLER_11_1918 vccd vssd sg13cmos5l_decap_8
XFILLER_6_770 vccd vssd sg13cmos5l_decap_8
XFILLER_5_280 vccd vssd sg13cmos5l_decap_8
XFILLER_9_2002 vccd vssd sg13cmos5l_decap_8
XFILLER_9_1323 vccd vssd sg13cmos5l_decap_8
XFILLER_39_0 vccd vssd sg13cmos5l_decap_8
XFILLER_22_2704 vccd vssd sg13cmos5l_decap_8
X_1405_ _1406_/B _1407_/A _1404_/Y _1403_/Y vccd vssd sg13cmos5l_a21oi_1
XFILLER_9_2079 vccd vssd sg13cmos5l_decap_8
XFILLER_44_1749 vccd vssd sg13cmos5l_decap_8
X_1336_ _1336_/Y _1334_/Y _1333_/Y _1335_/Y vccd vssd sg13cmos5l_o21ai_1
XFILLER_42_1451 vccd vssd sg13cmos5l_decap_8
X_1267_ _1267_/Y _0849_/Y _1314_/B _1265_/X _1266_/Y _1315_/B1 vccd vssd sg13cmos5l_a221oi_1
XFILLER_20_2450 vccd vssd sg13cmos5l_decap_8
XFILLER_37_663 vccd vssd sg13cmos5l_decap_8
XFILLER_36_140 vccd vssd sg13cmos5l_decap_8
X_1198_ _1198_/X _1198_/A _1198_/B _1198_/C vccd vssd sg13cmos5l_or3_1
XFILLER_0_2555 vccd vssd sg13cmos5l_decap_8
XFILLER_25_836 vccd vssd sg13cmos5l_decap_8
XFILLER_36_1200 vccd vssd sg13cmos5l_decap_8
XFILLER_24_357 vccd vssd sg13cmos5l_decap_8
XFILLER_0_1876 vccd vssd sg13cmos5l_decap_8
XFILLER_20_574 vccd vssd sg13cmos5l_decap_8
XFILLER_10_2107 vccd vssd sg13cmos5l_decap_8
XFILLER_4_707 vccd vssd sg13cmos5l_decap_8
XFILLER_14_1575 vccd vssd sg13cmos5l_decap_8
XFILLER_3_217 vccd vssd sg13cmos5l_decap_8
XFILLER_10_1428 vccd vssd sg13cmos5l_decap_8
XFILLER_27_2637 vccd vssd sg13cmos5l_decap_8
XFILLER_10_77 vccd vssd sg13cmos5l_decap_8
XFILLER_27_1925 vccd vssd sg13cmos5l_decap_8
XFILLER_0_924 vccd vssd sg13cmos5l_decap_8
XFILLER_9_2580 vccd vssd sg13cmos5l_decap_4
XFILLER_5_2422 vccd vssd sg13cmos5l_decap_8
XFILLER_21_2225 vccd vssd sg13cmos5l_decap_8
XFILLER_19_42 vccd vssd sg13cmos5l_decap_8
XFILLER_5_1743 vccd vssd sg13cmos5l_decap_8
XFILLER_9_1890 vccd vssd sg13cmos5l_decap_8
XFILLER_28_630 vccd vssd sg13cmos5l_decap_8
XFILLER_5_2499 vccd vssd sg13cmos5l_decap_8
XFILLER_38_2700 vccd vssd sg13cmos5l_decap_8
XFILLER_28_685 vccd vssd sg13cmos5l_decap_8
XFILLER_27_140 vccd vssd sg13cmos5l_decap_8
XFILLER_21_1557 vccd vssd sg13cmos5l_decap_8
XFILLER_16_847 vccd vssd sg13cmos5l_decap_8
XFILLER_42_154 vccd vssd sg13cmos5l_decap_8
XFILLER_38_2777 vccd vssd sg13cmos5l_decap_8
XFILLER_35_63 vccd vssd sg13cmos5l_decap_8
XFILLER_19_2143 vccd vssd sg13cmos5l_decap_8
XFILLER_15_357 vccd vssd sg13cmos5l_decap_8
XFILLER_19_1442 vccd vssd sg13cmos5l_decap_8
XFILLER_42_198 vccd vssd sg13cmos5l_decap_8
Xtiedowns\[89\] status[89] vccd vssd sg13cmos5l_antennanp
XFILLER_32_2365 vccd vssd sg13cmos5l_decap_4
XFILLER_11_574 vccd vssd sg13cmos5l_decap_8
XFILLER_32_1653 vccd vssd sg13cmos5l_decap_8
XFILLER_7_567 vccd vssd sg13cmos5l_decap_8
XFILLER_10_2663 vccd vssd sg13cmos5l_decap_8
XFILLER_13_1085 vccd vssd sg13cmos5l_decap_8
XFILLER_45_2737 vccd vssd sg13cmos5l_decap_8
XFILLER_10_1995 vccd vssd sg13cmos5l_decap_8
XFILLER_32_7 vccd vssd sg13cmos5l_decap_8
XFILLER_26_2158 vccd vssd sg13cmos5l_decap_8
XFILLER_3_784 vccd vssd sg13cmos5l_decap_8
XFILLER_6_2219 vccd vssd sg13cmos5l_decap_8
XFILLER_2_294 vccd vssd sg13cmos5l_decap_8
XFILLER_38_427 vccd vssd sg13cmos5l_decap_8
XFILLER_26_1468 vccd vssd sg13cmos5l_decap_8
X_1121_ _1121_/Y _1674_/Q _1382_/A vccd vssd sg13cmos5l_nor2_1
XFILLER_20_1001 vccd vssd sg13cmos5l_decap_8
XFILLER_19_630 vccd vssd sg13cmos5l_decap_8
XFILLER_4_1253 vccd vssd sg13cmos5l_decap_8
X_1052_ _1052_/Y _1052_/A _1070_/C vccd vssd sg13cmos5l_nor2_1
XFILLER_18_140 vccd vssd sg13cmos5l_decap_8
XFILLER_0_1106 vccd vssd sg13cmos5l_decap_8
XFILLER_20_1078 vccd vssd sg13cmos5l_decap_8
XFILLER_37_2243 vccd vssd sg13cmos5l_decap_8
XFILLER_34_666 vccd vssd sg13cmos5l_decap_8
XFILLER_33_154 vccd vssd sg13cmos5l_decap_8
XFILLER_37_1575 vccd vssd sg13cmos5l_decap_8
XFILLER_15_2541 vccd vssd sg13cmos5l_decap_8
X_0905_ _0905_/Y _0938_/B _0905_/B vccd vssd sg13cmos5l_nand2_1
XFILLER_15_2585 vccd vssd sg13cmos5l_decap_8
XFILLER_30_894 vccd vssd sg13cmos5l_decap_4
XFILLER_15_1862 vccd vssd sg13cmos5l_decap_8
XFILLER_11_1715 vccd vssd sg13cmos5l_decap_8
X_0836_ _0836_/Y status[88] vccd vssd sg13cmos5l_inv_1
XFILLER_31_1152 vccd vssd sg13cmos5l_decap_8
Xoutbuffers\[72\] control[72] _1740_/Q vccd vssd sg13cmos5l_buf_8
XFILLER_44_2236 vccd vssd sg13cmos5l_decap_8
XFILLER_6_2720 vccd vssd sg13cmos5l_decap_8
XFILLER_9_1120 vccd vssd sg13cmos5l_decap_8
XFILLER_44_1546 vccd vssd sg13cmos5l_decap_8
XFILLER_29_1081 vccd vssd sg13cmos5l_decap_8
XFILLER_26_2670 vccd vssd sg13cmos5l_decap_8
XFILLER_22_2501 vccd vssd sg13cmos5l_decap_8
XFILLER_29_427 vccd vssd sg13cmos5l_decap_8
XFILLER_9_1197 vccd vssd sg13cmos5l_decap_8
X_1319_ _1319_/Y status[41] _1361_/B vccd vssd sg13cmos5l_nand2b_1
XFILLER_42_1270 vccd vssd sg13cmos5l_decap_8
XFILLER_22_2578 vccd vssd sg13cmos5l_decap_8
XFILLER_2_2639 vccd vssd sg13cmos5l_decap_8
XFILLER_38_2007 vccd vssd sg13cmos5l_decap_8
XFILLER_22_1888 vccd vssd sg13cmos5l_decap_8
XFILLER_38_1306 vccd vssd sg13cmos5l_decap_8
XFILLER_25_633 vccd vssd sg13cmos5l_decap_8
XFILLER_0_2352 vccd vssd sg13cmos5l_decap_8
XFILLER_0_1673 vccd vssd sg13cmos5l_decap_8
XFILLER_24_154 vccd vssd sg13cmos5l_decap_8
XFILLER_40_669 vccd vssd sg13cmos5l_decap_8
XFILLER_36_1074 vccd vssd sg13cmos5l_decap_8
XFILLER_33_2685 vccd vssd sg13cmos5l_decap_8
XFILLER_21_861 vccd vssd sg13cmos5l_decap_8
XFILLER_16_1659 vccd vssd sg13cmos5l_decap_8
XFILLER_14_2051 vccd vssd sg13cmos5l_decap_8
XFILLER_21_21 vccd vssd sg13cmos5l_decap_8
XFILLER_20_371 vccd vssd sg13cmos5l_decap_8
XFILLER_33_1995 vccd vssd sg13cmos5l_decap_8
XFILLER_4_504 vccd vssd sg13cmos5l_decap_8
XFILLER_10_1225 vccd vssd sg13cmos5l_decap_8
XFILLER_14_1372 vccd vssd sg13cmos5l_decap_8
XFILLER_27_2401 vccd vssd sg13cmos5l_decap_8
XFILLER_21_98 vccd vssd sg13cmos5l_decap_8
XFILLER_7_2506 vccd vssd sg13cmos5l_decap_8
XFILLER_27_1733 vccd vssd sg13cmos5l_decap_4
XFILLER_23_2309 vccd vssd sg13cmos5l_decap_8
XFILLER_0_721 vccd vssd sg13cmos5l_decap_8
XFILLER_7_1827 vccd vssd sg13cmos5l_decap_8
XFILLER_40_2645 vccd vssd sg13cmos5l_decap_8
XFILLER_27_1788 vccd vssd sg13cmos5l_decap_8
XFILLER_0_798 vccd vssd sg13cmos5l_decap_8
XFILLER_40_1911 vccd vssd sg13cmos5l_decap_8
XFILLER_5_1540 vccd vssd sg13cmos5l_decap_8
XFILLER_5_2296 vccd vssd sg13cmos5l_decap_8
XFILLER_40_1955 vccd vssd sg13cmos5l_decap_8
XFILLER_21_2077 vccd vssd sg13cmos5l_decap_8
XFILLER_1_2149 vccd vssd sg13cmos5l_decap_8
XFILLER_21_1365 vccd vssd sg13cmos5l_decap_8
XFILLER_44_986 vccd vssd sg13cmos5l_decap_8
XFILLER_43_441 vccd vssd sg13cmos5l_decap_8
XFILLER_16_644 vccd vssd sg13cmos5l_decap_8
XFILLER_43_474 vccd vssd sg13cmos5l_decap_8
XFILLER_38_2574 vccd vssd sg13cmos5l_decap_8
XFILLER_34_2427 vccd vssd sg13cmos5l_decap_8
XFILLER_15_154 vccd vssd sg13cmos5l_decap_8
XFILLER_38_1873 vccd vssd sg13cmos5l_decap_8
XFILLER_34_1704 vccd vssd sg13cmos5l_decap_8
XFILLER_31_669 vccd vssd sg13cmos5l_decap_8
XFILLER_30_168 vccd vssd sg13cmos5l_decap_8
XFILLER_12_861 vccd vssd sg13cmos5l_decap_8
XFILLER_32_2173 vccd vssd sg13cmos5l_decap_8
XFILLER_15_1169 vccd vssd sg13cmos5l_decap_8
XFILLER_8_854 vccd vssd sg13cmos5l_decap_8
XFILLER_11_371 vccd vssd sg13cmos5l_decap_8
XFILLER_12_2747 vccd vssd sg13cmos5l_decap_8
X_1670_ _1670_/Q _1675_/CLK _1670_/D fanout139/X vccd vssd sg13cmos5l_dfrbpq_1
XFILLER_7_56 vccd vssd sg13cmos5l_decap_8
XFILLER_7_364 vccd vssd sg13cmos5l_decap_8
Xhold309 _1678_/D _1433_/X vccd vssd sg13cmos5l_dlygate4sd3_1
XFILLER_28_1508 vccd vssd sg13cmos5l_decap_8
XFILLER_45_2534 vccd vssd sg13cmos5l_decap_8
XFILLER_3_581 vccd vssd sg13cmos5l_decap_8
XFILLER_10_1792 vccd vssd sg13cmos5l_decap_8
XFILLER_45_1855 vccd vssd sg13cmos5l_decap_8
XFILLER_6_2016 vccd vssd sg13cmos5l_decap_8
XFILLER_41_1719 vccd vssd sg13cmos5l_decap_8
XFILLER_39_736 vccd vssd sg13cmos5l_decap_8
XFILLER_26_1243 vccd vssd sg13cmos5l_decap_8
XFILLER_6_1337 vccd vssd sg13cmos5l_decap_8
XFILLER_38_224 vccd vssd sg13cmos5l_decap_8
XFILLER_27_909 vccd vssd sg13cmos5l_decap_8
X_1104_ _1104_/Y _1101_/Y _1102_/Y _1103_/Y vccd vssd sg13cmos5l_o21ai_1
XFILLER_4_1050 vccd vssd sg13cmos5l_decap_8
XFILLER_39_1637 vccd vssd sg13cmos5l_decap_8
XFILLER_37_2040 vccd vssd sg13cmos5l_decap_8
X_1035_ _1035_/X _1036_/A _1036_/B vccd vssd sg13cmos5l_and2_1
XFILLER_1_1960 vccd vssd sg13cmos5l_decap_8
XFILLER_22_658 vccd vssd sg13cmos5l_decap_8
XFILLER_17_1935 vccd vssd sg13cmos5l_decap_4
XFILLER_21_168 vccd vssd sg13cmos5l_decap_8
XFILLER_17_1979 vccd vssd sg13cmos5l_decap_8
XFILLER_15_2360 vccd vssd sg13cmos5l_decap_8
XFILLER_33_1269 vccd vssd sg13cmos5l_decap_8
XFILLER_11_2235 vccd vssd sg13cmos5l_decap_8
XFILLER_11_1512 vccd vssd sg13cmos5l_decap_8
XFILLER_28_2721 vccd vssd sg13cmos5l_decap_8
X_1799_ _1799_/Q _1802_/CLK _1799_/D _1634_/Y vccd vssd sg13cmos5l_dfrbpq_1
XFILLER_11_1589 vccd vssd sg13cmos5l_decap_8
XFILLER_44_2033 vccd vssd sg13cmos5l_decap_8
XFILLER_1_518 vccd vssd sg13cmos5l_decap_8
XFILLER_24_2629 vccd vssd sg13cmos5l_decap_8
XFILLER_44_1343 vccd vssd sg13cmos5l_decap_8
XFILLER_24_1906 vccd vssd sg13cmos5l_decap_8
XFILLER_29_224 vccd vssd sg13cmos5l_decap_8
XFILLER_22_2364 vccd vssd sg13cmos5l_decap_8
XFILLER_2_2436 vccd vssd sg13cmos5l_decap_8
XFILLER_6_2594 vccd vssd sg13cmos5l_decap_8
XFILLER_45_728 vccd vssd sg13cmos5l_decap_8
XFILLER_22_1641 vccd vssd sg13cmos5l_decap_8
XFILLER_44_227 vccd vssd sg13cmos5l_decap_8
XFILLER_26_931 vccd vssd sg13cmos5l_decap_8
XFILLER_2_1757 vccd vssd sg13cmos5l_decap_8
XFILLER_41_901 vccd vssd sg13cmos5l_decap_8
XFILLER_25_441 vccd vssd sg13cmos5l_decap_8
XFILLER_16_21 vccd vssd sg13cmos5l_decap_8
XFILLER_35_2714 vccd vssd sg13cmos5l_decap_8
XFILLER_0_1470 vccd vssd sg13cmos5l_decap_8
XFILLER_16_98 vccd vssd sg13cmos5l_decap_8
XFILLER_13_658 vccd vssd sg13cmos5l_decap_8
XFILLER_41_978 vccd vssd sg13cmos5l_decap_8
XFILLER_40_455 vccd vssd sg13cmos5l_decap_8
XFILLER_12_168 vccd vssd sg13cmos5l_decap_8
XFILLER_32_42 vccd vssd sg13cmos5l_decap_8
XFILLER_16_1456 vccd vssd sg13cmos5l_decap_8
XFILLER_12_1309 vccd vssd sg13cmos5l_decap_8
XFILLER_4_301 vccd vssd sg13cmos5l_decap_8
XFILLER_10_1022 vccd vssd sg13cmos5l_decap_8
XFILLER_5_868 vccd vssd sg13cmos5l_decap_8
XFILLER_4_378 vccd vssd sg13cmos5l_decap_8
XFILLER_7_2303 vccd vssd sg13cmos5l_decap_8
XFILLER_10_1099 vccd vssd sg13cmos5l_decap_8
XFILLER_23_2106 vccd vssd sg13cmos5l_decap_8
XFILLER_27_2297 vccd vssd sg13cmos5l_decap_8
XFILLER_7_1624 vccd vssd sg13cmos5l_decap_8
XFILLER_0_595 vccd vssd sg13cmos5l_decap_8
XFILLER_5_2093 vccd vssd sg13cmos5l_decap_8
XFILLER_40_1774 vccd vssd sg13cmos5l_decap_8
XFILLER_35_238 vccd vssd sg13cmos5l_decap_8
XFILLER_21_1162 vccd vssd sg13cmos5l_decap_8
XFILLER_17_931 vccd vssd sg13cmos5l_decap_8
XFILLER_16_441 vccd vssd sg13cmos5l_decap_8
XFILLER_1_1267 vccd vssd sg13cmos5l_decap_8
XFILLER_38_2382 vccd vssd sg13cmos5l_decap_8
XFILLER_34_2235 vccd vssd sg13cmos5l_decap_8
XFILLER_32_967 vccd vssd sg13cmos5l_decap_8
XFILLER_38_1692 vccd vssd sg13cmos5l_decap_4
XFILLER_34_1523 vccd vssd sg13cmos5l_decap_8
X_1722_ _1722_/Q clkload3/A _1722_/D fanout125/X vccd vssd sg13cmos5l_dfrbpq_1
XFILLER_8_651 vccd vssd sg13cmos5l_decap_8
X_1653_ _1653_/Q _1809_/CLK _1653_/D _1618_/Y vccd vssd sg13cmos5l_dfrbpq_1
XFILLER_7_161 vccd vssd sg13cmos5l_decap_8
XFILLER_12_1876 vccd vssd sg13cmos5l_decap_8
XFILLER_45_2331 vccd vssd sg13cmos5l_decap_8
X_1584_ _1584_/X _1481_/A hold506/X _1587_/S vccd vssd sg13cmos5l_mux2_1
XFILLER_28_1316 vccd vssd sg13cmos5l_decap_8
XFILLER_45_1652 vccd vssd sg13cmos5l_decap_8
XFILLER_26_1040 vccd vssd sg13cmos5l_decap_8
XFILLER_21_0 vccd vssd sg13cmos5l_decap_8
XFILLER_39_522 vccd vssd sg13cmos5l_decap_8
XFILLER_23_2662 vccd vssd sg13cmos5l_decap_8
XFILLER_3_2723 vccd vssd sg13cmos5l_decap_8
XFILLER_6_1134 vccd vssd sg13cmos5l_decap_8
XFILLER_27_717 vccd vssd sg13cmos5l_decap_8
Xoutbuffers\[35\] control[35] _1703_/Q vccd vssd sg13cmos5l_buf_8
XFILLER_26_238 vccd vssd sg13cmos5l_decap_8
X_1018_ _1018_/Y _1197_/B _1055_/A vccd vssd sg13cmos5l_nor2_1
XFILLER_39_1423 vccd vssd sg13cmos5l_decap_8
XFILLER_35_761 vccd vssd sg13cmos5l_decap_8
XFILLER_23_945 vccd vssd sg13cmos5l_decap_8
XFILLER_17_2455 vccd vssd sg13cmos5l_decap_8
XFILLER_37_1180 vccd vssd sg13cmos5l_decap_4
XFILLER_22_455 vccd vssd sg13cmos5l_decap_8
XFILLER_17_1743 vccd vssd sg13cmos5l_decap_8
XFILLER_30_2666 vccd vssd sg13cmos5l_decap_8
XFILLER_11_2065 vccd vssd sg13cmos5l_decap_8
XFILLER_30_1987 vccd vssd sg13cmos5l_decap_8
XFILLER_2_805 vccd vssd sg13cmos5l_decap_8
XFILLER_1_315 vccd vssd sg13cmos5l_decap_8
XFILLER_11_1386 vccd vssd sg13cmos5l_decap_8
XFILLER_28_2562 vccd vssd sg13cmos5l_decap_8
XFILLER_8_1911 vccd vssd sg13cmos5l_decap_8
XFILLER_8_2656 vccd vssd sg13cmos5l_decap_8
XFILLER_44_1140 vccd vssd sg13cmos5l_decap_8
XFILLER_28_2595 vccd vssd sg13cmos5l_decap_8
XFILLER_28_1861 vccd vssd sg13cmos5l_decap_8
XFILLER_24_2426 vccd vssd sg13cmos5l_decap_8
XFILLER_41_2740 vccd vssd sg13cmos5l_decap_8
XFILLER_24_1736 vccd vssd sg13cmos5l_decap_8
XFILLER_6_2380 vccd vssd sg13cmos5l_decap_8
XFILLER_2_2233 vccd vssd sg13cmos5l_decap_8
XFILLER_8_1988 vccd vssd sg13cmos5l_decap_8
XFILLER_45_525 vccd vssd sg13cmos5l_decap_8
XFILLER_40_1059 vccd vssd sg13cmos5l_decap_8
XFILLER_27_42 vccd vssd sg13cmos5l_decap_8
XFILLER_18_728 vccd vssd sg13cmos5l_decap_8
XFILLER_17_238 vccd vssd sg13cmos5l_decap_8
XFILLER_2_1554 vccd vssd sg13cmos5l_decap_8
XFILLER_26_794 vccd vssd sg13cmos5l_decap_8
XFILLER_14_945 vccd vssd sg13cmos5l_decap_8
XFILLER_43_52 vccd vssd sg13cmos5l_decap_8
XFILLER_41_775 vccd vssd sg13cmos5l_decap_8
XFILLER_40_252 vccd vssd sg13cmos5l_decap_8
XFILLER_35_2588 vccd vssd sg13cmos5l_decap_8
XFILLER_35_1821 vccd vssd sg13cmos5l_decap_4
XFILLER_13_455 vccd vssd sg13cmos5l_decap_8
XFILLER_16_1253 vccd vssd sg13cmos5l_decap_8
XFILLER_9_448 vccd vssd sg13cmos5l_decap_8
XFILLER_35_1887 vccd vssd sg13cmos5l_decap_8
XFILLER_12_1106 vccd vssd sg13cmos5l_decap_8
Xtiedowns\[71\] status[71] vccd vssd sg13cmos5l_antennanp
XFILLER_5_665 vccd vssd sg13cmos5l_decap_8
XFILLER_29_1603 vccd vssd sg13cmos5l_decap_8
XFILLER_4_175 vccd vssd sg13cmos5l_decap_8
XFILLER_29_1636 vccd vssd sg13cmos5l_decap_8
XFILLER_4_35 vccd vssd sg13cmos5l_decap_8
XFILLER_7_2100 vccd vssd sg13cmos5l_decap_8
XFILLER_9_1708 vccd vssd sg13cmos5l_decap_8
XFILLER_27_2094 vccd vssd sg13cmos5l_decap_8
XFILLER_7_1421 vccd vssd sg13cmos5l_decap_8
XFILLER_27_1382 vccd vssd sg13cmos5l_decap_8
XFILLER_1_882 vccd vssd sg13cmos5l_decap_8
XFILLER_7_2177 vccd vssd sg13cmos5l_decap_8
XFILLER_42_1869 vccd vssd sg13cmos5l_decap_8
XFILLER_40_2261 vccd vssd sg13cmos5l_decap_8
XFILLER_0_392 vccd vssd sg13cmos5l_decap_8
XFILLER_23_1268 vccd vssd sg13cmos5l_decap_8
XFILLER_7_1498 vccd vssd sg13cmos5l_decap_8
XFILLER_40_1571 vccd vssd sg13cmos5l_decap_8
Xoutbuffers\[125\] control[125] _1793_/Q vccd vssd sg13cmos5l_buf_8
XFILLER_1_1064 vccd vssd sg13cmos5l_decap_8
XFILLER_34_2021 vccd vssd sg13cmos5l_decap_8
XFILLER_32_742 vccd vssd sg13cmos5l_decap_8
XFILLER_31_252 vccd vssd sg13cmos5l_decap_8
XFILLER_18_2764 vccd vssd sg13cmos5l_decap_8
XFILLER_14_2628 vccd vssd sg13cmos5l_decap_8
XFILLER_34_2076 vccd vssd sg13cmos5l_decap_8
XFILLER_32_797 vccd vssd sg13cmos5l_decap_8
XFILLER_20_959 vccd vssd sg13cmos5l_decap_8
X_1705_ _1705_/Q _1711_/CLK _1705_/D fanout130/X vccd vssd sg13cmos5l_dfrbpq_1
XFILLER_12_2363 vccd vssd sg13cmos5l_decap_8
XFILLER_12_1673 vccd vssd sg13cmos5l_decap_8
X_1636_ _1636_/Y _1641_/A _1638_/B_N vccd vssd sg13cmos5l_nor2b_1
X_1567_ _1567_/X _1542_/A hold407/X _1567_/S vccd vssd sg13cmos5l_mux2_1
XFILLER_25_2735 vccd vssd sg13cmos5l_decap_8
XFILLER_8_1218 vccd vssd sg13cmos5l_decap_8
X_1498_ _1509_/S _1588_/A _1498_/B vccd vssd sg13cmos5l_nand2_1
XFILLER_41_2069 vccd vssd sg13cmos5l_decap_8
XFILLER_41_1346 vccd vssd sg13cmos5l_decap_8
XFILLER_3_2520 vccd vssd sg13cmos5l_decap_8
XFILLER_39_374 vccd vssd sg13cmos5l_decap_8
XFILLER_3_1841 vccd vssd sg13cmos5l_decap_8
XFILLER_27_547 vccd vssd sg13cmos5l_decap_8
XFILLER_3_2597 vccd vssd sg13cmos5l_decap_8
XFILLER_19_2539 vccd vssd sg13cmos5l_decap_4
XFILLER_39_1264 vccd vssd sg13cmos5l_decap_8
Xfanout12 _1485_/S _1480_/S vccd vssd sg13cmos5l_buf_1
XFILLER_23_742 vccd vssd sg13cmos5l_decap_8
XFILLER_19_1816 vccd vssd sg13cmos5l_decap_8
Xfanout56 _1363_/A2 _1003_/Y vccd vssd sg13cmos5l_buf_1
Xfanout45 _1371_/B _1029_/Y vccd vssd sg13cmos5l_buf_1
Xfanout34 _1486_/B _1043_/Y vccd vssd sg13cmos5l_buf_1
Xfanout23 _1210_/B _1058_/Y vccd vssd sg13cmos5l_buf_1
XFILLER_22_252 vccd vssd sg13cmos5l_decap_8
XFILLER_17_2263 vccd vssd sg13cmos5l_decap_4
XFILLER_35_1139 vccd vssd sg13cmos5l_decap_8
XFILLER_32_2728 vccd vssd sg13cmos5l_decap_8
Xfanout67 _1152_/B _1556_/B vccd vssd sg13cmos5l_buf_1
XFILLER_17_2285 vccd vssd sg13cmos5l_decap_8
XFILLER_17_1540 vccd vssd sg13cmos5l_decap_8
XFILLER_11_959 vccd vssd sg13cmos5l_decap_8
Xfanout89 _1390_/A _0945_/Y vccd vssd sg13cmos5l_buf_1
XFILLER_10_469 vccd vssd sg13cmos5l_decap_8
XFILLER_13_77 vccd vssd sg13cmos5l_decap_8
XFILLER_30_1751 vccd vssd sg13cmos5l_decap_8
XFILLER_30_1784 vccd vssd sg13cmos5l_decap_4
XFILLER_2_602 vccd vssd sg13cmos5l_decap_8
XFILLER_11_1183 vccd vssd sg13cmos5l_decap_8
Xhold481 _1779_/D _1577_/X vccd vssd sg13cmos5l_dlygate4sd3_1
Xhold470 _0902_/A _0904_/C vccd vssd sg13cmos5l_dlygate4sd3_1
XFILLER_1_112 vccd vssd sg13cmos5l_decap_8
Xhold492 hold492/X _1768_/Q vccd vssd sg13cmos5l_dlygate4sd3_1
XFILLER_2_679 vccd vssd sg13cmos5l_decap_8
XFILLER_8_2464 vccd vssd sg13cmos5l_decap_8
XFILLER_1_189 vccd vssd sg13cmos5l_decap_8
XFILLER_4_2317 vccd vssd sg13cmos5l_decap_8
XFILLER_38_63 vccd vssd sg13cmos5l_decap_8
XFILLER_24_1533 vccd vssd sg13cmos5l_decap_8
XFILLER_8_1785 vccd vssd sg13cmos5l_decap_8
XFILLER_24_1588 vccd vssd sg13cmos5l_decap_8
XFILLER_18_525 vccd vssd sg13cmos5l_decap_8
XFILLER_2_2030 vccd vssd sg13cmos5l_decap_8
XFILLER_4_1638 vccd vssd sg13cmos5l_decap_8
XFILLER_45_322 vccd vssd sg13cmos5l_decap_8
XFILLER_41_1880 vccd vssd sg13cmos5l_decap_8
XFILLER_2_1351 vccd vssd sg13cmos5l_decap_8
XFILLER_37_2639 vccd vssd sg13cmos5l_decap_8
XFILLER_33_528 vccd vssd sg13cmos5l_decap_8
XFILLER_45_399 vccd vssd sg13cmos5l_decap_8
XFILLER_14_742 vccd vssd sg13cmos5l_decap_8
XFILLER_35_2341 vccd vssd sg13cmos5l_decap_8
XFILLER_18_1337 vccd vssd sg13cmos5l_decap_8
XFILLER_13_252 vccd vssd sg13cmos5l_decap_8
XFILLER_41_572 vccd vssd sg13cmos5l_decap_8
XFILLER_35_2385 vccd vssd sg13cmos5l_decap_8
XFILLER_31_2249 vccd vssd sg13cmos5l_decap_8
XFILLER_31_1515 vccd vssd sg13cmos5l_decap_8
XFILLER_16_1050 vccd vssd sg13cmos5l_decap_8
XFILLER_9_245 vccd vssd sg13cmos5l_decap_8
Xclkload15 clkload15/Y _1697_/CLK vccd vssd sg13cmos5l_inv_1
XFILLER_29_2112 vccd vssd sg13cmos5l_decap_8
XFILLER_6_952 vccd vssd sg13cmos5l_decap_8
XFILLER_13_1960 vccd vssd sg13cmos5l_decap_8
XFILLER_5_462 vccd vssd sg13cmos5l_decap_8
X_1421_ _1668_/D _1488_/A1 _1428_/S hold202/X vccd vssd sg13cmos5l_o21ai_1
XFILLER_29_1433 vccd vssd sg13cmos5l_decap_8
XFILLER_9_1505 vccd vssd sg13cmos5l_decap_8
XFILLER_29_1499 vccd vssd sg13cmos5l_decap_8
X_1352_ _1352_/Y _1351_/Y _1349_/Y _1217_/B vccd vssd sg13cmos5l_o21ai_1
XFILLER_42_1622 vccd vssd sg13cmos5l_decap_8
X_1283_ _1283_/X _1758_/Q _1371_/B _1531_/B vccd vssd sg13cmos5l_a21o_1
Xtiedowns\[115\] status[115] vccd vssd sg13cmos5l_antennanp
XFILLER_42_1666 vccd vssd sg13cmos5l_decap_8
XFILLER_20_2632 vccd vssd sg13cmos5l_decap_8
XFILLER_7_1295 vccd vssd sg13cmos5l_decap_8
XFILLER_42_1699 vccd vssd sg13cmos5l_decap_8
XFILLER_37_845 vccd vssd sg13cmos5l_decap_8
XFILLER_36_322 vccd vssd sg13cmos5l_decap_8
XFILLER_23_1098 vccd vssd sg13cmos5l_decap_8
XFILLER_3_1148 vccd vssd sg13cmos5l_decap_8
XFILLER_0_2737 vccd vssd sg13cmos5l_decap_8
XFILLER_24_539 vccd vssd sg13cmos5l_decap_8
XFILLER_36_1426 vccd vssd sg13cmos5l_decap_8
XFILLER_36_1448 vccd vssd sg13cmos5l_decap_8
XFILLER_18_2583 vccd vssd sg13cmos5l_decap_8
XFILLER_14_2414 vccd vssd sg13cmos5l_decap_8
Xclkload9 clkload9/Y clkload9/A vccd vssd sg13cmos5l_inv_1
XFILLER_20_756 vccd vssd sg13cmos5l_decap_8
XFILLER_18_1882 vccd vssd sg13cmos5l_decap_8
XFILLER_18_1871 vccd vssd sg13cmos5l_decap_8
X_0998_ _0998_/Y _1029_/A _1058_/B _1046_/B vccd vssd sg13cmos5l_nor3_1
XFILLER_14_1757 vccd vssd sg13cmos5l_decap_8
XFILLER_30_1047 vccd vssd sg13cmos5l_decap_8
XFILLER_12_1470 vccd vssd sg13cmos5l_decap_8
X_1619_ _1619_/Y _1644_/A _1643_/B_N vccd vssd sg13cmos5l_nor2b_1
XFILLER_25_2510 vccd vssd sg13cmos5l_decap_8
XFILLER_8_1015 vccd vssd sg13cmos5l_decap_8
XFILLER_9_2784 vccd vssd sg13cmos5l_decap_8
XFILLER_25_2587 vccd vssd sg13cmos5l_decap_8
XFILLER_5_1925 vccd vssd sg13cmos5l_decap_8
XFILLER_41_1143 vccd vssd sg13cmos5l_decap_8
XFILLER_39_182 vccd vssd sg13cmos5l_decap_8
XFILLER_27_322 vccd vssd sg13cmos5l_decap_8
XFILLER_21_1739 vccd vssd sg13cmos5l_decap_8
XFILLER_3_2394 vccd vssd sg13cmos5l_decap_8
XFILLER_28_889 vccd vssd sg13cmos5l_decap_4
XFILLER_27_399 vccd vssd sg13cmos5l_decap_8
XFILLER_15_539 vccd vssd sg13cmos5l_decap_8
XFILLER_24_21 vccd vssd sg13cmos5l_decap_8
XFILLER_19_1624 vccd vssd sg13cmos5l_decap_8
XFILLER_36_2672 vccd vssd sg13cmos5l_decap_8
XFILLER_17_2060 vccd vssd sg13cmos5l_decap_8
XFILLER_24_98 vccd vssd sg13cmos5l_decap_8
XFILLER_11_756 vccd vssd sg13cmos5l_decap_8
XFILLER_32_1857 vccd vssd sg13cmos5l_decap_8
XFILLER_7_749 vccd vssd sg13cmos5l_decap_8
XFILLER_10_266 vccd vssd sg13cmos5l_decap_8
XFILLER_40_42 vccd vssd sg13cmos5l_decap_8
XFILLER_30_2293 vccd vssd sg13cmos5l_decap_8
XFILLER_30_2260 vccd vssd sg13cmos5l_decap_8
XFILLER_6_259 vccd vssd sg13cmos5l_decap_8
XFILLER_13_1267 vccd vssd sg13cmos5l_decap_8
XFILLER_26_2329 vccd vssd sg13cmos5l_decap_8
XFILLER_26_1606 vccd vssd sg13cmos5l_decap_4
XFILLER_3_966 vccd vssd sg13cmos5l_decap_8
XFILLER_2_476 vccd vssd sg13cmos5l_decap_8
XFILLER_8_2261 vccd vssd sg13cmos5l_decap_8
Xtiedowns\[34\] status[34] vccd vssd sg13cmos5l_antennanp
XFILLER_43_1931 vccd vssd sg13cmos5l_decap_4
XFILLER_1_14 vccd vssd sg13cmos5l_decap_8
XFILLER_4_2114 vccd vssd sg13cmos5l_decap_8
XFILLER_37_119 vccd vssd sg13cmos5l_decap_8
XFILLER_19_812 vccd vssd sg13cmos5l_decap_8
XFILLER_4_1435 vccd vssd sg13cmos5l_decap_8
XFILLER_8_1582 vccd vssd sg13cmos5l_decap_8
XFILLER_18_322 vccd vssd sg13cmos5l_decap_8
XFILLER_19_889 vccd vssd sg13cmos5l_decap_8
XFILLER_45_196 vccd vssd sg13cmos5l_decap_8
XFILLER_37_2425 vccd vssd sg13cmos5l_decap_8
XFILLER_33_336 vccd vssd sg13cmos5l_decap_8
XFILLER_18_399 vccd vssd sg13cmos5l_decap_8
XFILLER_37_2469 vccd vssd sg13cmos5l_decap_8
XFILLER_37_1724 vccd vssd sg13cmos5l_decap_8
XFILLER_42_870 vccd vssd sg13cmos5l_decap_8
X_0921_ _0921_/Y _1801_/Q _0920_/Y _0915_/A vccd vssd sg13cmos5l_a21oi_1
XFILLER_18_1134 vccd vssd sg13cmos5l_decap_8
XFILLER_11_2609 vccd vssd sg13cmos5l_decap_8
X_0852_ _0852_/Y _0852_/A vccd vssd sg13cmos5l_inv_1
XFILLER_31_1301 vccd vssd sg13cmos5l_decap_8
XFILLER_31_2079 vccd vssd sg13cmos5l_decap_8
XFILLER_44_2429 vccd vssd sg13cmos5l_decap_8
XFILLER_9_1302 vccd vssd sg13cmos5l_decap_8
XFILLER_9_2058 vccd vssd sg13cmos5l_decap_8
XFILLER_44_1728 vccd vssd sg13cmos5l_decap_8
XFILLER_29_1263 vccd vssd sg13cmos5l_decap_8
X_1404_ _1404_/Y _0898_/B _0898_/C _0898_/A vccd vssd sg13cmos5l_o21ai_1
X_1335_ _1335_/Y _1725_/Q _1498_/B _1486_/B vccd vssd sg13cmos5l_a21oi_1
XFILLER_9_1379 vccd vssd sg13cmos5l_decap_8
XFILLER_42_1430 vccd vssd sg13cmos5l_decap_8
XFILLER_28_119 vccd vssd sg13cmos5l_decap_8
X_1266_ _1266_/Y status[74] _1362_/A2 _1314_/B vccd vssd sg13cmos5l_a21oi_1
XFILLER_0_2534 vccd vssd sg13cmos5l_decap_8
XFILLER_4_2681 vccd vssd sg13cmos5l_decap_8
XFILLER_7_1092 vccd vssd sg13cmos5l_decap_8
X_1197_ _1198_/B _1744_/Q _1197_/B _1197_/C vccd vssd sg13cmos5l_nor3_1
XFILLER_25_815 vccd vssd sg13cmos5l_decap_8
XFILLER_36_196 vccd vssd sg13cmos5l_decap_8
XFILLER_24_336 vccd vssd sg13cmos5l_decap_8
XFILLER_0_1855 vccd vssd sg13cmos5l_decap_8
XFILLER_40_818 vccd vssd sg13cmos5l_decap_8
XFILLER_14_2222 vccd vssd sg13cmos5l_decap_8
XFILLER_20_553 vccd vssd sg13cmos5l_decap_8
XFILLER_31_2591 vccd vssd sg13cmos5l_decap_8
XFILLER_10_1407 vccd vssd sg13cmos5l_decap_8
XFILLER_14_1554 vccd vssd sg13cmos5l_decap_8
XFILLER_31_1890 vccd vssd sg13cmos5l_decap_8
XFILLER_27_2616 vccd vssd sg13cmos5l_decap_8
XFILLER_27_1904 vccd vssd sg13cmos5l_decap_8
XFILLER_0_903 vccd vssd sg13cmos5l_decap_8
XFILLER_10_56 vccd vssd sg13cmos5l_decap_8
XFILLER_5_2401 vccd vssd sg13cmos5l_decap_8
XFILLER_21_2204 vccd vssd sg13cmos5l_decap_8
XFILLER_19_21 vccd vssd sg13cmos5l_decap_8
XFILLER_25_2395 vccd vssd sg13cmos5l_decap_8
XFILLER_25_1672 vccd vssd sg13cmos5l_decap_8
XFILLER_19_119 vccd vssd sg13cmos5l_decap_8
XFILLER_5_1722 vccd vssd sg13cmos5l_decap_8
XFILLER_5_2478 vccd vssd sg13cmos5l_decap_8
XFILLER_25_1694 vccd vssd sg13cmos5l_decap_8
XFILLER_21_1536 vccd vssd sg13cmos5l_decap_8
XFILLER_19_98 vccd vssd sg13cmos5l_decap_8
XFILLER_16_826 vccd vssd sg13cmos5l_decap_8
XFILLER_3_2191 vccd vssd sg13cmos5l_decap_8
XFILLER_5_1799 vccd vssd sg13cmos5l_decap_8
XFILLER_35_42 vccd vssd sg13cmos5l_decap_8
XFILLER_19_2122 vccd vssd sg13cmos5l_decap_8
XFILLER_15_336 vccd vssd sg13cmos5l_decap_8
XFILLER_42_133 vccd vssd sg13cmos5l_decap_8
XFILLER_38_2756 vccd vssd sg13cmos5l_decap_8
XFILLER_34_2609 vccd vssd sg13cmos5l_decap_8
XFILLER_27_196 vccd vssd sg13cmos5l_decap_8
XFILLER_19_1421 vccd vssd sg13cmos5l_decap_8
XFILLER_42_177 vccd vssd sg13cmos5l_decap_8
XFILLER_36_2491 vccd vssd sg13cmos5l_decap_8
XFILLER_32_2333 vccd vssd sg13cmos5l_decap_8
XFILLER_19_1498 vccd vssd sg13cmos5l_decap_8
XFILLER_32_1632 vccd vssd sg13cmos5l_decap_8
XFILLER_11_553 vccd vssd sg13cmos5l_decap_8
XFILLER_32_2388 vccd vssd sg13cmos5l_decap_8
XFILLER_7_546 vccd vssd sg13cmos5l_decap_8
XFILLER_30_2090 vccd vssd sg13cmos5l_decap_8
XFILLER_10_2642 vccd vssd sg13cmos5l_decap_8
XFILLER_13_1064 vccd vssd sg13cmos5l_decap_8
XFILLER_45_2716 vccd vssd sg13cmos5l_decap_8
XFILLER_3_763 vccd vssd sg13cmos5l_decap_8
XFILLER_10_1974 vccd vssd sg13cmos5l_decap_8
XFILLER_26_2137 vccd vssd sg13cmos5l_decap_8
XFILLER_2_273 vccd vssd sg13cmos5l_decap_8
XFILLER_43_2440 vccd vssd sg13cmos5l_decap_8
XFILLER_26_1447 vccd vssd sg13cmos5l_decap_8
XFILLER_25_7 vccd vssd sg13cmos5l_decap_8
XFILLER_6_1519 vccd vssd sg13cmos5l_decap_8
XFILLER_38_406 vccd vssd sg13cmos5l_decap_8
X_1120_ _1120_/Y _1682_/Q _1052_/Y _1419_/B vccd vssd sg13cmos5l_a21oi_1
XFILLER_4_1232 vccd vssd sg13cmos5l_decap_8
X_1051_ _1051_/X _1699_/Q _1164_/B _1439_/B vccd vssd sg13cmos5l_a21o_1
XFILLER_37_2222 vccd vssd sg13cmos5l_decap_8
XFILLER_20_1057 vccd vssd sg13cmos5l_decap_8
XFILLER_19_686 vccd vssd sg13cmos5l_decap_8
XFILLER_33_133 vccd vssd sg13cmos5l_decap_8
XFILLER_18_196 vccd vssd sg13cmos5l_decap_8
XFILLER_30_840 vccd vssd sg13cmos5l_decap_8
X_0904_ _0904_/Y _1394_/A _0904_/B _0904_/C vccd vssd sg13cmos5l_nand3_1
XFILLER_15_1841 vccd vssd sg13cmos5l_decap_8
XFILLER_11_2417 vccd vssd sg13cmos5l_decap_4
XFILLER_31_1131 vccd vssd sg13cmos5l_decap_8
Xclkbuf_5_3_0_SCK clkload2/A clkbuf_5_3_0_SCK/A vccd vssd sg13cmos5l_buf_8
X_0835_ _1394_/C _0835_/A vccd vssd sg13cmos5l_inv_1
XFILLER_44_2215 vccd vssd sg13cmos5l_decap_8
Xoutbuffers\[65\] control[65] _1733_/Q vccd vssd sg13cmos5l_buf_8
XFILLER_44_1525 vccd vssd sg13cmos5l_decap_8
XFILLER_29_406 vccd vssd sg13cmos5l_decap_8
XFILLER_2_2618 vccd vssd sg13cmos5l_decap_8
XFILLER_5_1029 vccd vssd sg13cmos5l_decap_8
XFILLER_6_2776 vccd vssd sg13cmos5l_decap_8
XFILLER_9_1176 vccd vssd sg13cmos5l_decap_8
X_1318_ _1318_/Y _1316_/Y _1315_/Y _1317_/Y vccd vssd sg13cmos5l_o21ai_1
XFILLER_22_2557 vccd vssd sg13cmos5l_decap_8
XFILLER_22_1823 vccd vssd sg13cmos5l_decap_8
X_1249_ _1249_/Y _0851_/Y _1342_/B _1247_/Y _1248_/Y vccd vssd sg13cmos5l_a22oi_1
XFILLER_22_1867 vccd vssd sg13cmos5l_decap_8
XFILLER_2_1939 vccd vssd sg13cmos5l_decap_8
XFILLER_0_2331 vccd vssd sg13cmos5l_decap_8
XFILLER_38_995 vccd vssd sg13cmos5l_decap_8
XFILLER_25_612 vccd vssd sg13cmos5l_decap_8
XFILLER_24_133 vccd vssd sg13cmos5l_decap_8
XFILLER_20_1591 vccd vssd sg13cmos5l_decap_8
XFILLER_0_1652 vccd vssd sg13cmos5l_decap_8
XFILLER_40_626 vccd vssd sg13cmos5l_decap_8
XFILLER_25_689 vccd vssd sg13cmos5l_decap_8
XFILLER_40_648 vccd vssd sg13cmos5l_decap_8
XFILLER_36_1053 vccd vssd sg13cmos5l_decap_8
XFILLER_21_840 vccd vssd sg13cmos5l_decap_8
XFILLER_33_2664 vccd vssd sg13cmos5l_decap_8
XFILLER_20_350 vccd vssd sg13cmos5l_decap_8
XFILLER_16_1638 vccd vssd sg13cmos5l_decap_8
XFILLER_14_2030 vccd vssd sg13cmos5l_decap_8
XFILLER_33_1974 vccd vssd sg13cmos5l_decap_8
XFILLER_14_1351 vccd vssd sg13cmos5l_decap_8
XFILLER_10_1204 vccd vssd sg13cmos5l_decap_8
XFILLER_21_77 vccd vssd sg13cmos5l_decap_8
XFILLER_27_2457 vccd vssd sg13cmos5l_decap_8
XFILLER_27_1712 vccd vssd sg13cmos5l_decap_8
XFILLER_0_700 vccd vssd sg13cmos5l_decap_8
XFILLER_7_1806 vccd vssd sg13cmos5l_decap_8
XFILLER_40_2624 vccd vssd sg13cmos5l_decap_8
XFILLER_27_1767 vccd vssd sg13cmos5l_decap_8
XFILLER_25_2192 vccd vssd sg13cmos5l_decap_8
XFILLER_21_2001 vccd vssd sg13cmos5l_decap_8
XFILLER_0_777 vccd vssd sg13cmos5l_decap_8
XFILLER_40_1934 vccd vssd sg13cmos5l_decap_8
XFILLER_21_2056 vccd vssd sg13cmos5l_decap_8
XFILLER_1_2128 vccd vssd sg13cmos5l_decap_8
XFILLER_5_2275 vccd vssd sg13cmos5l_decap_8
XFILLER_21_1344 vccd vssd sg13cmos5l_decap_8
XFILLER_28_483 vccd vssd sg13cmos5l_decap_8
XFILLER_16_623 vccd vssd sg13cmos5l_decap_8
XFILLER_1_1449 vccd vssd sg13cmos5l_decap_8
XFILLER_5_1596 vccd vssd sg13cmos5l_decap_8
XFILLER_44_965 vccd vssd sg13cmos5l_decap_8
XFILLER_43_453 vccd vssd sg13cmos5l_decap_8
XFILLER_38_2553 vccd vssd sg13cmos5l_decap_8
XFILLER_15_133 vccd vssd sg13cmos5l_decap_8
XFILLER_34_2406 vccd vssd sg13cmos5l_decap_8
XFILLER_12_840 vccd vssd sg13cmos5l_decap_8
XFILLER_32_2152 vccd vssd sg13cmos5l_decap_8
XFILLER_30_147 vccd vssd sg13cmos5l_decap_8
XFILLER_19_1295 vccd vssd sg13cmos5l_decap_8
XFILLER_11_350 vccd vssd sg13cmos5l_decap_8
XFILLER_12_2726 vccd vssd sg13cmos5l_decap_8
XFILLER_15_1148 vccd vssd sg13cmos5l_decap_8
XFILLER_7_35 vccd vssd sg13cmos5l_decap_8
XFILLER_8_833 vccd vssd sg13cmos5l_decap_8
XFILLER_32_1484 vccd vssd sg13cmos5l_decap_8
XFILLER_7_343 vccd vssd sg13cmos5l_decap_8
XFILLER_45_2513 vccd vssd sg13cmos5l_decap_8
XFILLER_10_1771 vccd vssd sg13cmos5l_decap_8
XFILLER_10_2494 vccd vssd sg13cmos5l_decap_8
XFILLER_3_560 vccd vssd sg13cmos5l_decap_8
XFILLER_45_1834 vccd vssd sg13cmos5l_decap_8
XFILLER_26_1222 vccd vssd sg13cmos5l_decap_8
XFILLER_38_203 vccd vssd sg13cmos5l_decap_8
XFILLER_6_1316 vccd vssd sg13cmos5l_decap_8
XFILLER_26_1299 vccd vssd sg13cmos5l_decap_8
X_1103_ _1103_/Y _1786_/Q _1279_/B _1151_/B vccd vssd sg13cmos5l_a21oi_1
XFILLER_39_2339 vccd vssd sg13cmos5l_decap_8
XFILLER_39_1605 vccd vssd sg13cmos5l_decap_8
X_1034_ _1034_/Y _0876_/Y _1155_/B _1030_/Y _1032_/Y _1284_/B1 vccd vssd sg13cmos5l_a221oi_1
XFILLER_19_483 vccd vssd sg13cmos5l_decap_8
XFILLER_1_2695 vccd vssd sg13cmos5l_decap_8
XFILLER_22_637 vccd vssd sg13cmos5l_decap_8
Xoutbuffers\[9\] control[9] _1677_/Q vccd vssd sg13cmos5l_buf_8
XFILLER_33_1226 vccd vssd sg13cmos5l_decap_8
XFILLER_21_147 vccd vssd sg13cmos5l_decap_8
XFILLER_17_1958 vccd vssd sg13cmos5l_decap_8
XFILLER_11_2214 vccd vssd sg13cmos5l_decap_8
XFILLER_28_2700 vccd vssd sg13cmos5l_decap_8
X_1798_ _1798_/Q _1798_/CLK _1798_/D _1633_/Y vccd vssd sg13cmos5l_dfrbpq_1
XFILLER_11_1568 vccd vssd sg13cmos5l_decap_8
XFILLER_44_2012 vccd vssd sg13cmos5l_decap_8
XFILLER_27_1019 vccd vssd sg13cmos5l_decap_8
XFILLER_24_2608 vccd vssd sg13cmos5l_decap_8
XFILLER_44_1322 vccd vssd sg13cmos5l_decap_8
XFILLER_28_2777 vccd vssd sg13cmos5l_decap_8
XFILLER_44_2089 vccd vssd sg13cmos5l_decap_8
XFILLER_29_203 vccd vssd sg13cmos5l_decap_8
XFILLER_6_2562 vccd vssd sg13cmos5l_decap_8
XFILLER_44_1399 vccd vssd sg13cmos5l_decap_8
XFILLER_22_2343 vccd vssd sg13cmos5l_decap_8
XFILLER_22_1620 vccd vssd sg13cmos5l_decap_8
XFILLER_2_2415 vccd vssd sg13cmos5l_decap_8
XFILLER_45_707 vccd vssd sg13cmos5l_decap_8
XFILLER_6_1883 vccd vssd sg13cmos5l_decap_8
XFILLER_44_206 vccd vssd sg13cmos5l_decap_8
XFILLER_26_910 vccd vssd sg13cmos5l_decap_8
XFILLER_2_1736 vccd vssd sg13cmos5l_decap_8
XFILLER_37_280 vccd vssd sg13cmos5l_decap_8
XFILLER_25_420 vccd vssd sg13cmos5l_decap_8
XFILLER_22_1697 vccd vssd sg13cmos5l_decap_8
XFILLER_38_1148 vccd vssd sg13cmos5l_decap_8
XFILLER_16_77 vccd vssd sg13cmos5l_decap_8
XFILLER_41_957 vccd vssd sg13cmos5l_decap_8
XFILLER_25_497 vccd vssd sg13cmos5l_decap_8
XFILLER_13_637 vccd vssd sg13cmos5l_decap_8
XFILLER_32_21 vccd vssd sg13cmos5l_decap_8
XFILLER_16_1435 vccd vssd sg13cmos5l_decap_8
XFILLER_12_147 vccd vssd sg13cmos5l_decap_8
XFILLER_33_2483 vccd vssd sg13cmos5l_decap_8
XFILLER_32_98 vccd vssd sg13cmos5l_decap_8
XFILLER_33_1793 vccd vssd sg13cmos5l_decap_8
XFILLER_5_847 vccd vssd sg13cmos5l_decap_8
XFILLER_10_1001 vccd vssd sg13cmos5l_decap_8
XFILLER_4_357 vccd vssd sg13cmos5l_decap_8
XFILLER_29_1829 vccd vssd sg13cmos5l_decap_4
XFILLER_10_1078 vccd vssd sg13cmos5l_decap_8
XFILLER_27_2265 vccd vssd sg13cmos5l_decap_8
XFILLER_7_1603 vccd vssd sg13cmos5l_decap_8
XFILLER_27_1553 vccd vssd sg13cmos5l_decap_4
XFILLER_23_1406 vccd vssd sg13cmos5l_decap_8
XFILLER_0_574 vccd vssd sg13cmos5l_decap_8
XFILLER_7_2359 vccd vssd sg13cmos5l_decap_8
XFILLER_44_2590 vccd vssd sg13cmos5l_decap_8
XFILLER_40_2443 vccd vssd sg13cmos5l_decap_8
XFILLER_5_2072 vccd vssd sg13cmos5l_decap_8
XFILLER_40_2498 vccd vssd sg13cmos5l_decap_8
XFILLER_40_1753 vccd vssd sg13cmos5l_decap_8
XFILLER_35_217 vccd vssd sg13cmos5l_decap_8
XFILLER_21_1141 vccd vssd sg13cmos5l_decap_8
XFILLER_17_910 vccd vssd sg13cmos5l_decap_8
XFILLER_5_1393 vccd vssd sg13cmos5l_decap_8
XFILLER_28_280 vccd vssd sg13cmos5l_decap_8
XFILLER_16_420 vccd vssd sg13cmos5l_decap_8
XFILLER_1_1246 vccd vssd sg13cmos5l_decap_8
XFILLER_44_784 vccd vssd sg13cmos5l_decap_8
XFILLER_38_2350 vccd vssd sg13cmos5l_decap_4
XFILLER_32_902 vccd vssd sg13cmos5l_decap_8
XFILLER_17_987 vccd vssd sg13cmos5l_decap_8
XFILLER_32_946 vccd vssd sg13cmos5l_decap_8
XFILLER_31_434 vccd vssd sg13cmos5l_decap_8
XFILLER_16_497 vccd vssd sg13cmos5l_decap_8
XFILLER_19_1092 vccd vssd sg13cmos5l_decap_8
XFILLER_16_2692 vccd vssd sg13cmos5l_decap_8
XFILLER_8_630 vccd vssd sg13cmos5l_decap_8
X_1721_ _1721_/Q clkload3/A _1721_/D fanout128/X vccd vssd sg13cmos5l_dfrbpq_1
XFILLER_7_140 vccd vssd sg13cmos5l_decap_8
XFILLER_12_2556 vccd vssd sg13cmos5l_decap_8
X_1652_ _1652_/Q _1652_/CLK _1652_/D _1617_/Y vccd vssd sg13cmos5l_dfrbpq_1
XFILLER_12_1855 vccd vssd sg13cmos5l_decap_8
XFILLER_12_2589 vccd vssd sg13cmos5l_decap_8
XFILLER_45_2310 vccd vssd sg13cmos5l_decap_8
X_1583_ _1583_/X _1562_/A hold500/X _1587_/S vccd vssd sg13cmos5l_mux2_1
XFILLER_45_1631 vccd vssd sg13cmos5l_decap_8
XFILLER_45_2387 vccd vssd sg13cmos5l_decap_8
XFILLER_39_501 vccd vssd sg13cmos5l_decap_8
XFILLER_6_1113 vccd vssd sg13cmos5l_decap_8
XFILLER_41_1517 vccd vssd sg13cmos5l_decap_4
XFILLER_23_2641 vccd vssd sg13cmos5l_decap_8
XFILLER_3_2702 vccd vssd sg13cmos5l_decap_8
XFILLER_26_1096 vccd vssd sg13cmos5l_decap_8
XFILLER_23_1962 vccd vssd sg13cmos5l_decap_8
XFILLER_14_0 vccd vssd sg13cmos5l_decap_8
XFILLER_26_217 vccd vssd sg13cmos5l_decap_8
XFILLER_3_2779 vccd vssd sg13cmos5l_decap_8
XFILLER_39_1402 vccd vssd sg13cmos5l_decap_8
Xoutbuffers\[28\] control[28] _1696_/Q vccd vssd sg13cmos5l_buf_8
XFILLER_19_280 vccd vssd sg13cmos5l_decap_8
XFILLER_1_2492 vccd vssd sg13cmos5l_decap_8
XFILLER_39_2169 vccd vssd sg13cmos5l_decap_8
X_1017_ _1055_/A _1046_/A _1017_/B vccd vssd sg13cmos5l_nand2b_1
XFILLER_23_924 vccd vssd sg13cmos5l_decap_8
XFILLER_34_294 vccd vssd sg13cmos5l_decap_8
XFILLER_22_434 vccd vssd sg13cmos5l_decap_8
XFILLER_17_2434 vccd vssd sg13cmos5l_decap_8
XFILLER_17_1722 vccd vssd sg13cmos5l_decap_8
Xtiedowns\[0\] status[0] vccd vssd sg13cmos5l_antennanp
XFILLER_34_2770 vccd vssd sg13cmos5l_decap_8
XFILLER_33_1045 vccd vssd sg13cmos5l_decap_8
XFILLER_30_2645 vccd vssd sg13cmos5l_decap_8
XFILLER_11_2044 vccd vssd sg13cmos5l_decap_8
XFILLER_30_1966 vccd vssd sg13cmos5l_decap_8
XFILLER_11_1365 vccd vssd sg13cmos5l_decap_8
XFILLER_28_2541 vccd vssd sg13cmos5l_decap_8
XFILLER_28_1840 vccd vssd sg13cmos5l_decap_8
XFILLER_24_2405 vccd vssd sg13cmos5l_decap_8
XFILLER_8_2635 vccd vssd sg13cmos5l_decap_8
XFILLER_24_1715 vccd vssd sg13cmos5l_decap_8
XFILLER_8_1967 vccd vssd sg13cmos5l_decap_8
XFILLER_44_1196 vccd vssd sg13cmos5l_decap_8
XFILLER_40_1038 vccd vssd sg13cmos5l_decap_8
XFILLER_18_707 vccd vssd sg13cmos5l_decap_8
XFILLER_2_2212 vccd vssd sg13cmos5l_decap_8
XFILLER_45_504 vccd vssd sg13cmos5l_decap_8
XFILLER_27_21 vccd vssd sg13cmos5l_decap_8
XFILLER_22_2195 vccd vssd sg13cmos5l_decap_8
XFILLER_22_1450 vccd vssd sg13cmos5l_decap_8
XFILLER_17_217 vccd vssd sg13cmos5l_decap_8
XFILLER_2_1533 vccd vssd sg13cmos5l_decap_8
XFILLER_6_1680 vccd vssd sg13cmos5l_decap_8
XFILLER_2_2289 vccd vssd sg13cmos5l_decap_8
XFILLER_26_773 vccd vssd sg13cmos5l_decap_8
XFILLER_27_98 vccd vssd sg13cmos5l_decap_8
XFILLER_14_924 vccd vssd sg13cmos5l_decap_8
XFILLER_35_1800 vccd vssd sg13cmos5l_decap_8
XFILLER_25_294 vccd vssd sg13cmos5l_decap_8
XFILLER_18_1519 vccd vssd sg13cmos5l_decap_8
XFILLER_13_434 vccd vssd sg13cmos5l_decap_8
XFILLER_41_754 vccd vssd sg13cmos5l_decap_8
XFILLER_40_231 vccd vssd sg13cmos5l_decap_8
XFILLER_35_2567 vccd vssd sg13cmos5l_decap_8
XFILLER_35_1866 vccd vssd sg13cmos5l_decap_8
XFILLER_35_1844 vccd vssd sg13cmos5l_decap_8
XFILLER_16_1232 vccd vssd sg13cmos5l_decap_8
XFILLER_9_427 vccd vssd sg13cmos5l_decap_8
XFILLER_33_1590 vccd vssd sg13cmos5l_decap_8
Xtiedowns\[64\] status[64] vccd vssd sg13cmos5l_antennanp
XFILLER_5_644 vccd vssd sg13cmos5l_decap_8
XFILLER_4_14 vccd vssd sg13cmos5l_decap_8
XFILLER_4_154 vccd vssd sg13cmos5l_decap_8
XFILLER_27_2073 vccd vssd sg13cmos5l_decap_8
XFILLER_1_861 vccd vssd sg13cmos5l_decap_8
XFILLER_7_1400 vccd vssd sg13cmos5l_decap_8
XFILLER_7_2156 vccd vssd sg13cmos5l_decap_8
XFILLER_27_1350 vccd vssd sg13cmos5l_decap_8
XFILLER_3_2009 vccd vssd sg13cmos5l_decap_8
XFILLER_0_371 vccd vssd sg13cmos5l_decap_8
XFILLER_7_1477 vccd vssd sg13cmos5l_decap_8
XFILLER_40_1550 vccd vssd sg13cmos5l_decap_8
XFILLER_36_548 vccd vssd sg13cmos5l_decap_4
XFILLER_1_1043 vccd vssd sg13cmos5l_decap_8
XFILLER_5_1190 vccd vssd sg13cmos5l_decap_8
XFILLER_44_592 vccd vssd sg13cmos5l_decap_8
XFILLER_36_1619 vccd vssd sg13cmos5l_decap_8
Xoutbuffers\[118\] control[118] _1786_/Q vccd vssd sg13cmos5l_buf_8
XFILLER_34_2000 vccd vssd sg13cmos5l_decap_8
XFILLER_32_721 vccd vssd sg13cmos5l_decap_8
XFILLER_18_2743 vccd vssd sg13cmos5l_decap_8
XFILLER_17_784 vccd vssd sg13cmos5l_decap_8
XFILLER_31_231 vccd vssd sg13cmos5l_decap_8
XFILLER_17_1029 vccd vssd sg13cmos5l_decap_8
XFILLER_16_294 vccd vssd sg13cmos5l_decap_8
XFILLER_20_938 vccd vssd sg13cmos5l_decap_8
XFILLER_12_2342 vccd vssd sg13cmos5l_decap_8
XFILLER_14_1939 vccd vssd sg13cmos5l_decap_8
XFILLER_30_1229 vccd vssd sg13cmos5l_decap_8
X_1704_ _1704_/Q _1802_/CLK _1704_/D _1635_/B_N vccd vssd sg13cmos5l_dfrbpq_1
XFILLER_9_994 vccd vssd sg13cmos5l_decap_8
XFILLER_12_1652 vccd vssd sg13cmos5l_decap_8
X_1635_ _1635_/Y _1641_/A _1635_/B_N vccd vssd sg13cmos5l_nor2b_1
X_1566_ _1566_/X _1528_/A hold490/X _1566_/S vccd vssd sg13cmos5l_mux2_1
XFILLER_25_2714 vccd vssd sg13cmos5l_decap_8
XFILLER_45_2184 vccd vssd sg13cmos5l_decap_8
XFILLER_28_1169 vccd vssd sg13cmos5l_decap_8
XFILLER_28_1147 vccd vssd sg13cmos5l_decap_8
XFILLER_41_2048 vccd vssd sg13cmos5l_decap_8
X_1497_ _1497_/X hold526/X hold411/X _1497_/S vccd vssd sg13cmos5l_mux2_1
XFILLER_41_1325 vccd vssd sg13cmos5l_decap_8
XFILLER_27_504 vccd vssd sg13cmos5l_decap_8
XFILLER_3_1820 vccd vssd sg13cmos5l_decap_8
XFILLER_3_2576 vccd vssd sg13cmos5l_decap_8
XFILLER_42_529 vccd vssd sg13cmos5l_decap_8
XFILLER_19_2518 vccd vssd sg13cmos5l_decap_8
XFILLER_3_1897 vccd vssd sg13cmos5l_decap_8
XFILLER_35_592 vccd vssd sg13cmos5l_decap_8
Xfanout13 _1471_/S _1472_/B vccd vssd sg13cmos5l_buf_1
XFILLER_23_721 vccd vssd sg13cmos5l_decap_8
Xfanout35 _1337_/B _1043_/Y vccd vssd sg13cmos5l_buf_1
XFILLER_35_1118 vccd vssd sg13cmos5l_decap_8
Xfanout24 _1419_/B _1055_/Y vccd vssd sg13cmos5l_buf_1
XFILLER_32_2707 vccd vssd sg13cmos5l_decap_8
Xfanout46 _1151_/B _1568_/B vccd vssd sg13cmos5l_buf_1
XFILLER_22_231 vccd vssd sg13cmos5l_decap_8
XFILLER_17_2242 vccd vssd sg13cmos5l_decap_8
Xfanout57 _1317_/B1 _1001_/Y vccd vssd sg13cmos5l_buf_1
Xfanout79 _1261_/B _0979_/Y vccd vssd sg13cmos5l_buf_1
XFILLER_23_798 vccd vssd sg13cmos5l_decap_8
Xfanout68 _0936_/B _0905_/Y vccd vssd sg13cmos5l_buf_1
XFILLER_11_938 vccd vssd sg13cmos5l_decap_8
XFILLER_13_2128 vccd vssd sg13cmos5l_decap_8
XFILLER_10_448 vccd vssd sg13cmos5l_decap_8
XFILLER_13_56 vccd vssd sg13cmos5l_decap_8
XFILLER_17_1596 vccd vssd sg13cmos5l_decap_8
XFILLER_13_1449 vccd vssd sg13cmos5l_decap_8
XFILLER_11_1162 vccd vssd sg13cmos5l_decap_8
Xhold460 hold460/X _1742_/Q vccd vssd sg13cmos5l_dlygate4sd3_1
Xhold471 _1664_/D _0944_/Y vccd vssd sg13cmos5l_dlygate4sd3_1
XFILLER_2_658 vccd vssd sg13cmos5l_decap_8
Xhold493 _1768_/D _1564_/X vccd vssd sg13cmos5l_dlygate4sd3_1
Xhold482 _0835_/A _0948_/A vccd vssd sg13cmos5l_dlygate4sd3_1
XFILLER_8_2443 vccd vssd sg13cmos5l_decap_8
XFILLER_1_168 vccd vssd sg13cmos5l_decap_8
XFILLER_38_42 vccd vssd sg13cmos5l_decap_8
XFILLER_4_1617 vccd vssd sg13cmos5l_decap_8
XFILLER_8_1764 vccd vssd sg13cmos5l_decap_8
XFILLER_45_301 vccd vssd sg13cmos5l_decap_8
XFILLER_41_2593 vccd vssd sg13cmos5l_decap_8
XFILLER_24_1567 vccd vssd sg13cmos5l_decap_8
XFILLER_18_504 vccd vssd sg13cmos5l_decap_8
XFILLER_2_2086 vccd vssd sg13cmos5l_decap_8
XFILLER_2_1330 vccd vssd sg13cmos5l_decap_8
XFILLER_45_378 vccd vssd sg13cmos5l_decap_8
XFILLER_37_2618 vccd vssd sg13cmos5l_decap_8
XFILLER_22_1280 vccd vssd sg13cmos5l_decap_8
XFILLER_18_2006 vccd vssd sg13cmos5l_decap_4
XFILLER_35_2320 vccd vssd sg13cmos5l_decap_8
XFILLER_18_2039 vccd vssd sg13cmos5l_decap_8
XFILLER_14_721 vccd vssd sg13cmos5l_decap_8
XFILLER_41_551 vccd vssd sg13cmos5l_decap_8
XFILLER_37_1939 vccd vssd sg13cmos5l_decap_8
XFILLER_18_1316 vccd vssd sg13cmos5l_decap_8
XFILLER_13_231 vccd vssd sg13cmos5l_decap_8
XFILLER_35_2364 vccd vssd sg13cmos5l_decap_8
XFILLER_35_1630 vccd vssd sg13cmos5l_decap_8
XFILLER_9_224 vccd vssd sg13cmos5l_decap_8
XFILLER_14_798 vccd vssd sg13cmos5l_decap_8
XFILLER_35_1685 vccd vssd sg13cmos5l_decap_8
XFILLER_31_2228 vccd vssd sg13cmos5l_decap_8
Xclkload16 clkload16/Y _1707_/CLK vccd vssd sg13cmos5l_inv_1
XFILLER_6_931 vccd vssd sg13cmos5l_decap_8
XFILLER_13_2695 vccd vssd sg13cmos5l_decap_8
XFILLER_5_441 vccd vssd sg13cmos5l_decap_8
X_1420_ _1420_/Y _1420_/A _1428_/S vccd vssd sg13cmos5l_nand2_1
XFILLER_29_1412 vccd vssd sg13cmos5l_decap_8
XFILLER_42_2313 vccd vssd sg13cmos5l_decap_8
X_1351_ _1351_/Y _1351_/A _1351_/B vccd vssd sg13cmos5l_nand2_1
XFILLER_42_2346 vccd vssd sg13cmos5l_decap_8
XFILLER_42_1645 vccd vssd sg13cmos5l_decap_8
X_1282_ _1282_/Y _0844_/Y _1152_/B _1280_/Y _1281_/Y vccd vssd sg13cmos5l_a22oi_1
XFILLER_27_1180 vccd vssd sg13cmos5l_decap_8
XFILLER_20_2611 vccd vssd sg13cmos5l_decap_8
XFILLER_37_824 vccd vssd sg13cmos5l_decap_8
XFILLER_36_301 vccd vssd sg13cmos5l_decap_8
XFILLER_3_1127 vccd vssd sg13cmos5l_decap_8
XFILLER_0_2716 vccd vssd sg13cmos5l_decap_8
XFILLER_7_1274 vccd vssd sg13cmos5l_decap_8
XFILLER_40_2081 vccd vssd sg13cmos5l_decap_8
XFILLER_23_1077 vccd vssd sg13cmos5l_decap_8
XFILLER_20_2688 vccd vssd sg13cmos5l_decap_8
Xtiedowns\[108\] status[108] vccd vssd sg13cmos5l_antennanp
XFILLER_36_378 vccd vssd sg13cmos5l_decap_8
XFILLER_24_518 vccd vssd sg13cmos5l_decap_8
XFILLER_20_1987 vccd vssd sg13cmos5l_decap_8
XFILLER_17_581 vccd vssd sg13cmos5l_decap_8
XFILLER_36_1405 vccd vssd sg13cmos5l_decap_8
XFILLER_18_1850 vccd vssd sg13cmos5l_decap_8
XFILLER_32_595 vccd vssd sg13cmos5l_decap_8
XFILLER_20_735 vccd vssd sg13cmos5l_decap_8
XFILLER_31_2773 vccd vssd sg13cmos5l_decap_8
X_0997_ _1046_/B _0997_/A _0997_/B vccd vssd sg13cmos5l_nand2_1
XFILLER_14_1736 vccd vssd sg13cmos5l_decap_8
Xoutbuffers\[95\] control[95] _1763_/Q vccd vssd sg13cmos5l_buf_8
XFILLER_9_791 vccd vssd sg13cmos5l_decap_8
XFILLER_12_2194 vccd vssd sg13cmos5l_decap_8
X_1618_ _1618_/Y _1639_/A _1643_/B_N vccd vssd sg13cmos5l_nor2b_1
XFILLER_9_2763 vccd vssd sg13cmos5l_decap_8
X_1549_ _1549_/X _1443_/A hold392/X _1549_/S vccd vssd sg13cmos5l_mux2_1
XFILLER_25_2566 vccd vssd sg13cmos5l_decap_8
XFILLER_5_2616 vccd vssd sg13cmos5l_decap_8
XFILLER_25_1832 vccd vssd sg13cmos5l_decap_8
XFILLER_21_2419 vccd vssd sg13cmos5l_decap_8
XFILLER_5_1904 vccd vssd sg13cmos5l_decap_8
XFILLER_39_161 vccd vssd sg13cmos5l_decap_8
XFILLER_27_301 vccd vssd sg13cmos5l_decap_8
XFILLER_21_1718 vccd vssd sg13cmos5l_decap_8
XFILLER_28_857 vccd vssd sg13cmos5l_decap_8
XFILLER_25_1898 vccd vssd sg13cmos5l_decap_8
XFILLER_3_2373 vccd vssd sg13cmos5l_decap_8
XFILLER_27_378 vccd vssd sg13cmos5l_decap_8
XFILLER_15_518 vccd vssd sg13cmos5l_decap_8
XFILLER_36_890 vccd vssd sg13cmos5l_decap_8
XFILLER_19_1603 vccd vssd sg13cmos5l_decap_8
XFILLER_3_1694 vccd vssd sg13cmos5l_decap_8
XFILLER_36_2651 vccd vssd sg13cmos5l_decap_8
XFILLER_39_1084 vccd vssd sg13cmos5l_decap_8
XFILLER_24_77 vccd vssd sg13cmos5l_decap_8
XFILLER_23_595 vccd vssd sg13cmos5l_decap_8
XFILLER_11_735 vccd vssd sg13cmos5l_decap_8
XFILLER_36_1994 vccd vssd sg13cmos5l_decap_8
XFILLER_17_1393 vccd vssd sg13cmos5l_decap_8
XFILLER_7_728 vccd vssd sg13cmos5l_decap_8
XFILLER_10_245 vccd vssd sg13cmos5l_decap_8
XFILLER_40_21 vccd vssd sg13cmos5l_decap_8
XFILLER_6_238 vccd vssd sg13cmos5l_decap_8
XFILLER_13_1246 vccd vssd sg13cmos5l_decap_8
XFILLER_40_98 vccd vssd sg13cmos5l_decap_8
XFILLER_30_1582 vccd vssd sg13cmos5l_decap_8
XFILLER_3_945 vccd vssd sg13cmos5l_decap_8
XFILLER_43_2611 vccd vssd sg13cmos5l_decap_8
XFILLER_2_455 vccd vssd sg13cmos5l_decap_8
XFILLER_24_2021 vccd vssd sg13cmos5l_decap_8
Xhold290 _1409_/B _1408_/Y vccd vssd sg13cmos5l_dlygate4sd3_1
XFILLER_8_2240 vccd vssd sg13cmos5l_decap_8
XFILLER_24_1331 vccd vssd sg13cmos5l_decap_8
XFILLER_8_1561 vccd vssd sg13cmos5l_decap_8
Xtiedowns\[27\] status[27] vccd vssd sg13cmos5l_antennanp
XFILLER_43_1976 vccd vssd sg13cmos5l_decap_8
XFILLER_18_301 vccd vssd sg13cmos5l_decap_8
XFILLER_4_1414 vccd vssd sg13cmos5l_decap_8
XFILLER_37_2404 vccd vssd sg13cmos5l_decap_8
XFILLER_20_1239 vccd vssd sg13cmos5l_decap_8
XFILLER_19_868 vccd vssd sg13cmos5l_decap_8
XFILLER_45_175 vccd vssd sg13cmos5l_decap_8
XFILLER_33_315 vccd vssd sg13cmos5l_decap_8
XFILLER_27_890 vccd vssd sg13cmos5l_decap_8
XFILLER_18_378 vccd vssd sg13cmos5l_decap_8
XFILLER_18_1113 vccd vssd sg13cmos5l_decap_8
XFILLER_35_2161 vccd vssd sg13cmos5l_decap_8
X_0920_ _0920_/Y _0920_/A vccd vssd sg13cmos5l_inv_1
XFILLER_31_2014 vccd vssd sg13cmos5l_decap_8
XFILLER_14_595 vccd vssd sg13cmos5l_decap_8
X_0851_ _0851_/Y _0851_/A vccd vssd sg13cmos5l_inv_1
XFILLER_35_1482 vccd vssd sg13cmos5l_decap_8
XFILLER_31_2058 vccd vssd sg13cmos5l_decap_8
XFILLER_15_2779 vccd vssd sg13cmos5l_decap_8
XFILLER_31_1379 vccd vssd sg13cmos5l_decap_8
XFILLER_44_2408 vccd vssd sg13cmos5l_decap_8
XFILLER_29_1220 vccd vssd sg13cmos5l_decap_8
XFILLER_9_2037 vccd vssd sg13cmos5l_decap_8
XFILLER_44_1707 vccd vssd sg13cmos5l_decap_8
X_1403_ _1403_/Y _1403_/A _1403_/B _1403_/C vccd vssd sg13cmos5l_nor3_1
X_1334_ _1334_/Y _1733_/Q _1038_/Y _1036_/Y vccd vssd sg13cmos5l_o21ai_1
XFILLER_22_2739 vccd vssd sg13cmos5l_decap_8
XFILLER_9_1358 vccd vssd sg13cmos5l_decap_8
X_1265_ _1265_/X _1265_/A _1265_/B _1265_/C _1265_/D vccd vssd sg13cmos5l_and4_1
XFILLER_42_2198 vccd vssd sg13cmos5l_decap_8
XFILLER_4_2660 vccd vssd sg13cmos5l_decap_8
XFILLER_7_1071 vccd vssd sg13cmos5l_decap_8
XFILLER_37_621 vccd vssd sg13cmos5l_decap_8
XFILLER_0_2513 vccd vssd sg13cmos5l_decap_8
X_1196_ _1198_/C _1752_/Q _1155_/B _1195_/Y _1194_/Y _1284_/B1 vccd vssd sg13cmos5l_a221oi_1
XFILLER_20_2485 vccd vssd sg13cmos5l_decap_8
XFILLER_4_1981 vccd vssd sg13cmos5l_decap_8
XFILLER_37_698 vccd vssd sg13cmos5l_decap_8
XFILLER_36_175 vccd vssd sg13cmos5l_decap_8
XFILLER_24_315 vccd vssd sg13cmos5l_decap_8
XFILLER_20_1773 vccd vssd sg13cmos5l_decap_8
XFILLER_0_1834 vccd vssd sg13cmos5l_decap_8
Xoutbuffers\[10\] control[10] _1678_/Q vccd vssd sg13cmos5l_buf_8
XFILLER_36_1235 vccd vssd sg13cmos5l_decap_8
XFILLER_14_2201 vccd vssd sg13cmos5l_decap_8
XFILLER_32_392 vccd vssd sg13cmos5l_decap_8
XFILLER_20_532 vccd vssd sg13cmos5l_decap_8
XFILLER_18_2392 vccd vssd sg13cmos5l_decap_8
XFILLER_18_1680 vccd vssd sg13cmos5l_decap_8
XFILLER_14_1533 vccd vssd sg13cmos5l_decap_8
XFILLER_14_2278 vccd vssd sg13cmos5l_decap_8
XFILLER_31_2570 vccd vssd sg13cmos5l_decap_8
XFILLER_10_35 vccd vssd sg13cmos5l_decap_8
XFILLER_0_959 vccd vssd sg13cmos5l_decap_8
XFILLER_5_1701 vccd vssd sg13cmos5l_decap_8
XFILLER_5_2457 vccd vssd sg13cmos5l_decap_8
XFILLER_21_1515 vccd vssd sg13cmos5l_decap_8
XFILLER_19_77 vccd vssd sg13cmos5l_decap_8
XFILLER_28_665 vccd vssd sg13cmos5l_decap_8
XFILLER_16_805 vccd vssd sg13cmos5l_decap_8
XFILLER_3_2170 vccd vssd sg13cmos5l_decap_8
XFILLER_5_1778 vccd vssd sg13cmos5l_decap_8
XFILLER_42_112 vccd vssd sg13cmos5l_decap_8
XFILLER_38_2735 vccd vssd sg13cmos5l_decap_8
XFILLER_35_21 vccd vssd sg13cmos5l_decap_8
XFILLER_27_175 vccd vssd sg13cmos5l_decap_8
XFILLER_19_2101 vccd vssd sg13cmos5l_decap_4
XFILLER_3_1491 vccd vssd sg13cmos5l_decap_8
XFILLER_15_315 vccd vssd sg13cmos5l_decap_8
XFILLER_43_668 vccd vssd sg13cmos5l_decap_8
XFILLER_19_1400 vccd vssd sg13cmos5l_decap_8
XFILLER_36_2470 vccd vssd sg13cmos5l_decap_8
XFILLER_35_98 vccd vssd sg13cmos5l_decap_8
XFILLER_24_882 vccd vssd sg13cmos5l_decap_8
XFILLER_15_2009 vccd vssd sg13cmos5l_decap_8
XFILLER_32_2312 vccd vssd sg13cmos5l_decap_8
XFILLER_30_329 vccd vssd sg13cmos5l_decap_8
XFILLER_23_392 vccd vssd sg13cmos5l_decap_8
XFILLER_19_1477 vccd vssd sg13cmos5l_decap_8
XFILLER_11_532 vccd vssd sg13cmos5l_decap_8
XFILLER_32_1611 vccd vssd sg13cmos5l_decap_8
XFILLER_17_1190 vccd vssd sg13cmos5l_decap_8
XFILLER_7_525 vccd vssd sg13cmos5l_decap_8
XFILLER_13_1043 vccd vssd sg13cmos5l_decap_8
XFILLER_32_1699 vccd vssd sg13cmos5l_decap_8
XFILLER_10_1953 vccd vssd sg13cmos5l_decap_8
XFILLER_10_2698 vccd vssd sg13cmos5l_decap_8
XFILLER_26_2116 vccd vssd sg13cmos5l_decap_8
XFILLER_3_742 vccd vssd sg13cmos5l_decap_8
XFILLER_2_252 vccd vssd sg13cmos5l_decap_8
XFILLER_26_1426 vccd vssd sg13cmos5l_decap_8
XFILLER_43_1784 vccd vssd sg13cmos5l_decap_4
XFILLER_18_7 vccd vssd sg13cmos5l_decap_8
XFILLER_4_1211 vccd vssd sg13cmos5l_decap_8
X_1050_ _1050_/Y _1050_/A _1070_/C vccd vssd sg13cmos5l_nor2_1
XFILLER_21_2783 vccd vssd sg13cmos5l_decap_8
XFILLER_20_1036 vccd vssd sg13cmos5l_decap_8
XFILLER_19_665 vccd vssd sg13cmos5l_decap_8
XFILLER_37_2201 vccd vssd sg13cmos5l_decap_8
XFILLER_34_613 vccd vssd sg13cmos5l_decap_8
XFILLER_18_175 vccd vssd sg13cmos5l_decap_8
XFILLER_4_1288 vccd vssd sg13cmos5l_decap_8
XFILLER_33_112 vccd vssd sg13cmos5l_decap_8
XFILLER_22_819 vccd vssd sg13cmos5l_decap_8
XFILLER_15_882 vccd vssd sg13cmos5l_decap_8
Xoutbuffers\[100\] control[100] _1768_/Q vccd vssd sg13cmos5l_buf_8
XFILLER_33_189 vccd vssd sg13cmos5l_decap_8
XFILLER_21_329 vccd vssd sg13cmos5l_decap_8
XFILLER_14_392 vccd vssd sg13cmos5l_decap_8
X_0903_ _0903_/Y _1407_/A _0903_/B vccd vssd sg13cmos5l_nor2_1
XFILLER_15_1820 vccd vssd sg13cmos5l_decap_8
XFILLER_31_1110 vccd vssd sg13cmos5l_decap_8
X_0834_ _0899_/A _1394_/B vccd vssd sg13cmos5l_inv_1
XFILLER_15_1897 vccd vssd sg13cmos5l_decap_8
XFILLER_31_1187 vccd vssd sg13cmos5l_decap_8
XFILLER_44_0 vccd vssd sg13cmos5l_decap_8
XFILLER_44_1504 vccd vssd sg13cmos5l_decap_8
XFILLER_9_1155 vccd vssd sg13cmos5l_decap_8
Xoutbuffers\[58\] control[58] _1726_/Q vccd vssd sg13cmos5l_buf_8
XFILLER_22_2536 vccd vssd sg13cmos5l_decap_8
XFILLER_22_1802 vccd vssd sg13cmos5l_decap_8
XFILLER_5_1008 vccd vssd sg13cmos5l_decap_8
X_1317_ _1317_/Y status[49] _1362_/B1 _1317_/B1 vccd vssd sg13cmos5l_a21oi_1
XFILLER_26_1982 vccd vssd sg13cmos5l_decap_8
XFILLER_38_974 vccd vssd sg13cmos5l_decap_8
X_1248_ _1248_/Y _1695_/Q _1453_/B _1439_/B vccd vssd sg13cmos5l_a21oi_1
XFILLER_20_2271 vccd vssd sg13cmos5l_decap_8
XFILLER_2_1918 vccd vssd sg13cmos5l_decap_8
XFILLER_2_91 vccd vssd sg13cmos5l_decap_8
XFILLER_0_2310 vccd vssd sg13cmos5l_decap_8
XFILLER_0_1631 vccd vssd sg13cmos5l_decap_8
X_1179_ _1183_/D _1176_/Y _1177_/Y _1178_/X vccd vssd sg13cmos5l_a21o_2
XFILLER_25_668 vccd vssd sg13cmos5l_decap_8
XFILLER_24_112 vccd vssd sg13cmos5l_decap_8
XFILLER_20_1570 vccd vssd sg13cmos5l_decap_8
XFILLER_0_2387 vccd vssd sg13cmos5l_decap_8
XFILLER_40_605 vccd vssd sg13cmos5l_decap_8
XFILLER_13_819 vccd vssd sg13cmos5l_decap_8
XFILLER_33_2643 vccd vssd sg13cmos5l_decap_8
XFILLER_24_189 vccd vssd sg13cmos5l_decap_8
XFILLER_16_1617 vccd vssd sg13cmos5l_decap_8
XFILLER_12_329 vccd vssd sg13cmos5l_decap_8
X_1620__151 _1656_/CLK _1807_/CLK vccd vssd sg13cmos5l_inv_1
XFILLER_33_1953 vccd vssd sg13cmos5l_decap_8
XFILLER_21_896 vccd vssd sg13cmos5l_decap_8
XFILLER_14_1330 vccd vssd sg13cmos5l_decap_8
XFILLER_14_2086 vccd vssd sg13cmos5l_decap_8
XFILLER_21_56 vccd vssd sg13cmos5l_decap_8
XFILLER_4_539 vccd vssd sg13cmos5l_decap_8
XFILLER_27_2436 vccd vssd sg13cmos5l_decap_8
XFILLER_44_2772 vccd vssd sg13cmos5l_decap_8
XFILLER_40_2603 vccd vssd sg13cmos5l_decap_8
XFILLER_0_756 vccd vssd sg13cmos5l_decap_8
XFILLER_43_1025 vccd vssd sg13cmos5l_decap_4
XFILLER_25_2171 vccd vssd sg13cmos5l_decap_8
XFILLER_5_2254 vccd vssd sg13cmos5l_decap_8
XFILLER_1_2107 vccd vssd sg13cmos5l_decap_8
XFILLER_21_1323 vccd vssd sg13cmos5l_decap_8
XFILLER_5_1575 vccd vssd sg13cmos5l_decap_8
XFILLER_44_933 vccd vssd sg13cmos5l_decap_8
XFILLER_44_922 vccd vssd sg13cmos5l_decap_8
XFILLER_28_462 vccd vssd sg13cmos5l_decap_8
XFILLER_16_602 vccd vssd sg13cmos5l_decap_8
XFILLER_1_1428 vccd vssd sg13cmos5l_decap_8
XFILLER_44_944 vccd vssd sg13cmos5l_decap_8
XFILLER_38_2532 vccd vssd sg13cmos5l_decap_8
XFILLER_15_112 vccd vssd sg13cmos5l_decap_8
Xclkbuf_5_19_0_SCK _1685_/CLK clkbuf_3_4_0_SCK/X vccd vssd sg13cmos5l_buf_8
XFILLER_16_679 vccd vssd sg13cmos5l_decap_8
XFILLER_30_126 vccd vssd sg13cmos5l_decap_8
XFILLER_15_189 vccd vssd sg13cmos5l_decap_8
Xtiedowns\[94\] status[94] vccd vssd sg13cmos5l_antennanp
XFILLER_34_1739 vccd vssd sg13cmos5l_decap_8
XFILLER_19_1274 vccd vssd sg13cmos5l_decap_8
XFILLER_15_1127 vccd vssd sg13cmos5l_decap_8
XFILLER_8_812 vccd vssd sg13cmos5l_decap_8
XFILLER_7_14 vccd vssd sg13cmos5l_decap_8
XFILLER_7_322 vccd vssd sg13cmos5l_decap_8
XFILLER_12_896 vccd vssd sg13cmos5l_decap_8
XFILLER_32_1463 vccd vssd sg13cmos5l_decap_8
XFILLER_8_889 vccd vssd sg13cmos5l_decap_8
XFILLER_7_399 vccd vssd sg13cmos5l_decap_8
XFILLER_10_2473 vccd vssd sg13cmos5l_decap_8
XFILLER_10_1750 vccd vssd sg13cmos5l_decap_8
XFILLER_45_1813 vccd vssd sg13cmos5l_decap_8
XFILLER_45_2569 vccd vssd sg13cmos5l_decap_8
XFILLER_39_716 vccd vssd sg13cmos5l_decap_4
XFILLER_39_2307 vccd vssd sg13cmos5l_decap_8
XFILLER_38_259 vccd vssd sg13cmos5l_decap_8
X_1102_ _1102_/Y _1794_/Q _1197_/B _1102_/C vccd vssd sg13cmos5l_nor3_1
XFILLER_39_2318 vccd vssd sg13cmos5l_decap_8
X_1033_ _1033_/Y _1197_/B _1197_/C vccd vssd sg13cmos5l_nor2_1
XFILLER_21_2580 vccd vssd sg13cmos5l_decap_8
XFILLER_19_462 vccd vssd sg13cmos5l_decap_8
XFILLER_1_2674 vccd vssd sg13cmos5l_decap_8
XFILLER_4_1085 vccd vssd sg13cmos5l_decap_8
XFILLER_21_1890 vccd vssd sg13cmos5l_decap_8
XFILLER_35_977 vccd vssd sg13cmos5l_decap_8
XFILLER_22_616 vccd vssd sg13cmos5l_decap_8
XFILLER_17_2616 vccd vssd sg13cmos5l_decap_4
XFILLER_1_1995 vccd vssd sg13cmos5l_decap_8
XFILLER_37_2075 vccd vssd sg13cmos5l_decap_8
XFILLER_21_126 vccd vssd sg13cmos5l_decap_8
XFILLER_37_1385 vccd vssd sg13cmos5l_decap_8
XFILLER_33_1205 vccd vssd sg13cmos5l_decap_8
XFILLER_15_2395 vccd vssd sg13cmos5l_decap_8
XFILLER_30_693 vccd vssd sg13cmos5l_decap_8
X_1797_ _1797_/Q _1798_/CLK _1797_/D _1632_/Y vccd vssd sg13cmos5l_dfrbpq_1
XFILLER_15_1694 vccd vssd sg13cmos5l_decap_8
XFILLER_11_1547 vccd vssd sg13cmos5l_decap_8
XFILLER_28_2756 vccd vssd sg13cmos5l_decap_8
XFILLER_44_1301 vccd vssd sg13cmos5l_decap_8
XFILLER_44_2068 vccd vssd sg13cmos5l_decap_8
XFILLER_22_2322 vccd vssd sg13cmos5l_decap_8
XFILLER_6_2541 vccd vssd sg13cmos5l_decap_8
XFILLER_44_1378 vccd vssd sg13cmos5l_decap_8
XFILLER_40_1209 vccd vssd sg13cmos5l_decap_8
XFILLER_29_259 vccd vssd sg13cmos5l_decap_8
XFILLER_2_1715 vccd vssd sg13cmos5l_decap_8
XFILLER_6_1862 vccd vssd sg13cmos5l_decap_8
XFILLER_38_793 vccd vssd sg13cmos5l_decap_8
XFILLER_22_1676 vccd vssd sg13cmos5l_decap_8
XFILLER_0_2184 vccd vssd sg13cmos5l_decap_8
XFILLER_26_999 vccd vssd sg13cmos5l_decap_8
XFILLER_25_476 vccd vssd sg13cmos5l_decap_8
XFILLER_16_56 vccd vssd sg13cmos5l_decap_8
XFILLER_13_616 vccd vssd sg13cmos5l_decap_8
XFILLER_41_936 vccd vssd sg13cmos5l_decap_8
XFILLER_40_413 vccd vssd sg13cmos5l_decap_8
XFILLER_35_2749 vccd vssd sg13cmos5l_decap_8
XFILLER_16_2137 vccd vssd sg13cmos5l_decap_4
XFILLER_12_126 vccd vssd sg13cmos5l_decap_8
XFILLER_16_1414 vccd vssd sg13cmos5l_decap_8
XFILLER_9_609 vccd vssd sg13cmos5l_decap_8
XFILLER_33_2462 vccd vssd sg13cmos5l_decap_8
XFILLER_8_119 vccd vssd sg13cmos5l_decap_8
XFILLER_32_77 vccd vssd sg13cmos5l_decap_8
XFILLER_21_693 vccd vssd sg13cmos5l_decap_8
XFILLER_5_826 vccd vssd sg13cmos5l_decap_8
XFILLER_29_1808 vccd vssd sg13cmos5l_decap_8
XFILLER_4_336 vccd vssd sg13cmos5l_decap_8
XFILLER_10_1057 vccd vssd sg13cmos5l_decap_8
XFILLER_27_2244 vccd vssd sg13cmos5l_decap_8
XFILLER_27_1532 vccd vssd sg13cmos5l_decap_8
XFILLER_7_2338 vccd vssd sg13cmos5l_decap_8
XFILLER_0_553 vccd vssd sg13cmos5l_decap_8
XFILLER_40_2422 vccd vssd sg13cmos5l_decap_8
XFILLER_27_1598 vccd vssd sg13cmos5l_decap_8
XFILLER_5_2051 vccd vssd sg13cmos5l_decap_8
XFILLER_7_1659 vccd vssd sg13cmos5l_decap_8
XFILLER_40_2477 vccd vssd sg13cmos5l_decap_8
XFILLER_40_1732 vccd vssd sg13cmos5l_decap_8
XFILLER_21_1120 vccd vssd sg13cmos5l_decap_8
Xclkbuf_5_2_0_SCK clkload1/A clkbuf_5_3_0_SCK/A vccd vssd sg13cmos5l_buf_8
XFILLER_1_1225 vccd vssd sg13cmos5l_decap_8
XFILLER_5_1372 vccd vssd sg13cmos5l_decap_8
XFILLER_21_1197 vccd vssd sg13cmos5l_decap_8
XFILLER_17_966 vccd vssd sg13cmos5l_decap_8
XFILLER_44_763 vccd vssd sg13cmos5l_decap_8
XFILLER_32_925 vccd vssd sg13cmos5l_decap_8
XFILLER_16_476 vccd vssd sg13cmos5l_decap_8
XFILLER_38_1650 vccd vssd sg13cmos5l_decap_8
XFILLER_31_413 vccd vssd sg13cmos5l_decap_8
XFILLER_19_1071 vccd vssd sg13cmos5l_decap_8
XFILLER_34_1569 vccd vssd sg13cmos5l_decap_8
X_1720_ _1720_/Q clkload0/A _1720_/D fanout128/X vccd vssd sg13cmos5l_dfrbpq_1
XFILLER_12_693 vccd vssd sg13cmos5l_decap_8
XFILLER_12_2535 vccd vssd sg13cmos5l_decap_8
X_1651_ _1651_/Q _1652_/CLK _1651_/D _1616_/Y vccd vssd sg13cmos5l_dfrbpq_1
XFILLER_8_686 vccd vssd sg13cmos5l_decap_8
XFILLER_12_1834 vccd vssd sg13cmos5l_decap_8
XFILLER_12_2579 vccd vssd sg13cmos5l_decap_4
XFILLER_32_1293 vccd vssd sg13cmos5l_decap_8
XFILLER_28_2008 vccd vssd sg13cmos5l_decap_8
XFILLER_7_196 vccd vssd sg13cmos5l_decap_8
X_1582_ _1582_/X _1560_/A hold417/X _1587_/S vccd vssd sg13cmos5l_mux2_1
XFILLER_45_2366 vccd vssd sg13cmos5l_decap_8
XFILLER_45_1610 vccd vssd sg13cmos5l_decap_8
XFILLER_23_2620 vccd vssd sg13cmos5l_decap_8
XFILLER_45_1687 vccd vssd sg13cmos5l_decap_8
XFILLER_26_1075 vccd vssd sg13cmos5l_decap_8
XFILLER_23_2697 vccd vssd sg13cmos5l_decap_8
XFILLER_23_1941 vccd vssd sg13cmos5l_decap_8
XFILLER_3_2758 vccd vssd sg13cmos5l_decap_8
XFILLER_6_1169 vccd vssd sg13cmos5l_decap_8
XFILLER_39_2148 vccd vssd sg13cmos5l_decap_8
XFILLER_23_1996 vccd vssd sg13cmos5l_decap_8
XFILLER_1_2471 vccd vssd sg13cmos5l_decap_8
X_1016_ _1016_/Y _0877_/Y _1232_/B _1147_/B vccd vssd sg13cmos5l_a21oi_1
XFILLER_23_903 vccd vssd sg13cmos5l_decap_8
XFILLER_17_2413 vccd vssd sg13cmos5l_decap_8
XFILLER_34_273 vccd vssd sg13cmos5l_decap_8
XFILLER_22_413 vccd vssd sg13cmos5l_decap_8
XFILLER_17_1701 vccd vssd sg13cmos5l_decap_8
XFILLER_1_1792 vccd vssd sg13cmos5l_decap_8
XFILLER_33_1024 vccd vssd sg13cmos5l_decap_8
XFILLER_30_2624 vccd vssd sg13cmos5l_decap_8
XFILLER_17_1778 vccd vssd sg13cmos5l_decap_8
XFILLER_11_2023 vccd vssd sg13cmos5l_decap_8
XFILLER_15_1491 vccd vssd sg13cmos5l_decap_8
XFILLER_11_1344 vccd vssd sg13cmos5l_decap_8
XFILLER_28_2520 vccd vssd sg13cmos5l_decap_8
XFILLER_8_2669 vccd vssd sg13cmos5l_decap_8
XFILLER_28_1896 vccd vssd sg13cmos5l_decap_8
XFILLER_8_1946 vccd vssd sg13cmos5l_decap_8
XFILLER_44_1175 vccd vssd sg13cmos5l_decap_8
XFILLER_41_2775 vccd vssd sg13cmos5l_decap_8
XFILLER_40_1017 vccd vssd sg13cmos5l_decap_8
XFILLER_22_2141 vccd vssd sg13cmos5l_decap_8
XFILLER_22_2174 vccd vssd sg13cmos5l_decap_8
XFILLER_2_2268 vccd vssd sg13cmos5l_decap_8
XFILLER_2_1512 vccd vssd sg13cmos5l_decap_8
XFILLER_27_77 vccd vssd sg13cmos5l_decap_8
XFILLER_2_1589 vccd vssd sg13cmos5l_decap_8
XFILLER_14_903 vccd vssd sg13cmos5l_decap_8
XFILLER_43_21 vccd vssd sg13cmos5l_decap_8
XFILLER_41_733 vccd vssd sg13cmos5l_decap_8
XFILLER_39_2682 vccd vssd sg13cmos5l_decap_8
XFILLER_40_210 vccd vssd sg13cmos5l_decap_8
XFILLER_25_273 vccd vssd sg13cmos5l_decap_8
XFILLER_13_413 vccd vssd sg13cmos5l_decap_8
XFILLER_39_1992 vccd vssd sg13cmos5l_decap_8
XFILLER_35_2546 vccd vssd sg13cmos5l_decap_8
XFILLER_16_1211 vccd vssd sg13cmos5l_decap_8
XFILLER_9_406 vccd vssd sg13cmos5l_decap_8
XFILLER_43_98 vccd vssd sg13cmos5l_decap_8
XFILLER_40_287 vccd vssd sg13cmos5l_decap_8
XFILLER_22_980 vccd vssd sg13cmos5l_decap_8
XFILLER_21_490 vccd vssd sg13cmos5l_decap_8
XFILLER_16_1288 vccd vssd sg13cmos5l_decap_8
XFILLER_5_623 vccd vssd sg13cmos5l_decap_8
XFILLER_29_2317 vccd vssd sg13cmos5l_decap_8
XFILLER_4_133 vccd vssd sg13cmos5l_decap_8
Xtiedowns\[57\] status[57] vccd vssd sg13cmos5l_antennanp
XFILLER_42_2528 vccd vssd sg13cmos5l_decap_8
XFILLER_27_2052 vccd vssd sg13cmos5l_decap_8
XFILLER_1_840 vccd vssd sg13cmos5l_decap_8
XFILLER_7_2135 vccd vssd sg13cmos5l_decap_8
XFILLER_42_1816 vccd vssd sg13cmos5l_decap_8
XFILLER_0_350 vccd vssd sg13cmos5l_decap_8
XFILLER_3_1309 vccd vssd sg13cmos5l_decap_8
XFILLER_7_1456 vccd vssd sg13cmos5l_decap_8
XFILLER_40_2296 vccd vssd sg13cmos5l_decap_8
XFILLER_36_527 vccd vssd sg13cmos5l_decap_8
XFILLER_1_1022 vccd vssd sg13cmos5l_decap_8
XFILLER_32_700 vccd vssd sg13cmos5l_decap_8
XFILLER_17_763 vccd vssd sg13cmos5l_decap_8
XFILLER_44_571 vccd vssd sg13cmos5l_decap_8
XFILLER_31_210 vccd vssd sg13cmos5l_decap_8
XFILLER_18_2722 vccd vssd sg13cmos5l_decap_8
XFILLER_16_273 vccd vssd sg13cmos5l_decap_8
XFILLER_1_1099 vccd vssd sg13cmos5l_decap_8
XFILLER_20_917 vccd vssd sg13cmos5l_decap_8
XFILLER_17_1008 vccd vssd sg13cmos5l_decap_8
XFILLER_38_1491 vccd vssd sg13cmos5l_decap_8
XFILLER_13_980 vccd vssd sg13cmos5l_decap_8
XFILLER_31_287 vccd vssd sg13cmos5l_decap_8
XFILLER_12_490 vccd vssd sg13cmos5l_decap_8
XFILLER_12_2321 vccd vssd sg13cmos5l_decap_8
XFILLER_14_1918 vccd vssd sg13cmos5l_decap_8
X_1703_ _1703_/Q _1707_/CLK _1703_/D fanout130/X vccd vssd sg13cmos5l_dfrbpq_1
XFILLER_9_973 vccd vssd sg13cmos5l_decap_8
XFILLER_12_1631 vccd vssd sg13cmos5l_decap_8
XFILLER_8_483 vccd vssd sg13cmos5l_decap_8
XFILLER_12_2398 vccd vssd sg13cmos5l_decap_4
X_1634_ _1634_/Y _1641_/A _1635_/B_N vccd vssd sg13cmos5l_nor2b_1
X_1565_ _1565_/X _1595_/A0 hold373/X _1567_/S vccd vssd sg13cmos5l_mux2_1
XFILLER_28_1126 vccd vssd sg13cmos5l_decap_8
XFILLER_45_2163 vccd vssd sg13cmos5l_decap_8
XFILLER_41_2027 vccd vssd sg13cmos5l_decap_8
XFILLER_41_1304 vccd vssd sg13cmos5l_decap_8
X_1496_ _1496_/Y hold272/X _1495_/B _1495_/Y vccd vssd sg13cmos5l_a21oi_1
XFILLER_45_1484 vccd vssd sg13cmos5l_decap_8
Xoutbuffers\[40\] control[40] _1708_/Q vccd vssd sg13cmos5l_buf_8
XFILLER_39_343 vccd vssd sg13cmos5l_decap_8
XFILLER_23_2494 vccd vssd sg13cmos5l_decap_8
XFILLER_3_2555 vccd vssd sg13cmos5l_decap_8
XFILLER_39_1222 vccd vssd sg13cmos5l_decap_8
XFILLER_23_700 vccd vssd sg13cmos5l_decap_8
XFILLER_3_1876 vccd vssd sg13cmos5l_decap_8
XFILLER_22_210 vccd vssd sg13cmos5l_decap_8
Xfanout36 _1198_/A _1037_/Y vccd vssd sg13cmos5l_buf_1
Xfanout25 _1429_/B _1052_/Y vccd vssd sg13cmos5l_buf_1
Xfanout47 _1279_/B _1578_/B vccd vssd sg13cmos5l_buf_1
Xfanout14 _1461_/S _1462_/S vccd vssd sg13cmos5l_buf_1
Xfanout58 _1361_/B _1001_/Y vccd vssd sg13cmos5l_buf_1
XFILLER_39_1299 vccd vssd sg13cmos5l_decap_8
Xfanout69 _1070_/C _1042_/Y vccd vssd sg13cmos5l_buf_1
XFILLER_23_777 vccd vssd sg13cmos5l_decap_8
XFILLER_11_917 vccd vssd sg13cmos5l_decap_8
XFILLER_13_2107 vccd vssd sg13cmos5l_decap_8
XFILLER_22_287 vccd vssd sg13cmos5l_decap_8
XFILLER_17_1575 vccd vssd sg13cmos5l_decap_8
XFILLER_10_427 vccd vssd sg13cmos5l_decap_8
XFILLER_13_35 vccd vssd sg13cmos5l_decap_8
XFILLER_13_1428 vccd vssd sg13cmos5l_decap_8
XFILLER_30_2476 vccd vssd sg13cmos5l_decap_8
XFILLER_11_1141 vccd vssd sg13cmos5l_decap_8
XFILLER_28_2350 vccd vssd sg13cmos5l_decap_8
Xhold472 hold472/X _1752_/Q vccd vssd sg13cmos5l_dlygate4sd3_1
Xhold461 _1742_/D _1524_/X vccd vssd sg13cmos5l_dlygate4sd3_1
Xhold450 _1798_/D _0939_/Y vccd vssd sg13cmos5l_dlygate4sd3_1
XFILLER_2_637 vccd vssd sg13cmos5l_decap_8
XFILLER_8_2422 vccd vssd sg13cmos5l_decap_8
Xhold494 hold494/X _1775_/Q vccd vssd sg13cmos5l_dlygate4sd3_1
Xhold483 _1665_/D _1418_/Y vccd vssd sg13cmos5l_dlygate4sd3_1
XFILLER_1_147 vccd vssd sg13cmos5l_decap_8
XFILLER_38_21 vccd vssd sg13cmos5l_decap_8
XFILLER_8_1743 vccd vssd sg13cmos5l_decap_8
XFILLER_28_1693 vccd vssd sg13cmos5l_decap_8
XFILLER_8_2499 vccd vssd sg13cmos5l_decap_8
XFILLER_41_2572 vccd vssd sg13cmos5l_decap_8
XFILLER_38_98 vccd vssd sg13cmos5l_decap_8
XFILLER_2_2065 vccd vssd sg13cmos5l_decap_8
XFILLER_45_357 vccd vssd sg13cmos5l_decap_8
XFILLER_37_1918 vccd vssd sg13cmos5l_decap_8
XFILLER_26_560 vccd vssd sg13cmos5l_decap_4
XFILLER_2_1386 vccd vssd sg13cmos5l_decap_8
XFILLER_14_700 vccd vssd sg13cmos5l_decap_8
XFILLER_13_210 vccd vssd sg13cmos5l_decap_8
XFILLER_9_203 vccd vssd sg13cmos5l_decap_8
XFILLER_14_777 vccd vssd sg13cmos5l_decap_8
XFILLER_13_287 vccd vssd sg13cmos5l_decap_8
Xclkload17 clkload17/Y _1699_/CLK vccd vssd sg13cmos5l_inv_1
XFILLER_16_1085 vccd vssd sg13cmos5l_decap_8
XFILLER_6_910 vccd vssd sg13cmos5l_decap_8
XFILLER_13_2674 vccd vssd sg13cmos5l_decap_8
XFILLER_5_420 vccd vssd sg13cmos5l_decap_8
XFILLER_10_994 vccd vssd sg13cmos5l_decap_8
XFILLER_6_987 vccd vssd sg13cmos5l_decap_8
XFILLER_13_1995 vccd vssd sg13cmos5l_decap_8
XFILLER_5_497 vccd vssd sg13cmos5l_decap_8
XFILLER_9_2219 vccd vssd sg13cmos5l_decap_8
X_1350_ _1351_/B mask_rev_in[25] _1350_/B vccd vssd sg13cmos5l_nand2_1
XFILLER_42_2325 vccd vssd sg13cmos5l_decap_8
XFILLER_42_2358 vccd vssd sg13cmos5l_decap_8
X_1281_ _1281_/Y _1774_/Q _1151_/B _1152_/B vccd vssd sg13cmos5l_a21oi_1
XFILLER_23_1001 vccd vssd sg13cmos5l_decap_8
XFILLER_7_1253 vccd vssd sg13cmos5l_decap_8
XFILLER_40_2060 vccd vssd sg13cmos5l_decap_8
XFILLER_37_803 vccd vssd sg13cmos5l_decap_8
XFILLER_23_1056 vccd vssd sg13cmos5l_decap_8
XFILLER_3_1106 vccd vssd sg13cmos5l_decap_8
XFILLER_20_2667 vccd vssd sg13cmos5l_decap_8
XFILLER_40_1381 vccd vssd sg13cmos5l_decap_8
XFILLER_36_357 vccd vssd sg13cmos5l_decap_8
XFILLER_20_1966 vccd vssd sg13cmos5l_decap_8
XFILLER_17_560 vccd vssd sg13cmos5l_decap_8
XFILLER_32_574 vccd vssd sg13cmos5l_decap_8
XFILLER_20_714 vccd vssd sg13cmos5l_decap_8
XFILLER_34_1152 vccd vssd sg13cmos5l_decap_8
XFILLER_14_1715 vccd vssd sg13cmos5l_decap_8
X_0996_ _0996_/Y _1137_/B _1036_/B vccd vssd sg13cmos5l_nor2b_1
XFILLER_31_2752 vccd vssd sg13cmos5l_decap_8
XFILLER_9_770 vccd vssd sg13cmos5l_decap_8
XFILLER_8_280 vccd vssd sg13cmos5l_decap_8
Xoutbuffers\[88\] control[88] _1756_/Q vccd vssd sg13cmos5l_buf_8
X_1617_ _1617_/Y _1617_/A _1617_/B_N vccd vssd sg13cmos5l_nor2b_1
XFILLER_29_2692 vccd vssd sg13cmos5l_decap_8
XFILLER_5_91 vccd vssd sg13cmos5l_decap_8
X_1548_ _1548_/Y hold287/X _1549_/S _1547_/Y vccd vssd sg13cmos5l_a21oi_1
XFILLER_25_2545 vccd vssd sg13cmos5l_decap_8
XFILLER_25_1811 vccd vssd sg13cmos5l_decap_8
XFILLER_45_1281 vccd vssd sg13cmos5l_decap_8
X_1479_ _1479_/Y hold259/X _1485_/S _1478_/Y vccd vssd sg13cmos5l_a21oi_1
XFILLER_39_140 vccd vssd sg13cmos5l_decap_8
XFILLER_25_1877 vccd vssd sg13cmos5l_decap_8
XFILLER_3_2352 vccd vssd sg13cmos5l_decap_8
XFILLER_41_1178 vccd vssd sg13cmos5l_decap_8
XFILLER_28_836 vccd vssd sg13cmos5l_decap_8
XFILLER_27_357 vccd vssd sg13cmos5l_decap_8
XFILLER_23_1590 vccd vssd sg13cmos5l_decap_8
XFILLER_3_1673 vccd vssd sg13cmos5l_decap_8
XFILLER_42_327 vccd vssd sg13cmos5l_decap_8
XFILLER_19_2338 vccd vssd sg13cmos5l_decap_8
XFILLER_39_1063 vccd vssd sg13cmos5l_decap_8
XFILLER_36_2630 vccd vssd sg13cmos5l_decap_8
XFILLER_24_56 vccd vssd sg13cmos5l_decap_8
XFILLER_23_574 vccd vssd sg13cmos5l_decap_8
XFILLER_19_1659 vccd vssd sg13cmos5l_decap_8
XFILLER_11_714 vccd vssd sg13cmos5l_decap_8
XFILLER_36_1973 vccd vssd sg13cmos5l_decap_8
XFILLER_32_1804 vccd vssd sg13cmos5l_decap_8
XFILLER_17_2095 vccd vssd sg13cmos5l_decap_8
XFILLER_7_707 vccd vssd sg13cmos5l_decap_8
XFILLER_10_224 vccd vssd sg13cmos5l_decap_8
XFILLER_17_1372 vccd vssd sg13cmos5l_decap_8
XFILLER_6_217 vccd vssd sg13cmos5l_decap_8
XFILLER_13_1225 vccd vssd sg13cmos5l_decap_8
XFILLER_40_77 vccd vssd sg13cmos5l_decap_8
XFILLER_3_924 vccd vssd sg13cmos5l_decap_8
Xhold280 _1487_/A _1716_/Q vccd vssd sg13cmos5l_dlygate4sd3_1
XFILLER_2_434 vccd vssd sg13cmos5l_decap_8
XFILLER_43_2645 vccd vssd sg13cmos5l_decap_8
Xhold291 _1413_/A _1409_/X vccd vssd sg13cmos5l_dlygate4sd3_1
XFILLER_8_1540 vccd vssd sg13cmos5l_decap_8
XFILLER_8_2296 vccd vssd sg13cmos5l_decap_8
XFILLER_24_2099 vccd vssd sg13cmos5l_decap_8
XFILLER_4_2149 vccd vssd sg13cmos5l_decap_8
XFILLER_41_2380 vccd vssd sg13cmos5l_decap_4
XFILLER_24_1398 vccd vssd sg13cmos5l_decap_8
XFILLER_20_1218 vccd vssd sg13cmos5l_decap_8
XFILLER_19_847 vccd vssd sg13cmos5l_decap_8
XFILLER_1_49 vccd vssd sg13cmos5l_decap_8
XFILLER_45_154 vccd vssd sg13cmos5l_decap_8
XFILLER_18_357 vccd vssd sg13cmos5l_decap_8
XFILLER_2_1183 vccd vssd sg13cmos5l_decap_8
XFILLER_37_1759 vccd vssd sg13cmos5l_decap_8
XFILLER_35_2140 vccd vssd sg13cmos5l_decap_8
XFILLER_15_2725 vccd vssd sg13cmos5l_decap_4
XFILLER_14_574 vccd vssd sg13cmos5l_decap_8
XFILLER_41_393 vccd vssd sg13cmos5l_decap_8
XFILLER_18_1169 vccd vssd sg13cmos5l_decap_8
X_0850_ _0850_/Y mask_rev_in[18] vccd vssd sg13cmos5l_inv_1
XFILLER_31_1358 vccd vssd sg13cmos5l_decap_8
XFILLER_10_791 vccd vssd sg13cmos5l_decap_8
XFILLER_6_784 vccd vssd sg13cmos5l_decap_8
XFILLER_9_2016 vccd vssd sg13cmos5l_decap_8
XFILLER_13_1792 vccd vssd sg13cmos5l_decap_8
X_1402_ _1648_/D _1488_/A1 _1401_/B _1401_/Y vccd vssd sg13cmos5l_o21ai_1
XFILLER_5_294 vccd vssd sg13cmos5l_decap_8
XFILLER_9_1337 vccd vssd sg13cmos5l_decap_8
X_1333_ _1333_/Y _1749_/Q _1531_/B _1331_/Y _1330_/Y _1332_/X vccd vssd sg13cmos5l_a221oi_1
XFILLER_22_2718 vccd vssd sg13cmos5l_decap_8
X_1264_ _1265_/D status[122] wire74/X _1309_/B1 status[106] vccd vssd sg13cmos5l_a22oi_1
Xtiedowns\[120\] status[120] vccd vssd sg13cmos5l_antennanp
XFILLER_42_2166 vccd vssd sg13cmos5l_decap_8
XFILLER_37_600 vccd vssd sg13cmos5l_decap_8
XFILLER_7_1050 vccd vssd sg13cmos5l_decap_8
XFILLER_42_1465 vccd vssd sg13cmos5l_decap_8
XFILLER_42_1498 vccd vssd sg13cmos5l_decap_8
XFILLER_37_677 vccd vssd sg13cmos5l_decap_8
X_1195_ _1195_/Y _1760_/Q _1371_/B vccd vssd sg13cmos5l_nand2b_1
XFILLER_20_2464 vccd vssd sg13cmos5l_decap_8
XFILLER_0_1813 vccd vssd sg13cmos5l_decap_8
XFILLER_4_1960 vccd vssd sg13cmos5l_decap_8
XFILLER_36_154 vccd vssd sg13cmos5l_decap_8
XFILLER_20_1752 vccd vssd sg13cmos5l_decap_8
XFILLER_0_2569 vccd vssd sg13cmos5l_decap_8
XFILLER_33_850 vccd vssd sg13cmos5l_decap_8
XFILLER_36_1214 vccd vssd sg13cmos5l_decap_8
XFILLER_33_894 vccd vssd sg13cmos5l_decap_8
XFILLER_32_371 vccd vssd sg13cmos5l_decap_8
XFILLER_20_511 vccd vssd sg13cmos5l_decap_8
XFILLER_14_1512 vccd vssd sg13cmos5l_decap_8
X_0979_ _0979_/Y _0995_/B _0988_/B _0988_/C _1058_/B vccd vssd sg13cmos5l_nor4_2
XFILLER_20_588 vccd vssd sg13cmos5l_decap_8
XFILLER_14_1589 vccd vssd sg13cmos5l_decap_8
XFILLER_10_14 vccd vssd sg13cmos5l_decap_8
XFILLER_27_1939 vccd vssd sg13cmos5l_decap_8
XFILLER_0_938 vccd vssd sg13cmos5l_decap_8
XFILLER_5_2436 vccd vssd sg13cmos5l_decap_8
XFILLER_21_2239 vccd vssd sg13cmos5l_decap_4
XFILLER_19_56 vccd vssd sg13cmos5l_decap_8
XFILLER_5_1757 vccd vssd sg13cmos5l_decap_8
XFILLER_28_644 vccd vssd sg13cmos5l_decap_8
XFILLER_38_2714 vccd vssd sg13cmos5l_decap_8
XFILLER_27_154 vccd vssd sg13cmos5l_decap_8
XFILLER_3_1470 vccd vssd sg13cmos5l_decap_8
XFILLER_43_636 vccd vssd sg13cmos5l_decap_8
XFILLER_31_809 vccd vssd sg13cmos5l_decap_8
XFILLER_35_77 vccd vssd sg13cmos5l_decap_8
XFILLER_30_308 vccd vssd sg13cmos5l_decap_8
XFILLER_24_861 vccd vssd sg13cmos5l_decap_8
XFILLER_23_371 vccd vssd sg13cmos5l_decap_8
XFILLER_19_1456 vccd vssd sg13cmos5l_decap_8
XFILLER_15_1309 vccd vssd sg13cmos5l_decap_8
XFILLER_11_511 vccd vssd sg13cmos5l_decap_8
XFILLER_7_504 vccd vssd sg13cmos5l_decap_8
XFILLER_10_2600 vccd vssd sg13cmos5l_decap_4
XFILLER_11_588 vccd vssd sg13cmos5l_decap_8
XFILLER_13_1022 vccd vssd sg13cmos5l_decap_8
XFILLER_3_721 vccd vssd sg13cmos5l_decap_8
XFILLER_10_1932 vccd vssd sg13cmos5l_decap_8
XFILLER_10_2677 vccd vssd sg13cmos5l_decap_8
XFILLER_13_1099 vccd vssd sg13cmos5l_decap_8
XFILLER_30_1391 vccd vssd sg13cmos5l_decap_8
XFILLER_2_231 vccd vssd sg13cmos5l_decap_8
XFILLER_4_0 vccd vssd sg13cmos5l_decap_8
XFILLER_26_1405 vccd vssd sg13cmos5l_decap_8
XFILLER_3_798 vccd vssd sg13cmos5l_decap_8
XFILLER_39_909 vccd vssd sg13cmos5l_decap_8
XFILLER_8_2093 vccd vssd sg13cmos5l_decap_8
XFILLER_21_2762 vccd vssd sg13cmos5l_decap_8
XFILLER_20_1015 vccd vssd sg13cmos5l_decap_8
XFILLER_19_644 vccd vssd sg13cmos5l_decap_8
XFILLER_4_1267 vccd vssd sg13cmos5l_decap_8
XFILLER_18_154 vccd vssd sg13cmos5l_decap_8
XFILLER_37_2257 vccd vssd sg13cmos5l_decap_4
XFILLER_33_168 vccd vssd sg13cmos5l_decap_8
XFILLER_21_308 vccd vssd sg13cmos5l_decap_8
XFILLER_15_2500 vccd vssd sg13cmos5l_decap_8
XFILLER_15_861 vccd vssd sg13cmos5l_decap_8
XFILLER_42_691 vccd vssd sg13cmos5l_decap_8
XFILLER_14_371 vccd vssd sg13cmos5l_decap_8
XFILLER_37_1589 vccd vssd sg13cmos5l_decap_8
X_0902_ _0902_/Y _0902_/A vccd vssd sg13cmos5l_inv_1
XFILLER_15_2555 vccd vssd sg13cmos5l_decap_8
XFILLER_35_1291 vccd vssd sg13cmos5l_decap_8
XFILLER_15_2599 vccd vssd sg13cmos5l_decap_8
XFILLER_15_1876 vccd vssd sg13cmos5l_decap_8
X_0833_ _0833_/Y _0900_/A vccd vssd sg13cmos5l_inv_1
XFILLER_31_1166 vccd vssd sg13cmos5l_decap_8
XFILLER_11_1729 vccd vssd sg13cmos5l_decap_8
XFILLER_13_2290 vccd vssd sg13cmos5l_decap_8
XFILLER_31_1199 vccd vssd sg13cmos5l_decap_8
XFILLER_6_581 vccd vssd sg13cmos5l_decap_8
XFILLER_37_0 vccd vssd sg13cmos5l_decap_8
XFILLER_9_1134 vccd vssd sg13cmos5l_decap_8
X_1316_ _1316_/Y status[57] _1360_/B1 vccd vssd sg13cmos5l_nor2b_1
XFILLER_29_1095 vccd vssd sg13cmos5l_decap_8
XFILLER_26_2684 vccd vssd sg13cmos5l_decap_8
XFILLER_26_1961 vccd vssd sg13cmos5l_decap_8
XFILLER_22_2515 vccd vssd sg13cmos5l_decap_8
XFILLER_2_70 vccd vssd sg13cmos5l_decap_8
XFILLER_42_1284 vccd vssd sg13cmos5l_decap_8
XFILLER_38_953 vccd vssd sg13cmos5l_decap_8
XFILLER_37_441 vccd vssd sg13cmos5l_decap_8
X_1247_ _1247_/Y _1711_/Q _1474_/B _1162_/B _1703_/Q _1246_/Y vccd vssd sg13cmos5l_a221oi_1
X_1178_ _1178_/X _1357_/C1 _0861_/Y _1261_/B vccd vssd sg13cmos5l_a21o_1
XFILLER_0_2366 vccd vssd sg13cmos5l_decap_8
XFILLER_0_1610 vccd vssd sg13cmos5l_decap_8
XFILLER_37_496 vccd vssd sg13cmos5l_decap_8
XFILLER_25_647 vccd vssd sg13cmos5l_decap_8
XFILLER_24_168 vccd vssd sg13cmos5l_decap_8
XFILLER_0_1687 vccd vssd sg13cmos5l_decap_8
XFILLER_12_308 vccd vssd sg13cmos5l_decap_8
XFILLER_33_2622 vccd vssd sg13cmos5l_decap_8
XFILLER_36_1088 vccd vssd sg13cmos5l_decap_8
XFILLER_33_1932 vccd vssd sg13cmos5l_decap_8
XFILLER_21_875 vccd vssd sg13cmos5l_decap_8
XFILLER_33_2699 vccd vssd sg13cmos5l_decap_8
XFILLER_14_2065 vccd vssd sg13cmos5l_decap_8
XFILLER_21_35 vccd vssd sg13cmos5l_decap_8
XFILLER_20_385 vccd vssd sg13cmos5l_decap_8
XFILLER_4_518 vccd vssd sg13cmos5l_decap_8
XFILLER_10_1239 vccd vssd sg13cmos5l_decap_8
XFILLER_14_1386 vccd vssd sg13cmos5l_decap_8
XFILLER_27_2415 vccd vssd sg13cmos5l_decap_8
XFILLER_44_2751 vccd vssd sg13cmos5l_decap_8
XFILLER_0_735 vccd vssd sg13cmos5l_decap_8
XFILLER_9_2380 vccd vssd sg13cmos5l_decap_8
XFILLER_25_2150 vccd vssd sg13cmos5l_decap_8
XFILLER_5_2233 vccd vssd sg13cmos5l_decap_8
XFILLER_43_1059 vccd vssd sg13cmos5l_decap_4
XFILLER_40_2659 vccd vssd sg13cmos5l_decap_8
XFILLER_21_1302 vccd vssd sg13cmos5l_decap_8
XFILLER_29_953 vccd vssd sg13cmos5l_decap_4
XFILLER_28_441 vccd vssd sg13cmos5l_decap_8
XFILLER_1_1407 vccd vssd sg13cmos5l_decap_8
XFILLER_5_1554 vccd vssd sg13cmos5l_decap_8
XFILLER_44_901 vccd vssd sg13cmos5l_decap_8
XFILLER_40_1969 vccd vssd sg13cmos5l_decap_8
XFILLER_38_2511 vccd vssd sg13cmos5l_decap_8
XFILLER_21_1379 vccd vssd sg13cmos5l_decap_8
XFILLER_16_658 vccd vssd sg13cmos5l_decap_8
XFILLER_38_2588 vccd vssd sg13cmos5l_decap_8
XFILLER_31_606 vccd vssd sg13cmos5l_decap_8
XFILLER_15_168 vccd vssd sg13cmos5l_decap_8
XFILLER_34_1718 vccd vssd sg13cmos5l_decap_8
XFILLER_30_105 vccd vssd sg13cmos5l_decap_8
XFILLER_19_1253 vccd vssd sg13cmos5l_decap_8
XFILLER_38_1887 vccd vssd sg13cmos5l_decap_8
XFILLER_15_1106 vccd vssd sg13cmos5l_decap_8
Xtiedowns\[87\] status[87] vccd vssd sg13cmos5l_antennanp
XFILLER_7_301 vccd vssd sg13cmos5l_decap_8
XFILLER_12_875 vccd vssd sg13cmos5l_decap_8
XFILLER_32_2187 vccd vssd sg13cmos5l_decap_8
XFILLER_32_1442 vccd vssd sg13cmos5l_decap_8
XFILLER_8_868 vccd vssd sg13cmos5l_decap_8
XFILLER_11_385 vccd vssd sg13cmos5l_decap_8
XFILLER_7_378 vccd vssd sg13cmos5l_decap_8
XFILLER_10_2452 vccd vssd sg13cmos5l_decap_8
XFILLER_45_2548 vccd vssd sg13cmos5l_decap_8
XFILLER_30_7 vccd vssd sg13cmos5l_decap_8
XFILLER_3_595 vccd vssd sg13cmos5l_decap_8
XFILLER_45_1869 vccd vssd sg13cmos5l_decap_8
XFILLER_26_1257 vccd vssd sg13cmos5l_decap_8
X_1101_ _1101_/Y _1085_/Y _1100_/Y _1588_/B vccd vssd sg13cmos5l_a21oi_1
XFILLER_38_238 vccd vssd sg13cmos5l_decap_8
XFILLER_19_441 vccd vssd sg13cmos5l_decap_8
X_1032_ _1032_/Y _1763_/Q _1371_/B _1155_/B vccd vssd sg13cmos5l_a21oi_1
XFILLER_35_912 vccd vssd sg13cmos5l_decap_8
XFILLER_1_2653 vccd vssd sg13cmos5l_decap_8
XFILLER_4_1064 vccd vssd sg13cmos5l_decap_8
XFILLER_34_433 vccd vssd sg13cmos5l_decap_8
XFILLER_37_2054 vccd vssd sg13cmos5l_decap_8
XFILLER_1_1974 vccd vssd sg13cmos5l_decap_8
XFILLER_34_488 vccd vssd sg13cmos5l_decap_4
XFILLER_21_105 vccd vssd sg13cmos5l_decap_8
XFILLER_15_2374 vccd vssd sg13cmos5l_decap_8
XFILLER_15_1673 vccd vssd sg13cmos5l_decap_8
XFILLER_11_2249 vccd vssd sg13cmos5l_decap_8
X_1796_ reset _1804_/CLK _1796_/D _1639_/B_N vccd vssd sg13cmos5l_dfrbpq_1
XFILLER_11_1526 vccd vssd sg13cmos5l_decap_8
Xoutbuffers\[70\] control[70] _1738_/Q vccd vssd sg13cmos5l_buf_8
XFILLER_28_2735 vccd vssd sg13cmos5l_decap_8
XFILLER_44_2047 vccd vssd sg13cmos5l_decap_8
XFILLER_22_2301 vccd vssd sg13cmos5l_decap_8
XFILLER_6_2520 vccd vssd sg13cmos5l_decap_8
XFILLER_44_1357 vccd vssd sg13cmos5l_decap_8
XFILLER_6_1841 vccd vssd sg13cmos5l_decap_8
XFILLER_29_238 vccd vssd sg13cmos5l_decap_8
XFILLER_22_2389 vccd vssd sg13cmos5l_decap_8
XFILLER_42_1092 vccd vssd sg13cmos5l_decap_4
XFILLER_22_1655 vccd vssd sg13cmos5l_decap_8
XFILLER_26_945 vccd vssd sg13cmos5l_decap_8
XFILLER_16_35 vccd vssd sg13cmos5l_decap_8
XFILLER_0_2163 vccd vssd sg13cmos5l_decap_8
XFILLER_41_915 vccd vssd sg13cmos5l_decap_8
XFILLER_35_2728 vccd vssd sg13cmos5l_decap_8
XFILLER_25_455 vccd vssd sg13cmos5l_decap_8
XFILLER_0_1484 vccd vssd sg13cmos5l_decap_8
XFILLER_12_105 vccd vssd sg13cmos5l_decap_8
XFILLER_40_469 vccd vssd sg13cmos5l_decap_8
XFILLER_33_1740 vccd vssd sg13cmos5l_decap_4
XFILLER_32_56 vccd vssd sg13cmos5l_decap_8
XFILLER_21_672 vccd vssd sg13cmos5l_decap_8
XFILLER_20_182 vccd vssd sg13cmos5l_decap_8
XFILLER_5_805 vccd vssd sg13cmos5l_decap_8
XFILLER_4_315 vccd vssd sg13cmos5l_decap_8
XFILLER_14_1183 vccd vssd sg13cmos5l_decap_8
XFILLER_10_1036 vccd vssd sg13cmos5l_decap_8
XFILLER_11_2783 vccd vssd sg13cmos5l_decap_8
XFILLER_27_2223 vccd vssd sg13cmos5l_decap_8
XFILLER_27_1511 vccd vssd sg13cmos5l_decap_8
XFILLER_7_2317 vccd vssd sg13cmos5l_decap_8
XFILLER_40_2401 vccd vssd sg13cmos5l_decap_8
XFILLER_0_532 vccd vssd sg13cmos5l_decap_8
XFILLER_27_1577 vccd vssd sg13cmos5l_decap_8
XFILLER_5_2030 vccd vssd sg13cmos5l_decap_8
XFILLER_7_1638 vccd vssd sg13cmos5l_decap_8
XFILLER_44_1891 vccd vssd sg13cmos5l_decap_8
XFILLER_40_1711 vccd vssd sg13cmos5l_decap_8
XFILLER_36_709 vccd vssd sg13cmos5l_decap_8
XFILLER_5_1351 vccd vssd sg13cmos5l_decap_8
XFILLER_1_1204 vccd vssd sg13cmos5l_decap_8
XFILLER_40_1799 vccd vssd sg13cmos5l_decap_8
XFILLER_40_1788 vccd vssd sg13cmos5l_decap_8
XFILLER_21_1176 vccd vssd sg13cmos5l_decap_8
XFILLER_17_945 vccd vssd sg13cmos5l_decap_8
X_1627__158 _1663_/CLK _1631__159/A vccd vssd sg13cmos5l_inv_1
XFILLER_16_455 vccd vssd sg13cmos5l_decap_8
XFILLER_38_2396 vccd vssd sg13cmos5l_decap_8
XFILLER_34_2205 vccd vssd sg13cmos5l_decap_4
XFILLER_34_2249 vccd vssd sg13cmos5l_decap_8
XFILLER_19_1050 vccd vssd sg13cmos5l_decap_8
XFILLER_34_1537 vccd vssd sg13cmos5l_decap_4
XFILLER_12_672 vccd vssd sg13cmos5l_decap_8
XFILLER_12_2514 vccd vssd sg13cmos5l_decap_8
XFILLER_32_1250 vccd vssd sg13cmos5l_decap_4
XFILLER_8_665 vccd vssd sg13cmos5l_decap_8
XFILLER_11_182 vccd vssd sg13cmos5l_decap_8
XFILLER_12_1813 vccd vssd sg13cmos5l_decap_8
XFILLER_32_1261 vccd vssd sg13cmos5l_decap_4
X_1650_ _1650_/Q _1675_/CLK _1650_/D _1615_/Y vccd vssd sg13cmos5l_dfrbpq_1
XFILLER_16_1993 vccd vssd sg13cmos5l_decap_8
XFILLER_7_175 vccd vssd sg13cmos5l_decap_8
X_1581_ _1581_/X _1591_/A0 hold401/X _1587_/S vccd vssd sg13cmos5l_mux2_1
XFILLER_10_2282 vccd vssd sg13cmos5l_decap_8
XFILLER_45_2345 vccd vssd sg13cmos5l_decap_8
XFILLER_4_882 vccd vssd sg13cmos5l_decap_8
XFILLER_41_2209 vccd vssd sg13cmos5l_decap_8
XFILLER_3_392 vccd vssd sg13cmos5l_decap_8
XFILLER_45_1666 vccd vssd sg13cmos5l_decap_8
XFILLER_26_1054 vccd vssd sg13cmos5l_decap_8
XFILLER_39_536 vccd vssd sg13cmos5l_decap_8
XFILLER_23_2676 vccd vssd sg13cmos5l_decap_8
XFILLER_3_2737 vccd vssd sg13cmos5l_decap_8
XFILLER_6_1148 vccd vssd sg13cmos5l_decap_8
XFILLER_1_2450 vccd vssd sg13cmos5l_decap_8
XFILLER_39_1437 vccd vssd sg13cmos5l_decap_8
X_1015_ _1015_/Y _1197_/B _1052_/A vccd vssd sg13cmos5l_nor2_1
XFILLER_35_775 vccd vssd sg13cmos5l_decap_4
XFILLER_34_252 vccd vssd sg13cmos5l_decap_8
XFILLER_1_1771 vccd vssd sg13cmos5l_decap_8
XFILLER_23_959 vccd vssd sg13cmos5l_decap_8
XFILLER_17_2469 vccd vssd sg13cmos5l_decap_8
XFILLER_10_609 vccd vssd sg13cmos5l_decap_8
XFILLER_33_1003 vccd vssd sg13cmos5l_decap_4
XFILLER_30_2603 vccd vssd sg13cmos5l_decap_8
XFILLER_22_469 vccd vssd sg13cmos5l_decap_8
XFILLER_17_1757 vccd vssd sg13cmos5l_decap_8
XFILLER_30_480 vccd vssd sg13cmos5l_decap_8
XFILLER_15_2182 vccd vssd sg13cmos5l_decap_8
XFILLER_11_2002 vccd vssd sg13cmos5l_decap_8
XFILLER_15_1470 vccd vssd sg13cmos5l_decap_8
XFILLER_8_91 vccd vssd sg13cmos5l_decap_8
XFILLER_11_1323 vccd vssd sg13cmos5l_decap_8
XFILLER_11_2079 vccd vssd sg13cmos5l_decap_8
X_1779_ _1779_/Q _1779_/CLK _1779_/D fanout114/X vccd vssd sg13cmos5l_dfrbpq_1
XFILLER_2_819 vccd vssd sg13cmos5l_decap_8
XFILLER_8_2604 vccd vssd sg13cmos5l_decap_4
Xclkbuf_5_18_0_SCK _1682_/CLK clkbuf_3_4_0_SCK/X vccd vssd sg13cmos5l_buf_8
XFILLER_28_2576 vccd vssd sg13cmos5l_decap_8
XFILLER_1_329 vccd vssd sg13cmos5l_decap_8
XFILLER_8_1925 vccd vssd sg13cmos5l_decap_8
XFILLER_44_1154 vccd vssd sg13cmos5l_decap_8
XFILLER_28_1875 vccd vssd sg13cmos5l_decap_8
XFILLER_22_2120 vccd vssd sg13cmos5l_decap_8
XFILLER_41_2754 vccd vssd sg13cmos5l_decap_8
XFILLER_6_2394 vccd vssd sg13cmos5l_decap_8
XFILLER_2_2247 vccd vssd sg13cmos5l_decap_8
XFILLER_45_539 vccd vssd sg13cmos5l_decap_8
XFILLER_26_720 vccd vssd sg13cmos5l_decap_8
XFILLER_27_56 vccd vssd sg13cmos5l_decap_8
XFILLER_39_2661 vccd vssd sg13cmos5l_decap_8
XFILLER_2_1568 vccd vssd sg13cmos5l_decap_8
XFILLER_41_712 vccd vssd sg13cmos5l_decap_8
XFILLER_35_2525 vccd vssd sg13cmos5l_decap_8
XFILLER_25_252 vccd vssd sg13cmos5l_decap_8
XFILLER_0_1281 vccd vssd sg13cmos5l_decap_8
XFILLER_39_1971 vccd vssd sg13cmos5l_decap_8
XFILLER_14_959 vccd vssd sg13cmos5l_decap_8
XFILLER_41_789 vccd vssd sg13cmos5l_decap_8
XFILLER_40_266 vccd vssd sg13cmos5l_decap_8
XFILLER_33_2260 vccd vssd sg13cmos5l_decap_8
XFILLER_13_469 vccd vssd sg13cmos5l_decap_8
XFILLER_16_1267 vccd vssd sg13cmos5l_decap_8
XFILLER_5_602 vccd vssd sg13cmos5l_decap_8
XFILLER_4_112 vccd vssd sg13cmos5l_decap_8
XFILLER_5_679 vccd vssd sg13cmos5l_decap_8
XFILLER_4_49 vccd vssd sg13cmos5l_decap_8
XFILLER_4_189 vccd vssd sg13cmos5l_decap_8
XFILLER_7_2114 vccd vssd sg13cmos5l_decap_8
XFILLER_11_1890 vccd vssd sg13cmos5l_decap_8
XFILLER_42_2507 vccd vssd sg13cmos5l_decap_8
XFILLER_1_896 vccd vssd sg13cmos5l_decap_8
XFILLER_7_1435 vccd vssd sg13cmos5l_decap_8
XFILLER_27_1396 vccd vssd sg13cmos5l_decap_8
XFILLER_40_2275 vccd vssd sg13cmos5l_decap_8
XFILLER_36_506 vccd vssd sg13cmos5l_decap_8
XFILLER_40_1585 vccd vssd sg13cmos5l_decap_8
XFILLER_1_1001 vccd vssd sg13cmos5l_decap_8
XFILLER_44_550 vccd vssd sg13cmos5l_decap_8
XFILLER_18_2701 vccd vssd sg13cmos5l_decap_8
XFILLER_17_742 vccd vssd sg13cmos5l_decap_8
XFILLER_16_252 vccd vssd sg13cmos5l_decap_8
XFILLER_1_1078 vccd vssd sg13cmos5l_decap_8
XFILLER_32_756 vccd vssd sg13cmos5l_decap_8
XFILLER_18_2778 vccd vssd sg13cmos5l_decap_8
XFILLER_31_266 vccd vssd sg13cmos5l_decap_8
XFILLER_12_2300 vccd vssd sg13cmos5l_decap_8
XFILLER_9_952 vccd vssd sg13cmos5l_decap_8
XFILLER_34_1378 vccd vssd sg13cmos5l_decap_8
X_1702_ _1702_/Q _1711_/CLK _1702_/D _1635_/B_N vccd vssd sg13cmos5l_dfrbpq_1
XFILLER_8_462 vccd vssd sg13cmos5l_decap_8
XFILLER_12_1610 vccd vssd sg13cmos5l_decap_8
X_1633_ _1633_/Y _1641_/A _1638_/B_N vccd vssd sg13cmos5l_nor2b_1
XFILLER_12_2377 vccd vssd sg13cmos5l_decap_8
XFILLER_12_1687 vccd vssd sg13cmos5l_decap_8
X_1564_ _1564_/X _1481_/A hold492/X _1566_/S vccd vssd sg13cmos5l_mux2_1
XFILLER_45_2142 vccd vssd sg13cmos5l_decap_8
XFILLER_41_2006 vccd vssd sg13cmos5l_decap_8
X_1495_ _1495_/Y _1495_/A _1495_/B vccd vssd sg13cmos5l_nor2_1
XFILLER_25_2749 vccd vssd sg13cmos5l_decap_8
XFILLER_45_1463 vccd vssd sg13cmos5l_decap_8
XFILLER_39_322 vccd vssd sg13cmos5l_decap_8
XFILLER_3_2534 vccd vssd sg13cmos5l_decap_8
XFILLER_23_2473 vccd vssd sg13cmos5l_decap_8
Xoutbuffers\[33\] control[33] _1701_/Q vccd vssd sg13cmos5l_buf_8
XFILLER_23_1783 vccd vssd sg13cmos5l_decap_8
XFILLER_3_1855 vccd vssd sg13cmos5l_decap_8
XFILLER_39_1201 vccd vssd sg13cmos5l_decap_8
XFILLER_17_2211 vccd vssd sg13cmos5l_decap_8
XFILLER_39_1278 vccd vssd sg13cmos5l_decap_8
Xfanout26 _1342_/B _1439_/B vccd vssd sg13cmos5l_buf_1
Xfanout15 _1449_/B _1439_/Y vccd vssd sg13cmos5l_buf_1
Xfanout37 _1510_/B _1037_/Y vccd vssd sg13cmos5l_buf_1
XFILLER_23_756 vccd vssd sg13cmos5l_decap_8
Xfanout59 _1268_/B1 _0998_/Y vccd vssd sg13cmos5l_buf_1
Xfanout48 _1578_/B _1021_/Y vccd vssd sg13cmos5l_buf_1
XFILLER_22_266 vccd vssd sg13cmos5l_decap_8
XFILLER_10_406 vccd vssd sg13cmos5l_decap_8
XFILLER_13_14 vccd vssd sg13cmos5l_decap_8
XFILLER_30_2411 vccd vssd sg13cmos5l_decap_8
XFILLER_17_2299 vccd vssd sg13cmos5l_decap_8
XFILLER_17_1554 vccd vssd sg13cmos5l_decap_8
XFILLER_13_1407 vccd vssd sg13cmos5l_decap_8
XFILLER_30_1710 vccd vssd sg13cmos5l_decap_8
Xclkbuf_5_1_0_SCK clkload0/A clkbuf_5_3_0_SCK/A vccd vssd sg13cmos5l_buf_8
XFILLER_11_1120 vccd vssd sg13cmos5l_decap_8
XFILLER_30_1765 vccd vssd sg13cmos5l_decap_8
Xhold440 _1698_/D _1461_/X vccd vssd sg13cmos5l_dlygate4sd3_1
Xhold462 hold462/X _1741_/Q vccd vssd sg13cmos5l_dlygate4sd3_1
Xhold451 _1394_/A _1664_/Q vccd vssd sg13cmos5l_dlygate4sd3_1
XFILLER_2_616 vccd vssd sg13cmos5l_decap_8
XFILLER_8_7 vccd vssd sg13cmos5l_decap_8
XFILLER_8_2401 vccd vssd sg13cmos5l_decap_8
XFILLER_11_1197 vccd vssd sg13cmos5l_decap_8
Xhold484 hold484/X _1785_/Q vccd vssd sg13cmos5l_dlygate4sd3_1
Xhold495 _1775_/D _1573_/X vccd vssd sg13cmos5l_dlygate4sd3_1
Xhold473 _1752_/D _1539_/X vccd vssd sg13cmos5l_dlygate4sd3_1
XFILLER_1_126 vccd vssd sg13cmos5l_decap_8
XFILLER_28_1672 vccd vssd sg13cmos5l_decap_8
XFILLER_24_2237 vccd vssd sg13cmos5l_decap_8
XFILLER_24_1503 vccd vssd sg13cmos5l_decap_8
XFILLER_8_1722 vccd vssd sg13cmos5l_decap_8
XFILLER_8_2478 vccd vssd sg13cmos5l_decap_8
XFILLER_41_2551 vccd vssd sg13cmos5l_decap_8
XFILLER_24_2259 vccd vssd sg13cmos5l_decap_8
XFILLER_38_77 vccd vssd sg13cmos5l_decap_8
XFILLER_2_2044 vccd vssd sg13cmos5l_decap_8
XFILLER_6_2191 vccd vssd sg13cmos5l_decap_8
XFILLER_8_1799 vccd vssd sg13cmos5l_decap_8
XFILLER_45_336 vccd vssd sg13cmos5l_decap_8
XFILLER_18_539 vccd vssd sg13cmos5l_decap_8
XFILLER_41_1894 vccd vssd sg13cmos5l_decap_8
XFILLER_2_1365 vccd vssd sg13cmos5l_decap_8
XFILLER_14_756 vccd vssd sg13cmos5l_decap_8
XFILLER_13_266 vccd vssd sg13cmos5l_decap_8
XFILLER_41_586 vccd vssd sg13cmos5l_decap_8
XFILLER_35_2399 vccd vssd sg13cmos5l_decap_8
XFILLER_9_259 vccd vssd sg13cmos5l_decap_8
XFILLER_31_1529 vccd vssd sg13cmos5l_decap_8
XFILLER_16_1064 vccd vssd sg13cmos5l_decap_8
XFILLER_10_973 vccd vssd sg13cmos5l_decap_8
XFILLER_13_2653 vccd vssd sg13cmos5l_decap_8
Xclkload18 clkload18/Y _1798_/CLK vccd vssd sg13cmos5l_inv_1
XFILLER_6_966 vccd vssd sg13cmos5l_decap_8
XFILLER_13_1974 vccd vssd sg13cmos5l_decap_8
XFILLER_29_2159 vccd vssd sg13cmos5l_decap_8
XFILLER_5_476 vccd vssd sg13cmos5l_decap_8
XFILLER_9_1519 vccd vssd sg13cmos5l_decap_8
XFILLER_42_1603 vccd vssd sg13cmos5l_decap_8
X_1280_ _1280_/Y _1277_/Y _1278_/X _1279_/Y vccd vssd sg13cmos5l_o21ai_1
XFILLER_1_693 vccd vssd sg13cmos5l_decap_8
XFILLER_7_1232 vccd vssd sg13cmos5l_decap_8
XFILLER_40_1360 vccd vssd sg13cmos5l_decap_8
XFILLER_37_859 vccd vssd sg13cmos5l_decap_8
XFILLER_36_336 vccd vssd sg13cmos5l_decap_8
XFILLER_20_2646 vccd vssd sg13cmos5l_decap_8
XFILLER_20_1912 vccd vssd sg13cmos5l_decap_8
Xoutbuffers\[123\] control[123] _1791_/Q vccd vssd sg13cmos5l_buf_8
XFILLER_32_553 vccd vssd sg13cmos5l_decap_8
XFILLER_14_2428 vccd vssd sg13cmos5l_decap_8
XFILLER_34_1131 vccd vssd sg13cmos5l_decap_8
XFILLER_31_2731 vccd vssd sg13cmos5l_decap_8
XFILLER_18_2597 vccd vssd sg13cmos5l_decap_8
X_0995_ _1036_/B _1070_/B _0995_/B vccd vssd sg13cmos5l_nor2_1
X_1616_ _1616_/Y _1617_/A _1617_/B_N vccd vssd sg13cmos5l_nor2b_1
XFILLER_12_1484 vccd vssd sg13cmos5l_decap_8
XFILLER_29_2671 vccd vssd sg13cmos5l_decap_8
XFILLER_5_70 vccd vssd sg13cmos5l_decap_8
X_1547_ _1547_/Y _1547_/A _1549_/S vccd vssd sg13cmos5l_nor2_1
XFILLER_29_1981 vccd vssd sg13cmos5l_decap_8
XFILLER_25_2524 vccd vssd sg13cmos5l_decap_8
XFILLER_8_1029 vccd vssd sg13cmos5l_decap_8
XFILLER_45_1260 vccd vssd sg13cmos5l_decap_8
X_1478_ _1478_/Y _1478_/A _1485_/S vccd vssd sg13cmos5l_nor2_1
XFILLER_41_1113 vccd vssd sg13cmos5l_decap_8
XFILLER_3_2331 vccd vssd sg13cmos5l_decap_8
XFILLER_5_1939 vccd vssd sg13cmos5l_decap_8
XFILLER_41_1157 vccd vssd sg13cmos5l_decap_8
XFILLER_23_2281 vccd vssd sg13cmos5l_decap_8
XFILLER_39_196 vccd vssd sg13cmos5l_decap_8
XFILLER_27_336 vccd vssd sg13cmos5l_decap_8
XFILLER_3_1652 vccd vssd sg13cmos5l_decap_8
XFILLER_43_829 vccd vssd sg13cmos5l_decap_4
XFILLER_42_306 vccd vssd sg13cmos5l_decap_8
XFILLER_19_2317 vccd vssd sg13cmos5l_decap_8
XFILLER_19_1638 vccd vssd sg13cmos5l_decap_8
XFILLER_36_2686 vccd vssd sg13cmos5l_decap_8
XFILLER_24_35 vccd vssd sg13cmos5l_decap_8
XFILLER_23_553 vccd vssd sg13cmos5l_decap_8
XFILLER_32_2539 vccd vssd sg13cmos5l_decap_8
XFILLER_17_2074 vccd vssd sg13cmos5l_decap_8
XFILLER_17_1351 vccd vssd sg13cmos5l_decap_8
XFILLER_10_203 vccd vssd sg13cmos5l_decap_8
XFILLER_13_1204 vccd vssd sg13cmos5l_decap_8
XFILLER_40_56 vccd vssd sg13cmos5l_decap_8
XFILLER_3_903 vccd vssd sg13cmos5l_decap_8
XFILLER_30_1573 vccd vssd sg13cmos5l_decap_4
XFILLER_2_413 vccd vssd sg13cmos5l_decap_8
Xhold270 hold270/X _1521_/Y vccd vssd sg13cmos5l_dlygate4sd3_1
XFILLER_43_2635 vccd vssd sg13cmos5l_decap_4
Xhold281 hold281/X _1487_/Y vccd vssd sg13cmos5l_dlygate4sd3_1
Xhold292 _1646_/D _1413_/Y vccd vssd sg13cmos5l_dlygate4sd3_1
XFILLER_43_2679 vccd vssd sg13cmos5l_decap_8
XFILLER_43_1912 vccd vssd sg13cmos5l_decap_4
XFILLER_28_1480 vccd vssd sg13cmos5l_decap_8
XFILLER_4_2128 vccd vssd sg13cmos5l_decap_8
XFILLER_8_2275 vccd vssd sg13cmos5l_decap_8
XFILLER_24_2078 vccd vssd sg13cmos5l_decap_8
XFILLER_1_28 vccd vssd sg13cmos5l_decap_8
XFILLER_19_826 vccd vssd sg13cmos5l_decap_8
XFILLER_4_1449 vccd vssd sg13cmos5l_decap_8
XFILLER_8_1596 vccd vssd sg13cmos5l_decap_8
XFILLER_45_133 vccd vssd sg13cmos5l_decap_8
XFILLER_41_1691 vccd vssd sg13cmos5l_decap_8
XFILLER_18_336 vccd vssd sg13cmos5l_decap_8
XFILLER_2_1162 vccd vssd sg13cmos5l_decap_8
XFILLER_42_884 vccd vssd sg13cmos5l_decap_8
XFILLER_37_1738 vccd vssd sg13cmos5l_decap_8
XFILLER_15_2704 vccd vssd sg13cmos5l_decap_8
XFILLER_14_553 vccd vssd sg13cmos5l_decap_8
XFILLER_18_1148 vccd vssd sg13cmos5l_decap_8
XFILLER_31_1315 vccd vssd sg13cmos5l_decap_4
XFILLER_10_770 vccd vssd sg13cmos5l_decap_8
XFILLER_6_763 vccd vssd sg13cmos5l_decap_8
XFILLER_13_1771 vccd vssd sg13cmos5l_decap_8
XFILLER_5_273 vccd vssd sg13cmos5l_decap_8
X_1401_ _1401_/Y _1401_/A _1401_/B vccd vssd sg13cmos5l_nand2_1
XFILLER_9_1316 vccd vssd sg13cmos5l_decap_8
XFILLER_42_1400 vccd vssd sg13cmos5l_decap_8
X_1332_ _1332_/X _1741_/Q _1520_/B _1198_/A vccd vssd sg13cmos5l_a21o_1
XFILLER_2_980 vccd vssd sg13cmos5l_decap_8
X_1263_ _1265_/C status[114] wire81/X vccd vssd sg13cmos5l_nand2_1
XFILLER_42_1444 vccd vssd sg13cmos5l_decap_8
XFILLER_1_490 vccd vssd sg13cmos5l_decap_8
Xtiedowns\[113\] status[113] vccd vssd sg13cmos5l_antennanp
XFILLER_20_2443 vccd vssd sg13cmos5l_decap_8
XFILLER_37_656 vccd vssd sg13cmos5l_decap_8
XFILLER_37_645 vccd vssd sg13cmos5l_decap_4
XFILLER_36_133 vccd vssd sg13cmos5l_decap_8
X_1194_ _1194_/Y _1192_/Y _1191_/Y _1193_/Y vccd vssd sg13cmos5l_o21ai_1
XFILLER_20_1731 vccd vssd sg13cmos5l_decap_8
XFILLER_0_2548 vccd vssd sg13cmos5l_decap_8
XFILLER_4_2695 vccd vssd sg13cmos5l_decap_8
XFILLER_25_829 vccd vssd sg13cmos5l_decap_8
XFILLER_0_1869 vccd vssd sg13cmos5l_decap_8
XFILLER_33_873 vccd vssd sg13cmos5l_decap_8
XFILLER_32_350 vccd vssd sg13cmos5l_decap_8
XFILLER_20_567 vccd vssd sg13cmos5l_decap_8
X_0978_ _1031_/B _0995_/B _1058_/B vccd vssd sg13cmos5l_nor2_1
XFILLER_14_1568 vccd vssd sg13cmos5l_decap_8
XFILLER_12_1281 vccd vssd sg13cmos5l_decap_8
XFILLER_27_1918 vccd vssd sg13cmos5l_decap_8
XFILLER_25_2321 vccd vssd sg13cmos5l_decap_8
XFILLER_0_917 vccd vssd sg13cmos5l_decap_8
XFILLER_5_2415 vccd vssd sg13cmos5l_decap_8
XFILLER_9_2573 vccd vssd sg13cmos5l_decap_8
XFILLER_21_2218 vccd vssd sg13cmos5l_decap_8
XFILLER_19_35 vccd vssd sg13cmos5l_decap_8
XFILLER_9_1883 vccd vssd sg13cmos5l_decap_8
XFILLER_28_623 vccd vssd sg13cmos5l_decap_8
XFILLER_5_1736 vccd vssd sg13cmos5l_decap_8
XFILLER_27_133 vccd vssd sg13cmos5l_decap_8
XFILLER_35_56 vccd vssd sg13cmos5l_decap_8
XFILLER_24_840 vccd vssd sg13cmos5l_decap_8
XFILLER_19_2136 vccd vssd sg13cmos5l_decap_8
XFILLER_42_147 vccd vssd sg13cmos5l_decap_8
XFILLER_23_350 vccd vssd sg13cmos5l_decap_8
XFILLER_19_1435 vccd vssd sg13cmos5l_decap_8
XFILLER_32_2347 vccd vssd sg13cmos5l_decap_4
XFILLER_11_567 vccd vssd sg13cmos5l_decap_8
XFILLER_13_1001 vccd vssd sg13cmos5l_decap_8
XFILLER_32_1646 vccd vssd sg13cmos5l_decap_8
XFILLER_10_1911 vccd vssd sg13cmos5l_decap_8
XFILLER_10_2656 vccd vssd sg13cmos5l_decap_8
XFILLER_3_700 vccd vssd sg13cmos5l_decap_8
XFILLER_13_1078 vccd vssd sg13cmos5l_decap_8
XFILLER_2_210 vccd vssd sg13cmos5l_decap_8
XFILLER_10_1988 vccd vssd sg13cmos5l_decap_8
XFILLER_3_777 vccd vssd sg13cmos5l_decap_8
XFILLER_2_287 vccd vssd sg13cmos5l_decap_8
XFILLER_8_2072 vccd vssd sg13cmos5l_decap_8
Xtiedowns\[32\] status[32] vccd vssd sg13cmos5l_antennanp
XFILLER_21_2741 vccd vssd sg13cmos5l_decap_8
XFILLER_19_623 vccd vssd sg13cmos5l_decap_8
XFILLER_8_1393 vccd vssd sg13cmos5l_decap_8
XFILLER_18_133 vccd vssd sg13cmos5l_decap_8
XFILLER_4_1246 vccd vssd sg13cmos5l_decap_8
XFILLER_37_2236 vccd vssd sg13cmos5l_decap_8
XFILLER_34_659 vccd vssd sg13cmos5l_decap_8
XFILLER_15_840 vccd vssd sg13cmos5l_decap_8
XFILLER_33_147 vccd vssd sg13cmos5l_decap_8
XFILLER_14_350 vccd vssd sg13cmos5l_decap_8
XFILLER_37_1568 vccd vssd sg13cmos5l_decap_8
XFILLER_19_2692 vccd vssd sg13cmos5l_decap_8
XFILLER_15_2523 vccd vssd sg13cmos5l_decap_4
X_0901_ _0904_/C _1409_/A _0901_/B vccd vssd sg13cmos5l_nand2_1
XFILLER_15_2578 vccd vssd sg13cmos5l_decap_8
XFILLER_15_1855 vccd vssd sg13cmos5l_decap_8
X_0832_ _0832_/Y _0832_/A vccd vssd sg13cmos5l_inv_1
XFILLER_31_1145 vccd vssd sg13cmos5l_decap_8
XFILLER_11_1708 vccd vssd sg13cmos5l_decap_8
XFILLER_6_560 vccd vssd sg13cmos5l_decap_8
XFILLER_44_2229 vccd vssd sg13cmos5l_decap_8
XFILLER_9_1113 vccd vssd sg13cmos5l_decap_8
XFILLER_44_1539 vccd vssd sg13cmos5l_decap_8
XFILLER_29_1074 vccd vssd sg13cmos5l_decap_8
XFILLER_26_2663 vccd vssd sg13cmos5l_decap_8
XFILLER_6_2713 vccd vssd sg13cmos5l_decap_8
X_1315_ _1315_/Y _1314_/Y _1313_/Y _1315_/B1 vccd vssd sg13cmos5l_a21oi_2
XFILLER_38_932 vccd vssd sg13cmos5l_decap_8
XFILLER_42_1263 vccd vssd sg13cmos5l_decap_8
XFILLER_37_420 vccd vssd sg13cmos5l_decap_8
X_1246_ _1246_/Y _0852_/Y _1486_/B _1244_/X _1245_/Y _1114_/B vccd vssd sg13cmos5l_a221oi_1
XFILLER_4_2492 vccd vssd sg13cmos5l_decap_8
X_1177_ _1177_/Y status[116] wire81/X _1357_/A2 status[100] _1357_/C1 vccd vssd sg13cmos5l_a221oi_1
XFILLER_0_2345 vccd vssd sg13cmos5l_decap_8
XFILLER_25_626 vccd vssd sg13cmos5l_decap_8
XFILLER_24_147 vccd vssd sg13cmos5l_decap_8
XFILLER_16_2309 vccd vssd sg13cmos5l_decap_8
XFILLER_0_1666 vccd vssd sg13cmos5l_decap_8
XFILLER_36_1023 vccd vssd sg13cmos5l_decap_8
XFILLER_33_2601 vccd vssd sg13cmos5l_decap_8
XANTENNA_10 _1326_/A vccd vssd sg13cmos5l_antennanp
XFILLER_36_1067 vccd vssd sg13cmos5l_decap_8
XFILLER_21_854 vccd vssd sg13cmos5l_decap_8
XFILLER_14_2044 vccd vssd sg13cmos5l_decap_8
XFILLER_33_2678 vccd vssd sg13cmos5l_decap_8
XFILLER_20_364 vccd vssd sg13cmos5l_decap_8
XFILLER_33_1988 vccd vssd sg13cmos5l_decap_8
XFILLER_21_14 vccd vssd sg13cmos5l_decap_8
XFILLER_14_1365 vccd vssd sg13cmos5l_decap_8
XFILLER_10_1218 vccd vssd sg13cmos5l_decap_8
XFILLER_0_714 vccd vssd sg13cmos5l_decap_8
XFILLER_44_2730 vccd vssd sg13cmos5l_decap_8
XFILLER_27_1726 vccd vssd sg13cmos5l_decap_8
XFILLER_5_2212 vccd vssd sg13cmos5l_decap_8
XFILLER_40_2638 vccd vssd sg13cmos5l_decap_8
XFILLER_40_1904 vccd vssd sg13cmos5l_decap_8
XFILLER_29_932 vccd vssd sg13cmos5l_decap_8
XFILLER_5_1533 vccd vssd sg13cmos5l_decap_8
XFILLER_9_1680 vccd vssd sg13cmos5l_decap_8
XFILLER_40_1948 vccd vssd sg13cmos5l_decap_8
XFILLER_28_420 vccd vssd sg13cmos5l_decap_8
XFILLER_5_2289 vccd vssd sg13cmos5l_decap_8
XFILLER_21_1358 vccd vssd sg13cmos5l_decap_8
XFILLER_43_412 vccd vssd sg13cmos5l_decap_4
XFILLER_28_497 vccd vssd sg13cmos5l_decap_8
XFILLER_16_637 vccd vssd sg13cmos5l_decap_8
XFILLER_44_979 vccd vssd sg13cmos5l_decap_8
XFILLER_43_467 vccd vssd sg13cmos5l_decap_8
XFILLER_38_2567 vccd vssd sg13cmos5l_decap_8
XFILLER_15_147 vccd vssd sg13cmos5l_decap_8
XFILLER_38_1866 vccd vssd sg13cmos5l_decap_8
XFILLER_19_1232 vccd vssd sg13cmos5l_decap_8
XFILLER_12_854 vccd vssd sg13cmos5l_decap_8
XFILLER_32_2166 vccd vssd sg13cmos5l_decap_8
XFILLER_8_847 vccd vssd sg13cmos5l_decap_8
XFILLER_11_364 vccd vssd sg13cmos5l_decap_8
XFILLER_7_49 vccd vssd sg13cmos5l_decap_8
XFILLER_7_357 vccd vssd sg13cmos5l_decap_8
XFILLER_32_1498 vccd vssd sg13cmos5l_decap_8
XFILLER_45_2527 vccd vssd sg13cmos5l_decap_8
XFILLER_10_1785 vccd vssd sg13cmos5l_decap_8
XFILLER_11_91 vccd vssd sg13cmos5l_decap_8
XFILLER_3_574 vccd vssd sg13cmos5l_decap_8
XFILLER_6_2009 vccd vssd sg13cmos5l_decap_8
XFILLER_45_1848 vccd vssd sg13cmos5l_decap_8
XFILLER_26_1236 vccd vssd sg13cmos5l_decap_8
XFILLER_23_7 vccd vssd sg13cmos5l_decap_8
X_1100_ _1100_/Y _1097_/Y _1098_/Y _1099_/Y vccd vssd sg13cmos5l_o21ai_1
XFILLER_39_729 vccd vssd sg13cmos5l_decap_8
XFILLER_38_217 vccd vssd sg13cmos5l_decap_8
XFILLER_19_420 vccd vssd sg13cmos5l_decap_8
XFILLER_1_2632 vccd vssd sg13cmos5l_decap_8
XFILLER_4_1043 vccd vssd sg13cmos5l_decap_8
XFILLER_8_1190 vccd vssd sg13cmos5l_decap_8
X_1031_ _1031_/X _1036_/A _1031_/B vccd vssd sg13cmos5l_and2_1
XFILLER_34_412 vccd vssd sg13cmos5l_decap_8
XFILLER_19_497 vccd vssd sg13cmos5l_decap_8
XFILLER_1_1953 vccd vssd sg13cmos5l_decap_8
XFILLER_37_2033 vccd vssd sg13cmos5l_decap_8
XFILLER_37_1332 vccd vssd sg13cmos5l_decap_8
XFILLER_17_1928 vccd vssd sg13cmos5l_decap_8
XFILLER_15_1652 vccd vssd sg13cmos5l_decap_8
XFILLER_11_1505 vccd vssd sg13cmos5l_decap_8
XFILLER_11_2228 vccd vssd sg13cmos5l_decap_8
X_1795_ _1795_/Q _1795_/CLK _1795_/D fanout114/X vccd vssd sg13cmos5l_dfrbpq_1
XFILLER_28_2714 vccd vssd sg13cmos5l_decap_8
XFILLER_44_2026 vccd vssd sg13cmos5l_decap_8
Xoutbuffers\[63\] control[63] _1731_/Q vccd vssd sg13cmos5l_buf_8
XFILLER_44_1336 vccd vssd sg13cmos5l_decap_8
XFILLER_29_217 vccd vssd sg13cmos5l_decap_8
XFILLER_6_1820 vccd vssd sg13cmos5l_decap_8
XFILLER_6_2576 vccd vssd sg13cmos5l_decap_8
XFILLER_6_2587 vccd vssd sg13cmos5l_decap_8
XFILLER_22_2357 vccd vssd sg13cmos5l_decap_8
XFILLER_22_1634 vccd vssd sg13cmos5l_decap_8
XFILLER_2_2429 vccd vssd sg13cmos5l_decap_8
X_1229_ _1229_/Y status[51] _1362_/B1 _1317_/B1 status[43] _1227_/Y vccd vssd sg13cmos5l_a221oi_1
XFILLER_26_924 vccd vssd sg13cmos5l_decap_8
XFILLER_0_2142 vccd vssd sg13cmos5l_decap_8
XFILLER_6_1897 vccd vssd sg13cmos5l_decap_8
XFILLER_37_294 vccd vssd sg13cmos5l_decap_8
XFILLER_25_434 vccd vssd sg13cmos5l_decap_8
XFILLER_16_14 vccd vssd sg13cmos5l_decap_8
XFILLER_38_1107 vccd vssd sg13cmos5l_decap_8
XFILLER_35_2707 vccd vssd sg13cmos5l_decap_8
XFILLER_0_1463 vccd vssd sg13cmos5l_decap_8
XFILLER_40_448 vccd vssd sg13cmos5l_decap_8
XFILLER_32_35 vccd vssd sg13cmos5l_decap_8
XFILLER_21_651 vccd vssd sg13cmos5l_decap_8
XFILLER_16_1449 vccd vssd sg13cmos5l_decap_8
XFILLER_33_2497 vccd vssd sg13cmos5l_decap_8
XFILLER_20_161 vccd vssd sg13cmos5l_decap_8
XFILLER_10_1015 vccd vssd sg13cmos5l_decap_8
XFILLER_11_2762 vccd vssd sg13cmos5l_decap_8
XFILLER_14_1162 vccd vssd sg13cmos5l_decap_8
XFILLER_0_511 vccd vssd sg13cmos5l_decap_8
XFILLER_7_1617 vccd vssd sg13cmos5l_decap_8
XFILLER_0_588 vccd vssd sg13cmos5l_decap_8
XFILLER_44_1870 vccd vssd sg13cmos5l_decap_8
XFILLER_5_1330 vccd vssd sg13cmos5l_decap_8
XFILLER_5_2086 vccd vssd sg13cmos5l_decap_8
XFILLER_40_1767 vccd vssd sg13cmos5l_decap_8
XFILLER_29_762 vccd vssd sg13cmos5l_decap_8
XFILLER_21_1155 vccd vssd sg13cmos5l_decap_8
XFILLER_17_924 vccd vssd sg13cmos5l_decap_8
XFILLER_28_294 vccd vssd sg13cmos5l_decap_8
XFILLER_16_434 vccd vssd sg13cmos5l_decap_8
XFILLER_38_2375 vccd vssd sg13cmos5l_decap_8
XFILLER_34_2228 vccd vssd sg13cmos5l_decap_8
XFILLER_25_990 vccd vssd sg13cmos5l_decap_8
XFILLER_43_297 vccd vssd sg13cmos5l_decap_4
XFILLER_31_448 vccd vssd sg13cmos5l_decap_8
XFILLER_40_982 vccd vssd sg13cmos5l_decap_8
XFILLER_12_651 vccd vssd sg13cmos5l_decap_8
XFILLER_12_2504 vccd vssd sg13cmos5l_decap_8
XFILLER_16_1972 vccd vssd sg13cmos5l_decap_8
XFILLER_8_644 vccd vssd sg13cmos5l_decap_8
XFILLER_11_161 vccd vssd sg13cmos5l_decap_8
XFILLER_7_154 vccd vssd sg13cmos5l_decap_8
X_1580_ _1780_/D _1590_/A1 _1587_/S hold249/X vccd vssd sg13cmos5l_o21ai_1
XFILLER_10_2261 vccd vssd sg13cmos5l_decap_8
XFILLER_12_1869 vccd vssd sg13cmos5l_decap_8
XFILLER_45_2324 vccd vssd sg13cmos5l_decap_8
XFILLER_28_1309 vccd vssd sg13cmos5l_decap_8
XFILLER_4_861 vccd vssd sg13cmos5l_decap_8
XFILLER_3_371 vccd vssd sg13cmos5l_decap_8
XFILLER_10_1582 vccd vssd sg13cmos5l_decap_8
XFILLER_45_1645 vccd vssd sg13cmos5l_decap_8
XFILLER_39_515 vccd vssd sg13cmos5l_decap_8
XFILLER_23_2655 vccd vssd sg13cmos5l_decap_8
XFILLER_3_2716 vccd vssd sg13cmos5l_decap_8
XFILLER_6_1127 vccd vssd sg13cmos5l_decap_8
XFILLER_23_1976 vccd vssd sg13cmos5l_decap_4
XFILLER_39_2117 vccd vssd sg13cmos5l_decap_8
XFILLER_23_1987 vccd vssd sg13cmos5l_decap_4
XFILLER_39_1416 vccd vssd sg13cmos5l_decap_8
XFILLER_35_754 vccd vssd sg13cmos5l_decap_8
XFILLER_34_231 vccd vssd sg13cmos5l_decap_8
X_1014_ _1052_/A _1017_/B _1014_/B vccd vssd sg13cmos5l_nand2_1
XFILLER_19_294 vccd vssd sg13cmos5l_decap_8
XFILLER_1_1750 vccd vssd sg13cmos5l_decap_8
XFILLER_23_938 vccd vssd sg13cmos5l_decap_8
XFILLER_22_448 vccd vssd sg13cmos5l_decap_8
XFILLER_17_2448 vccd vssd sg13cmos5l_decap_8
Xoutbuffers\[7\] control[7] _1675_/Q vccd vssd sg13cmos5l_buf_8
XFILLER_37_1195 vccd vssd sg13cmos5l_decap_8
XFILLER_34_2784 vccd vssd sg13cmos5l_decap_8
XFILLER_17_1736 vccd vssd sg13cmos5l_decap_8
XFILLER_30_2659 vccd vssd sg13cmos5l_decap_8
XFILLER_8_70 vccd vssd sg13cmos5l_decap_8
XFILLER_11_1302 vccd vssd sg13cmos5l_decap_8
XFILLER_11_2058 vccd vssd sg13cmos5l_decap_8
X_1778_ _1778_/Q _1779_/CLK _1778_/D fanout114/X vccd vssd sg13cmos5l_dfrbpq_1
XFILLER_11_1379 vccd vssd sg13cmos5l_decap_8
XFILLER_28_2555 vccd vssd sg13cmos5l_decap_8
XFILLER_1_308 vccd vssd sg13cmos5l_decap_8
XFILLER_28_2588 vccd vssd sg13cmos5l_decap_8
XFILLER_28_1854 vccd vssd sg13cmos5l_decap_8
XFILLER_24_2419 vccd vssd sg13cmos5l_decap_8
XFILLER_8_1904 vccd vssd sg13cmos5l_decap_8
XFILLER_8_2649 vccd vssd sg13cmos5l_decap_8
XFILLER_44_1133 vccd vssd sg13cmos5l_decap_8
XFILLER_41_2733 vccd vssd sg13cmos5l_decap_8
XFILLER_24_1729 vccd vssd sg13cmos5l_decap_8
XFILLER_2_2226 vccd vssd sg13cmos5l_decap_8
XFILLER_6_2373 vccd vssd sg13cmos5l_decap_8
XFILLER_45_518 vccd vssd sg13cmos5l_decap_8
XFILLER_27_35 vccd vssd sg13cmos5l_decap_8
XFILLER_2_1547 vccd vssd sg13cmos5l_decap_8
XFILLER_6_1694 vccd vssd sg13cmos5l_decap_8
XFILLER_39_2640 vccd vssd sg13cmos5l_decap_8
XFILLER_25_231 vccd vssd sg13cmos5l_decap_8
XFILLER_39_1950 vccd vssd sg13cmos5l_decap_8
XFILLER_26_787 vccd vssd sg13cmos5l_decap_8
XFILLER_0_1260 vccd vssd sg13cmos5l_decap_8
XFILLER_14_938 vccd vssd sg13cmos5l_decap_8
XFILLER_41_768 vccd vssd sg13cmos5l_decap_8
XFILLER_35_1814 vccd vssd sg13cmos5l_decap_8
XFILLER_13_448 vccd vssd sg13cmos5l_decap_8
XFILLER_43_89 vccd vssd sg13cmos5l_decap_4
XFILLER_40_245 vccd vssd sg13cmos5l_decap_8
XFILLER_16_1246 vccd vssd sg13cmos5l_decap_8
XFILLER_11_2581 vccd vssd sg13cmos5l_decap_8
XFILLER_5_658 vccd vssd sg13cmos5l_decap_8
XFILLER_29_1629 vccd vssd sg13cmos5l_decap_8
XFILLER_4_28 vccd vssd sg13cmos5l_decap_8
XFILLER_4_168 vccd vssd sg13cmos5l_decap_8
XFILLER_27_2087 vccd vssd sg13cmos5l_decap_8
XFILLER_1_875 vccd vssd sg13cmos5l_decap_8
XFILLER_7_1414 vccd vssd sg13cmos5l_decap_8
XFILLER_40_2254 vccd vssd sg13cmos5l_decap_8
XFILLER_0_385 vccd vssd sg13cmos5l_decap_8
XFILLER_40_1564 vccd vssd sg13cmos5l_decap_8
XFILLER_17_721 vccd vssd sg13cmos5l_decap_8
XFILLER_16_231 vccd vssd sg13cmos5l_decap_8
XFILLER_1_1057 vccd vssd sg13cmos5l_decap_8
XFILLER_38_2172 vccd vssd sg13cmos5l_decap_8
XFILLER_17_798 vccd vssd sg13cmos5l_decap_8
XFILLER_38_2194 vccd vssd sg13cmos5l_decap_8
XFILLER_34_2014 vccd vssd sg13cmos5l_decap_8
XFILLER_32_735 vccd vssd sg13cmos5l_decap_8
XFILLER_18_2757 vccd vssd sg13cmos5l_decap_8
XFILLER_34_2069 vccd vssd sg13cmos5l_decap_8
XFILLER_34_2047 vccd vssd sg13cmos5l_decap_4
XFILLER_31_245 vccd vssd sg13cmos5l_decap_8
XFILLER_40_790 vccd vssd sg13cmos5l_decap_8
XFILLER_34_1357 vccd vssd sg13cmos5l_decap_8
XFILLER_9_931 vccd vssd sg13cmos5l_decap_8
X_1701_ _1701_/Q _1707_/CLK _1701_/D _1635_/B_N vccd vssd sg13cmos5l_dfrbpq_1
XFILLER_8_441 vccd vssd sg13cmos5l_decap_8
XFILLER_12_2356 vccd vssd sg13cmos5l_decap_8
XFILLER_32_1092 vccd vssd sg13cmos5l_decap_8
X_1632_ _1632_/Y _1639_/A _1639_/B_N vccd vssd sg13cmos5l_nor2b_1
XFILLER_12_1666 vccd vssd sg13cmos5l_decap_8
XFILLER_45_2121 vccd vssd sg13cmos5l_decap_8
X_1563_ _1563_/Y hold388/X _1566_/S _1562_/Y vccd vssd sg13cmos5l_a21oi_1
X_1494_ _1494_/X _1595_/A0 hold356/X _1497_/S vccd vssd sg13cmos5l_mux2_1
XFILLER_25_2728 vccd vssd sg13cmos5l_decap_8
XFILLER_45_2198 vccd vssd sg13cmos5l_decap_8
XFILLER_45_1442 vccd vssd sg13cmos5l_decap_8
XFILLER_39_301 vccd vssd sg13cmos5l_decap_8
XFILLER_23_2452 vccd vssd sg13cmos5l_decap_8
XFILLER_3_2513 vccd vssd sg13cmos5l_decap_8
XFILLER_7_2682 vccd vssd sg13cmos5l_decap_8
XFILLER_41_1339 vccd vssd sg13cmos5l_decap_8
XFILLER_39_367 vccd vssd sg13cmos5l_decap_8
XFILLER_7_1981 vccd vssd sg13cmos5l_decap_8
XFILLER_12_0 vccd vssd sg13cmos5l_decap_8
XFILLER_23_1762 vccd vssd sg13cmos5l_decap_8
XFILLER_3_1834 vccd vssd sg13cmos5l_decap_8
Xoutbuffers\[26\] control[26] _1694_/Q vccd vssd sg13cmos5l_buf_8
XFILLER_19_1809 vccd vssd sg13cmos5l_decap_8
Xfanout16 _1451_/B _1439_/Y vccd vssd sg13cmos5l_buf_1
XFILLER_39_1257 vccd vssd sg13cmos5l_decap_8
Xfanout27 _1439_/B _1050_/Y vccd vssd sg13cmos5l_buf_1
Xfanout38 _1372_/B1 _1035_/X vccd vssd sg13cmos5l_buf_1
XFILLER_23_735 vccd vssd sg13cmos5l_decap_8
Xfanout49 _1148_/B _1366_/B1 vccd vssd sg13cmos5l_buf_1
XFILLER_22_245 vccd vssd sg13cmos5l_decap_8
XFILLER_17_2278 vccd vssd sg13cmos5l_decap_8
XFILLER_17_2256 vccd vssd sg13cmos5l_decap_8
XFILLER_17_1533 vccd vssd sg13cmos5l_decap_8
XFILLER_34_2581 vccd vssd sg13cmos5l_decap_8
XFILLER_30_1799 vccd vssd sg13cmos5l_decap_8
Xhold430 _1713_/D _1483_/X vccd vssd sg13cmos5l_dlygate4sd3_1
Xhold441 hold441/X _1726_/Q vccd vssd sg13cmos5l_dlygate4sd3_1
Xhold463 _1741_/D _1523_/X vccd vssd sg13cmos5l_dlygate4sd3_1
Xhold452 _0905_/B _0904_/Y vccd vssd sg13cmos5l_dlygate4sd3_1
XFILLER_1_105 vccd vssd sg13cmos5l_decap_8
XFILLER_11_1176 vccd vssd sg13cmos5l_decap_8
Xhold485 _1785_/D _1585_/X vccd vssd sg13cmos5l_dlygate4sd3_1
Xhold474 hold474/X _1789_/Q vccd vssd sg13cmos5l_dlygate4sd3_1
Xhold496 hold496/X _1776_/Q vccd vssd sg13cmos5l_dlygate4sd3_1
XFILLER_8_1701 vccd vssd sg13cmos5l_decap_8
XFILLER_28_1651 vccd vssd sg13cmos5l_decap_8
XFILLER_8_2457 vccd vssd sg13cmos5l_decap_8
XFILLER_41_2530 vccd vssd sg13cmos5l_decap_8
XFILLER_6_2170 vccd vssd sg13cmos5l_decap_8
XFILLER_8_1778 vccd vssd sg13cmos5l_decap_8
XFILLER_38_56 vccd vssd sg13cmos5l_decap_8
XFILLER_2_2023 vccd vssd sg13cmos5l_decap_8
XFILLER_45_315 vccd vssd sg13cmos5l_decap_8
XFILLER_41_1873 vccd vssd sg13cmos5l_decap_8
XFILLER_18_518 vccd vssd sg13cmos5l_decap_8
XFILLER_6_1491 vccd vssd sg13cmos5l_decap_8
XFILLER_22_1294 vccd vssd sg13cmos5l_decap_8
XFILLER_2_1344 vccd vssd sg13cmos5l_decap_8
XFILLER_35_2334 vccd vssd sg13cmos5l_decap_8
XFILLER_14_735 vccd vssd sg13cmos5l_decap_8
XFILLER_41_565 vccd vssd sg13cmos5l_decap_8
XFILLER_39_1791 vccd vssd sg13cmos5l_decap_8
XFILLER_35_2378 vccd vssd sg13cmos5l_decap_8
XFILLER_13_245 vccd vssd sg13cmos5l_decap_8
XFILLER_35_1644 vccd vssd sg13cmos5l_decap_8
XFILLER_16_1043 vccd vssd sg13cmos5l_decap_8
XFILLER_9_238 vccd vssd sg13cmos5l_decap_8
XFILLER_13_2632 vccd vssd sg13cmos5l_decap_8
XFILLER_35_1699 vccd vssd sg13cmos5l_decap_8
XFILLER_31_1508 vccd vssd sg13cmos5l_decap_8
XFILLER_10_952 vccd vssd sg13cmos5l_decap_8
Xclkload19 clkload19/Y _1713_/CLK vccd vssd sg13cmos5l_inv_1
XFILLER_6_945 vccd vssd sg13cmos5l_decap_8
XFILLER_13_1953 vccd vssd sg13cmos5l_decap_8
Xtiedowns\[62\] status[62] vccd vssd sg13cmos5l_antennanp
XFILLER_29_2105 vccd vssd sg13cmos5l_decap_8
XFILLER_5_455 vccd vssd sg13cmos5l_decap_8
XFILLER_29_1426 vccd vssd sg13cmos5l_decap_8
XFILLER_7_1211 vccd vssd sg13cmos5l_decap_8
XFILLER_1_672 vccd vssd sg13cmos5l_decap_8
XFILLER_42_1659 vccd vssd sg13cmos5l_decap_8
XFILLER_24_2783 vccd vssd sg13cmos5l_decap_8
XFILLER_20_2625 vccd vssd sg13cmos5l_decap_8
XFILLER_0_182 vccd vssd sg13cmos5l_decap_8
XFILLER_40_2095 vccd vssd sg13cmos5l_decap_8
XFILLER_37_838 vccd vssd sg13cmos5l_decap_8
XFILLER_36_315 vccd vssd sg13cmos5l_decap_8
XFILLER_7_1288 vccd vssd sg13cmos5l_decap_8
XFILLER_2_2590 vccd vssd sg13cmos5l_decap_8
XFILLER_45_882 vccd vssd sg13cmos5l_decap_8
XFILLER_44_392 vccd vssd sg13cmos5l_decap_8
Xoutbuffers\[116\] control[116] _1784_/Q vccd vssd sg13cmos5l_buf_8
XFILLER_36_1419 vccd vssd sg13cmos5l_decap_8
XFILLER_32_532 vccd vssd sg13cmos5l_decap_8
XFILLER_18_2532 vccd vssd sg13cmos5l_decap_8
XFILLER_17_595 vccd vssd sg13cmos5l_decap_8
Xclkbuf_5_17_0_SCK clkload9/A clkbuf_3_4_0_SCK/X vccd vssd sg13cmos5l_buf_8
XFILLER_18_2576 vccd vssd sg13cmos5l_decap_8
XFILLER_14_2407 vccd vssd sg13cmos5l_decap_8
XFILLER_31_2710 vccd vssd sg13cmos5l_decap_8
XFILLER_20_749 vccd vssd sg13cmos5l_decap_8
XFILLER_18_1864 vccd vssd sg13cmos5l_decap_8
X_0994_ _1000_/A status[79] _1225_/B _0990_/Y _0993_/Y vccd vssd sg13cmos5l_a22oi_1
XFILLER_12_2142 vccd vssd sg13cmos5l_decap_4
XFILLER_31_2787 vccd vssd sg13cmos5l_decap_4
XFILLER_12_1463 vccd vssd sg13cmos5l_decap_8
X_1615_ _1615_/Y _1617_/A _1644_/B_N vccd vssd sg13cmos5l_nor2b_1
XFILLER_29_2650 vccd vssd sg13cmos5l_decap_8
X_1546_ _1756_/D _1590_/A1 _1555_/S hold236/X vccd vssd sg13cmos5l_o21ai_1
XFILLER_25_2503 vccd vssd sg13cmos5l_decap_8
XFILLER_8_1008 vccd vssd sg13cmos5l_decap_8
XFILLER_9_2777 vccd vssd sg13cmos5l_decap_8
X_1477_ _1477_/X _1401_/A hold394/X _1480_/S vccd vssd sg13cmos5l_mux2_1
XFILLER_41_1136 vccd vssd sg13cmos5l_decap_8
XFILLER_23_2260 vccd vssd sg13cmos5l_decap_8
XFILLER_3_2310 vccd vssd sg13cmos5l_decap_8
XFILLER_5_1918 vccd vssd sg13cmos5l_decap_8
XFILLER_39_175 vccd vssd sg13cmos5l_decap_8
XFILLER_27_315 vccd vssd sg13cmos5l_decap_8
XFILLER_3_1631 vccd vssd sg13cmos5l_decap_8
XFILLER_3_2387 vccd vssd sg13cmos5l_decap_8
XFILLER_35_392 vccd vssd sg13cmos5l_decap_8
XFILLER_24_14 vccd vssd sg13cmos5l_decap_8
XFILLER_23_532 vccd vssd sg13cmos5l_decap_8
XFILLER_19_1617 vccd vssd sg13cmos5l_decap_8
XFILLER_36_2665 vccd vssd sg13cmos5l_decap_8
XFILLER_32_2507 vccd vssd sg13cmos5l_decap_4
XFILLER_17_2053 vccd vssd sg13cmos5l_decap_8
XFILLER_39_1098 vccd vssd sg13cmos5l_decap_8
XFILLER_17_1330 vccd vssd sg13cmos5l_decap_8
XFILLER_11_749 vccd vssd sg13cmos5l_decap_8
XFILLER_10_259 vccd vssd sg13cmos5l_decap_8
XFILLER_40_35 vccd vssd sg13cmos5l_decap_8
XFILLER_30_2253 vccd vssd sg13cmos5l_decap_8
XFILLER_30_2286 vccd vssd sg13cmos5l_decap_8
XFILLER_30_1552 vccd vssd sg13cmos5l_decap_8
XFILLER_30_1596 vccd vssd sg13cmos5l_decap_8
Xhold260 _1710_/D _1479_/Y vccd vssd sg13cmos5l_dlygate4sd3_1
Xhold271 _0868_/A _1722_/Q vccd vssd sg13cmos5l_dlygate4sd3_1
XFILLER_3_959 vccd vssd sg13cmos5l_decap_8
XFILLER_43_2625 vccd vssd sg13cmos5l_decap_8
Xhold282 _1511_/A _1732_/Q vccd vssd sg13cmos5l_dlygate4sd3_1
Xhold293 _0928_/A _1799_/Q vccd vssd sg13cmos5l_dlygate4sd3_1
XFILLER_2_469 vccd vssd sg13cmos5l_decap_8
XFILLER_8_2254 vccd vssd sg13cmos5l_decap_8
XFILLER_24_2035 vccd vssd sg13cmos5l_decap_4
XFILLER_4_2107 vccd vssd sg13cmos5l_decap_8
XFILLER_24_1345 vccd vssd sg13cmos5l_decap_4
XFILLER_24_1323 vccd vssd sg13cmos5l_decap_4
XFILLER_19_805 vccd vssd sg13cmos5l_decap_8
XFILLER_8_1575 vccd vssd sg13cmos5l_decap_8
XFILLER_18_315 vccd vssd sg13cmos5l_decap_8
XFILLER_4_1428 vccd vssd sg13cmos5l_decap_8
XFILLER_45_112 vccd vssd sg13cmos5l_decap_8
XFILLER_41_1670 vccd vssd sg13cmos5l_decap_8
XFILLER_2_1141 vccd vssd sg13cmos5l_decap_8
XFILLER_37_2418 vccd vssd sg13cmos5l_decap_8
XFILLER_45_189 vccd vssd sg13cmos5l_decap_8
XFILLER_33_329 vccd vssd sg13cmos5l_decap_8
XFILLER_26_392 vccd vssd sg13cmos5l_decap_8
XFILLER_14_532 vccd vssd sg13cmos5l_decap_8
XFILLER_42_863 vccd vssd sg13cmos5l_decap_8
XFILLER_41_340 vccd vssd sg13cmos5l_decap_8
XFILLER_18_1127 vccd vssd sg13cmos5l_decap_8
XFILLER_35_2175 vccd vssd sg13cmos5l_decap_4
XFILLER_35_1452 vccd vssd sg13cmos5l_decap_8
XFILLER_13_2440 vccd vssd sg13cmos5l_decap_8
XFILLER_35_1496 vccd vssd sg13cmos5l_decap_8
XFILLER_14_91 vccd vssd sg13cmos5l_decap_8
XFILLER_6_742 vccd vssd sg13cmos5l_decap_8
XFILLER_13_1750 vccd vssd sg13cmos5l_decap_8
XFILLER_5_252 vccd vssd sg13cmos5l_decap_8
X_1400_ _1649_/D _1401_/A _1478_/A _1401_/B vccd vssd sg13cmos5l_mux2_1
XFILLER_29_1256 vccd vssd sg13cmos5l_decap_8
X_1331_ _1331_/Y _0840_/Y _1371_/B _1531_/B vccd vssd sg13cmos5l_a21oi_1
X_1262_ _1265_/B status[98] wire78/X _1135_/B status[90] vccd vssd sg13cmos5l_a22oi_1
XFILLER_42_1423 vccd vssd sg13cmos5l_decap_8
XFILLER_24_2580 vccd vssd sg13cmos5l_decap_8
XFILLER_20_2422 vccd vssd sg13cmos5l_decap_8
XFILLER_4_2674 vccd vssd sg13cmos5l_decap_8
XFILLER_7_1085 vccd vssd sg13cmos5l_decap_8
XFILLER_37_635 vccd vssd sg13cmos5l_decap_4
XFILLER_36_112 vccd vssd sg13cmos5l_decap_8
X_1193_ _1193_/Y _1768_/Q _1152_/B _1544_/B vccd vssd sg13cmos5l_a21oi_1
XFILLER_25_808 vccd vssd sg13cmos5l_decap_8
XFILLER_20_1710 vccd vssd sg13cmos5l_decap_8
XFILLER_0_2527 vccd vssd sg13cmos5l_decap_8
Xtiedowns\[106\] status[106] vccd vssd sg13cmos5l_antennanp
Xclkbuf_5_0_0_SCK _1736_/CLK clkbuf_5_3_0_SCK/A vccd vssd sg13cmos5l_buf_8
XFILLER_20_2499 vccd vssd sg13cmos5l_decap_8
XFILLER_4_1995 vccd vssd sg13cmos5l_decap_8
XFILLER_36_189 vccd vssd sg13cmos5l_decap_8
XFILLER_24_329 vccd vssd sg13cmos5l_decap_8
XFILLER_18_882 vccd vssd sg13cmos5l_decap_8
XFILLER_0_1848 vccd vssd sg13cmos5l_decap_8
XFILLER_17_392 vccd vssd sg13cmos5l_decap_8
XFILLER_14_2215 vccd vssd sg13cmos5l_decap_8
XFILLER_20_546 vccd vssd sg13cmos5l_decap_8
XFILLER_18_1694 vccd vssd sg13cmos5l_decap_8
X_0977_ wire81/A _1070_/A _0981_/C _0988_/C _1058_/B vccd vssd sg13cmos5l_nor4_2
XFILLER_14_1547 vccd vssd sg13cmos5l_decap_8
Xoutbuffers\[93\] control[93] _1761_/Q vccd vssd sg13cmos5l_buf_8
XFILLER_31_2584 vccd vssd sg13cmos5l_decap_8
XFILLER_31_1883 vccd vssd sg13cmos5l_decap_8
XFILLER_12_1260 vccd vssd sg13cmos5l_decap_8
XFILLER_27_2609 vccd vssd sg13cmos5l_decap_8
XFILLER_10_49 vccd vssd sg13cmos5l_decap_8
XFILLER_9_2530 vccd vssd sg13cmos5l_decap_8
X_1529_ _1529_/Y hold275/X _1528_/B _1528_/Y vccd vssd sg13cmos5l_a21oi_1
XFILLER_25_2388 vccd vssd sg13cmos5l_decap_8
XFILLER_19_14 vccd vssd sg13cmos5l_decap_8
XFILLER_5_1715 vccd vssd sg13cmos5l_decap_8
XFILLER_9_1862 vccd vssd sg13cmos5l_decap_8
XFILLER_25_1687 vccd vssd sg13cmos5l_decap_8
XFILLER_25_1665 vccd vssd sg13cmos5l_decap_8
XFILLER_27_112 vccd vssd sg13cmos5l_decap_8
XFILLER_21_1529 vccd vssd sg13cmos5l_decap_8
XFILLER_3_2184 vccd vssd sg13cmos5l_decap_8
XFILLER_19_2115 vccd vssd sg13cmos5l_decap_8
XFILLER_16_819 vccd vssd sg13cmos5l_decap_8
XFILLER_42_126 vccd vssd sg13cmos5l_decap_8
XFILLER_38_2749 vccd vssd sg13cmos5l_decap_8
XFILLER_35_35 vccd vssd sg13cmos5l_decap_8
XFILLER_27_189 vccd vssd sg13cmos5l_decap_8
XFILLER_15_329 vccd vssd sg13cmos5l_decap_8
XFILLER_19_1414 vccd vssd sg13cmos5l_decap_8
XFILLER_36_2484 vccd vssd sg13cmos5l_decap_8
XFILLER_32_2326 vccd vssd sg13cmos5l_decap_8
XFILLER_24_896 vccd vssd sg13cmos5l_decap_8
XFILLER_11_546 vccd vssd sg13cmos5l_decap_8
XFILLER_36_1794 vccd vssd sg13cmos5l_decap_8
XFILLER_32_1625 vccd vssd sg13cmos5l_decap_8
XFILLER_7_539 vccd vssd sg13cmos5l_decap_8
XFILLER_14_2771 vccd vssd sg13cmos5l_decap_8
XFILLER_30_2083 vccd vssd sg13cmos5l_decap_8
XFILLER_10_2635 vccd vssd sg13cmos5l_decap_8
XFILLER_13_1057 vccd vssd sg13cmos5l_decap_8
XFILLER_30_1360 vccd vssd sg13cmos5l_decap_8
XFILLER_45_2709 vccd vssd sg13cmos5l_decap_8
XFILLER_10_1967 vccd vssd sg13cmos5l_decap_8
XFILLER_3_756 vccd vssd sg13cmos5l_decap_8
XFILLER_2_266 vccd vssd sg13cmos5l_decap_8
XFILLER_8_2051 vccd vssd sg13cmos5l_decap_8
Xtiedowns\[25\] status[25] vccd vssd sg13cmos5l_antennanp
XFILLER_24_1142 vccd vssd sg13cmos5l_decap_8
XFILLER_21_2720 vccd vssd sg13cmos5l_decap_8
XFILLER_19_602 vccd vssd sg13cmos5l_decap_8
XFILLER_4_1225 vccd vssd sg13cmos5l_decap_8
XFILLER_8_1372 vccd vssd sg13cmos5l_decap_8
XFILLER_18_112 vccd vssd sg13cmos5l_decap_8
XFILLER_19_679 vccd vssd sg13cmos5l_decap_8
XFILLER_37_2215 vccd vssd sg13cmos5l_decap_8
XFILLER_34_627 vccd vssd sg13cmos5l_decap_8
XFILLER_33_126 vccd vssd sg13cmos5l_decap_8
XFILLER_18_189 vccd vssd sg13cmos5l_decap_8
XFILLER_42_660 vccd vssd sg13cmos5l_decap_8
XFILLER_19_2671 vccd vssd sg13cmos5l_decap_8
XFILLER_15_896 vccd vssd sg13cmos5l_decap_8
X_0900_ _1403_/C _0900_/A _0900_/B vccd vssd sg13cmos5l_nor2_1
XFILLER_30_833 vccd vssd sg13cmos5l_decap_8
XFILLER_15_2568 vccd vssd sg13cmos5l_decap_8
XFILLER_31_1124 vccd vssd sg13cmos5l_decap_8
XFILLER_15_1834 vccd vssd sg13cmos5l_decap_8
X_0831_ _0831_/Y _0831_/A vccd vssd sg13cmos5l_inv_1
XFILLER_44_2208 vccd vssd sg13cmos5l_decap_8
XFILLER_44_1518 vccd vssd sg13cmos5l_decap_8
XFILLER_26_2642 vccd vssd sg13cmos5l_decap_8
X_1314_ _1314_/Y status[65] _1314_/B vccd vssd sg13cmos5l_nand2b_1
XFILLER_6_2769 vccd vssd sg13cmos5l_decap_8
XFILLER_9_1169 vccd vssd sg13cmos5l_decap_8
XFILLER_42_1242 vccd vssd sg13cmos5l_decap_8
XFILLER_38_911 vccd vssd sg13cmos5l_decap_8
XFILLER_26_1996 vccd vssd sg13cmos5l_decap_8
XFILLER_22_1816 vccd vssd sg13cmos5l_decap_8
X_1245_ _1245_/Y _1727_/Q _1498_/B _1486_/B vccd vssd sg13cmos5l_a21oi_1
XFILLER_0_2324 vccd vssd sg13cmos5l_decap_8
XFILLER_4_2471 vccd vssd sg13cmos5l_decap_8
X_1176_ _1176_/Y status[124] wire74/X _1309_/B1 status[108] vccd vssd sg13cmos5l_a22oi_1
XFILLER_38_988 vccd vssd sg13cmos5l_decap_8
XFILLER_25_605 vccd vssd sg13cmos5l_decap_8
XFILLER_24_126 vccd vssd sg13cmos5l_decap_8
XFILLER_20_1584 vccd vssd sg13cmos5l_decap_8
XFILLER_0_1645 vccd vssd sg13cmos5l_decap_8
XFILLER_4_1792 vccd vssd sg13cmos5l_decap_8
XFILLER_36_1002 vccd vssd sg13cmos5l_decap_8
XFILLER_40_619 vccd vssd sg13cmos5l_decap_8
Xtiedowns\[9\] status[9] vccd vssd sg13cmos5l_antennanp
XANTENNA_11 _1153_/B vccd vssd sg13cmos5l_antennanp
XFILLER_36_1046 vccd vssd sg13cmos5l_decap_8
XFILLER_33_2657 vccd vssd sg13cmos5l_decap_8
XFILLER_33_1901 vccd vssd sg13cmos5l_decap_8
XFILLER_21_833 vccd vssd sg13cmos5l_decap_8
XFILLER_14_2023 vccd vssd sg13cmos5l_decap_8
XFILLER_20_343 vccd vssd sg13cmos5l_decap_8
XFILLER_18_1491 vccd vssd sg13cmos5l_decap_8
XFILLER_33_1967 vccd vssd sg13cmos5l_decap_8
XFILLER_14_1344 vccd vssd sg13cmos5l_decap_8
XFILLER_27_1705 vccd vssd sg13cmos5l_decap_8
XFILLER_44_2786 vccd vssd sg13cmos5l_decap_4
XFILLER_40_2617 vccd vssd sg13cmos5l_decap_8
XFILLER_29_911 vccd vssd sg13cmos5l_decap_8
XFILLER_25_2185 vccd vssd sg13cmos5l_decap_8
XFILLER_5_1512 vccd vssd sg13cmos5l_decap_8
XFILLER_5_2268 vccd vssd sg13cmos5l_decap_8
XFILLER_40_1927 vccd vssd sg13cmos5l_decap_8
XFILLER_25_1473 vccd vssd sg13cmos5l_decap_8
XFILLER_21_2049 vccd vssd sg13cmos5l_decap_8
XFILLER_21_1337 vccd vssd sg13cmos5l_decap_8
XFILLER_28_476 vccd vssd sg13cmos5l_decap_8
XFILLER_16_616 vccd vssd sg13cmos5l_decap_8
XFILLER_5_1589 vccd vssd sg13cmos5l_decap_8
XFILLER_44_958 vccd vssd sg13cmos5l_decap_8
XFILLER_38_2546 vccd vssd sg13cmos5l_decap_8
XFILLER_15_126 vccd vssd sg13cmos5l_decap_8
XFILLER_19_1211 vccd vssd sg13cmos5l_decap_8
XFILLER_24_693 vccd vssd sg13cmos5l_decap_8
XFILLER_19_1288 vccd vssd sg13cmos5l_decap_8
XFILLER_12_833 vccd vssd sg13cmos5l_decap_8
XFILLER_12_2708 vccd vssd sg13cmos5l_decap_4
XFILLER_32_2145 vccd vssd sg13cmos5l_decap_8
XFILLER_7_28 vccd vssd sg13cmos5l_decap_8
XFILLER_8_826 vccd vssd sg13cmos5l_decap_8
XFILLER_11_343 vccd vssd sg13cmos5l_decap_8
XFILLER_12_2719 vccd vssd sg13cmos5l_decap_8
XFILLER_7_336 vccd vssd sg13cmos5l_decap_8
XFILLER_32_1477 vccd vssd sg13cmos5l_decap_8
XFILLER_45_2506 vccd vssd sg13cmos5l_decap_8
XFILLER_10_2487 vccd vssd sg13cmos5l_decap_8
XFILLER_3_553 vccd vssd sg13cmos5l_decap_8
XFILLER_10_1764 vccd vssd sg13cmos5l_decap_8
XFILLER_11_70 vccd vssd sg13cmos5l_decap_8
XFILLER_45_1827 vccd vssd sg13cmos5l_decap_8
XFILLER_6_1309 vccd vssd sg13cmos5l_decap_8
XFILLER_16_7 vccd vssd sg13cmos5l_decap_8
XFILLER_1_2611 vccd vssd sg13cmos5l_decap_8
XFILLER_4_1022 vccd vssd sg13cmos5l_decap_8
X_1030_ _1030_/Y _1771_/Q _1152_/B _1028_/Y _1027_/X vccd vssd sg13cmos5l_a22oi_1
XFILLER_21_2594 vccd vssd sg13cmos5l_decap_8
XFILLER_19_476 vccd vssd sg13cmos5l_decap_8
XFILLER_1_2688 vccd vssd sg13cmos5l_decap_8
XFILLER_1_1932 vccd vssd sg13cmos5l_decap_8
XFILLER_4_1099 vccd vssd sg13cmos5l_decap_8
XFILLER_37_2089 vccd vssd sg13cmos5l_decap_8
XFILLER_37_1311 vccd vssd sg13cmos5l_decap_8
XFILLER_19_2490 vccd vssd sg13cmos5l_decap_8
XFILLER_15_693 vccd vssd sg13cmos5l_decap_8
XFILLER_37_1399 vccd vssd sg13cmos5l_decap_8
XFILLER_33_1219 vccd vssd sg13cmos5l_decap_8
XFILLER_15_1631 vccd vssd sg13cmos5l_decap_8
XFILLER_11_2207 vccd vssd sg13cmos5l_decap_8
X_1794_ _1794_/Q clkload7/A _1794_/D fanout114/X vccd vssd sg13cmos5l_dfrbpq_1
XFILLER_44_2005 vccd vssd sg13cmos5l_decap_8
XFILLER_42_0 vccd vssd sg13cmos5l_decap_8
XFILLER_44_1315 vccd vssd sg13cmos5l_decap_8
XFILLER_26_2450 vccd vssd sg13cmos5l_decap_8
Xoutbuffers\[56\] control[56] _1724_/Q vccd vssd sg13cmos5l_buf_8
XFILLER_22_2336 vccd vssd sg13cmos5l_decap_8
XFILLER_2_2408 vccd vssd sg13cmos5l_decap_8
XFILLER_6_2555 vccd vssd sg13cmos5l_decap_8
XFILLER_42_1061 vccd vssd sg13cmos5l_decap_8
XFILLER_26_1782 vccd vssd sg13cmos5l_decap_8
XFILLER_22_1613 vccd vssd sg13cmos5l_decap_8
XFILLER_6_1876 vccd vssd sg13cmos5l_decap_8
X_1228_ _1228_/Y status[35] _1363_/A2 _1144_/B vccd vssd sg13cmos5l_a21oi_1
XFILLER_26_903 vccd vssd sg13cmos5l_decap_8
XFILLER_2_1729 vccd vssd sg13cmos5l_decap_8
XFILLER_0_2121 vccd vssd sg13cmos5l_decap_8
XFILLER_37_273 vccd vssd sg13cmos5l_decap_8
XFILLER_25_413 vccd vssd sg13cmos5l_decap_8
XFILLER_20_2082 vccd vssd sg13cmos5l_decap_8
XFILLER_38_1119 vccd vssd sg13cmos5l_decap_8
X_1159_ _1161_/B _1721_/Q _1337_/B vccd vssd sg13cmos5l_nand2_1
XFILLER_0_2198 vccd vssd sg13cmos5l_decap_8
XFILLER_0_1442 vccd vssd sg13cmos5l_decap_8
XFILLER_40_427 vccd vssd sg13cmos5l_decap_8
XFILLER_37_2590 vccd vssd sg13cmos5l_decap_8
XFILLER_21_630 vccd vssd sg13cmos5l_decap_8
XFILLER_33_2476 vccd vssd sg13cmos5l_decap_8
XFILLER_32_14 vccd vssd sg13cmos5l_decap_8
XFILLER_20_140 vccd vssd sg13cmos5l_decap_8
XFILLER_16_1428 vccd vssd sg13cmos5l_decap_8
XFILLER_14_1141 vccd vssd sg13cmos5l_decap_8
XFILLER_33_1786 vccd vssd sg13cmos5l_decap_8
XFILLER_11_2741 vccd vssd sg13cmos5l_decap_8
XFILLER_27_2258 vccd vssd sg13cmos5l_decap_8
XFILLER_27_1546 vccd vssd sg13cmos5l_decap_8
XFILLER_44_2583 vccd vssd sg13cmos5l_decap_8
XFILLER_40_2436 vccd vssd sg13cmos5l_decap_8
XFILLER_0_567 vccd vssd sg13cmos5l_decap_8
XFILLER_5_2065 vccd vssd sg13cmos5l_decap_8
XFILLER_40_1746 vccd vssd sg13cmos5l_decap_8
XFILLER_29_741 vccd vssd sg13cmos5l_decap_8
XFILLER_21_1134 vccd vssd sg13cmos5l_decap_8
XFILLER_17_903 vccd vssd sg13cmos5l_decap_8
XFILLER_44_733 vccd vssd sg13cmos5l_decap_8
XFILLER_28_273 vccd vssd sg13cmos5l_decap_8
XFILLER_16_413 vccd vssd sg13cmos5l_decap_8
XFILLER_1_1239 vccd vssd sg13cmos5l_decap_8
XFILLER_5_1386 vccd vssd sg13cmos5l_decap_8
XFILLER_38_2343 vccd vssd sg13cmos5l_decap_8
XFILLER_44_777 vccd vssd sg13cmos5l_decap_8
XFILLER_32_939 vccd vssd sg13cmos5l_decap_8
XFILLER_34_1506 vccd vssd sg13cmos5l_decap_8
XFILLER_31_427 vccd vssd sg13cmos5l_decap_8
XFILLER_24_490 vccd vssd sg13cmos5l_decap_8
XFILLER_12_630 vccd vssd sg13cmos5l_decap_8
Xtiedowns\[92\] status[92] vccd vssd sg13cmos5l_antennanp
XFILLER_40_961 vccd vssd sg13cmos5l_decap_8
XFILLER_19_1085 vccd vssd sg13cmos5l_decap_8
XFILLER_11_140 vccd vssd sg13cmos5l_decap_8
XFILLER_32_1241 vccd vssd sg13cmos5l_decap_4
XFILLER_16_1951 vccd vssd sg13cmos5l_decap_8
XFILLER_8_623 vccd vssd sg13cmos5l_decap_8
XFILLER_12_2549 vccd vssd sg13cmos5l_decap_8
XFILLER_7_133 vccd vssd sg13cmos5l_decap_8
XFILLER_10_2240 vccd vssd sg13cmos5l_decap_8
XFILLER_12_1848 vccd vssd sg13cmos5l_decap_8
XFILLER_22_91 vccd vssd sg13cmos5l_decap_8
XFILLER_45_2303 vccd vssd sg13cmos5l_decap_8
XFILLER_4_840 vccd vssd sg13cmos5l_decap_8
XFILLER_10_1561 vccd vssd sg13cmos5l_decap_8
XFILLER_3_350 vccd vssd sg13cmos5l_decap_8
XFILLER_45_1624 vccd vssd sg13cmos5l_decap_8
XFILLER_27_2770 vccd vssd sg13cmos5l_decap_8
XFILLER_23_2634 vccd vssd sg13cmos5l_decap_8
XFILLER_6_1106 vccd vssd sg13cmos5l_decap_8
XFILLER_26_1089 vccd vssd sg13cmos5l_decap_8
XFILLER_23_1911 vccd vssd sg13cmos5l_decap_4
XFILLER_23_1955 vccd vssd sg13cmos5l_decap_8
X_1013_ _1013_/Y _1005_/Y _1004_/Y _1012_/Y vccd vssd sg13cmos5l_o21ai_1
XFILLER_21_2391 vccd vssd sg13cmos5l_decap_8
XFILLER_19_273 vccd vssd sg13cmos5l_decap_8
XFILLER_34_210 vccd vssd sg13cmos5l_decap_8
XFILLER_21_1690 vccd vssd sg13cmos5l_decap_8
XFILLER_1_2485 vccd vssd sg13cmos5l_decap_8
XFILLER_23_917 vccd vssd sg13cmos5l_decap_8
XFILLER_17_2427 vccd vssd sg13cmos5l_decap_8
XFILLER_16_980 vccd vssd sg13cmos5l_decap_8
XFILLER_34_287 vccd vssd sg13cmos5l_decap_8
XFILLER_22_427 vccd vssd sg13cmos5l_decap_8
XFILLER_17_1715 vccd vssd sg13cmos5l_decap_8
XFILLER_15_490 vccd vssd sg13cmos5l_decap_8
XFILLER_37_1163 vccd vssd sg13cmos5l_decap_8
XFILLER_34_2763 vccd vssd sg13cmos5l_decap_8
XFILLER_31_950 vccd vssd sg13cmos5l_decap_8
XFILLER_33_1038 vccd vssd sg13cmos5l_decap_8
XFILLER_30_2638 vccd vssd sg13cmos5l_decap_8
XFILLER_11_2037 vccd vssd sg13cmos5l_decap_8
X_1777_ _1777_/Q _1779_/CLK _1777_/D fanout117/X vccd vssd sg13cmos5l_dfrbpq_1
XFILLER_11_1358 vccd vssd sg13cmos5l_decap_8
XFILLER_28_2534 vccd vssd sg13cmos5l_decap_8
XFILLER_8_2628 vccd vssd sg13cmos5l_decap_8
XFILLER_44_1112 vccd vssd sg13cmos5l_decap_8
XFILLER_28_1833 vccd vssd sg13cmos5l_decap_8
XFILLER_41_2712 vccd vssd sg13cmos5l_decap_8
XFILLER_24_1708 vccd vssd sg13cmos5l_decap_8
XFILLER_6_2352 vccd vssd sg13cmos5l_decap_8
XFILLER_44_1189 vccd vssd sg13cmos5l_decap_8
XFILLER_22_2155 vccd vssd sg13cmos5l_decap_8
XFILLER_2_2205 vccd vssd sg13cmos5l_decap_8
XFILLER_27_14 vccd vssd sg13cmos5l_decap_8
XFILLER_22_2188 vccd vssd sg13cmos5l_decap_8
XFILLER_22_1443 vccd vssd sg13cmos5l_decap_8
XFILLER_6_1673 vccd vssd sg13cmos5l_decap_8
XFILLER_2_1526 vccd vssd sg13cmos5l_decap_8
XFILLER_26_766 vccd vssd sg13cmos5l_decap_8
XFILLER_25_210 vccd vssd sg13cmos5l_decap_8
XFILLER_39_2696 vccd vssd sg13cmos5l_decap_8
XFILLER_14_917 vccd vssd sg13cmos5l_decap_8
XFILLER_41_747 vccd vssd sg13cmos5l_decap_8
XFILLER_40_224 vccd vssd sg13cmos5l_decap_8
XFILLER_25_287 vccd vssd sg13cmos5l_decap_8
XFILLER_13_427 vccd vssd sg13cmos5l_decap_8
XFILLER_16_1225 vccd vssd sg13cmos5l_decap_8
XFILLER_22_994 vccd vssd sg13cmos5l_decap_8
XFILLER_33_1583 vccd vssd sg13cmos5l_decap_8
XFILLER_5_637 vccd vssd sg13cmos5l_decap_8
XFILLER_4_147 vccd vssd sg13cmos5l_decap_8
XFILLER_27_2066 vccd vssd sg13cmos5l_decap_8
XFILLER_1_854 vccd vssd sg13cmos5l_decap_8
XFILLER_44_2380 vccd vssd sg13cmos5l_decap_8
XFILLER_27_1343 vccd vssd sg13cmos5l_decap_8
XFILLER_0_364 vccd vssd sg13cmos5l_decap_8
XFILLER_7_2149 vccd vssd sg13cmos5l_decap_8
XFILLER_40_2222 vccd vssd sg13cmos5l_decap_8
XFILLER_23_1207 vccd vssd sg13cmos5l_decap_4
XFILLER_40_1543 vccd vssd sg13cmos5l_decap_8
XFILLER_17_700 vccd vssd sg13cmos5l_decap_8
XFILLER_2_2772 vccd vssd sg13cmos5l_decap_8
XFILLER_5_1183 vccd vssd sg13cmos5l_decap_8
XFILLER_29_593 vccd vssd sg13cmos5l_decap_8
XFILLER_16_210 vccd vssd sg13cmos5l_decap_8
XFILLER_1_1036 vccd vssd sg13cmos5l_decap_8
XFILLER_38_2151 vccd vssd sg13cmos5l_decap_8
XFILLER_32_714 vccd vssd sg13cmos5l_decap_8
XFILLER_18_2736 vccd vssd sg13cmos5l_decap_8
XFILLER_17_777 vccd vssd sg13cmos5l_decap_8
XFILLER_17_91 vccd vssd sg13cmos5l_decap_8
XFILLER_44_585 vccd vssd sg13cmos5l_decap_8
XFILLER_31_224 vccd vssd sg13cmos5l_decap_8
XFILLER_16_287 vccd vssd sg13cmos5l_decap_8
XFILLER_34_1303 vccd vssd sg13cmos5l_decap_8
XFILLER_9_910 vccd vssd sg13cmos5l_decap_8
XFILLER_16_2493 vccd vssd sg13cmos5l_decap_8
XFILLER_8_420 vccd vssd sg13cmos5l_decap_8
XFILLER_13_994 vccd vssd sg13cmos5l_decap_8
X_1700_ _1700_/Q _1713_/CLK _1700_/D fanout130/X vccd vssd sg13cmos5l_dfrbpq_1
XFILLER_9_987 vccd vssd sg13cmos5l_decap_8
XFILLER_12_2335 vccd vssd sg13cmos5l_decap_8
XFILLER_16_1792 vccd vssd sg13cmos5l_decap_8
XFILLER_8_497 vccd vssd sg13cmos5l_decap_8
XFILLER_12_1645 vccd vssd sg13cmos5l_decap_8
XFILLER_45_2100 vccd vssd sg13cmos5l_decap_8
X_1562_ _1562_/Y _1562_/A _1567_/S vccd vssd sg13cmos5l_nor2_1
XFILLER_45_1421 vccd vssd sg13cmos5l_decap_8
X_1493_ _1493_/X _1504_/A hold425/X _1495_/B vccd vssd sg13cmos5l_mux2_1
XFILLER_25_2707 vccd vssd sg13cmos5l_decap_8
XFILLER_45_2177 vccd vssd sg13cmos5l_decap_8
XFILLER_41_1318 vccd vssd sg13cmos5l_decap_8
XFILLER_23_2431 vccd vssd sg13cmos5l_decap_8
XFILLER_7_2661 vccd vssd sg13cmos5l_decap_4
XFILLER_45_1498 vccd vssd sg13cmos5l_decap_8
XFILLER_23_1741 vccd vssd sg13cmos5l_decap_8
XFILLER_3_1813 vccd vssd sg13cmos5l_decap_8
XFILLER_7_1960 vccd vssd sg13cmos5l_decap_8
XFILLER_3_2569 vccd vssd sg13cmos5l_decap_8
XFILLER_1_2282 vccd vssd sg13cmos5l_decap_8
Xoutbuffers\[19\] control[19] _1687_/Q vccd vssd sg13cmos5l_buf_8
XFILLER_23_714 vccd vssd sg13cmos5l_decap_8
Xfanout17 _1437_/S _1438_/S vccd vssd sg13cmos5l_buf_1
Xfanout28 _1164_/B _1048_/X vccd vssd sg13cmos5l_buf_1
XFILLER_22_224 vccd vssd sg13cmos5l_decap_8
XFILLER_17_2235 vccd vssd sg13cmos5l_decap_8
Xfanout39 _1498_/B _1035_/X vccd vssd sg13cmos5l_buf_1
XFILLER_17_1512 vccd vssd sg13cmos5l_decap_8
XFILLER_34_2560 vccd vssd sg13cmos5l_decap_8
XFILLER_17_1589 vccd vssd sg13cmos5l_decap_8
XFILLER_13_49 vccd vssd sg13cmos5l_decap_8
Xhold420 _1702_/D _1467_/X vccd vssd sg13cmos5l_dlygate4sd3_1
XFILLER_11_1155 vccd vssd sg13cmos5l_decap_8
Xhold431 hold431/X _1749_/Q vccd vssd sg13cmos5l_dlygate4sd3_1
Xhold442 _1726_/D _1502_/X vccd vssd sg13cmos5l_dlygate4sd3_1
Xhold453 _0940_/B _0905_/Y vccd vssd sg13cmos5l_dlygate4sd3_1
Xhold475 _1789_/D _1591_/X vccd vssd sg13cmos5l_dlygate4sd3_1
XFILLER_28_1630 vccd vssd sg13cmos5l_decap_8
Xhold486 hold486/X _1777_/Q vccd vssd sg13cmos5l_dlygate4sd3_1
Xhold464 _1569_/A _1772_/Q vccd vssd sg13cmos5l_dlygate4sd3_1
XFILLER_8_2436 vccd vssd sg13cmos5l_decap_8
Xhold497 _1776_/D _1574_/X vccd vssd sg13cmos5l_dlygate4sd3_1
XFILLER_38_35 vccd vssd sg13cmos5l_decap_8
XFILLER_8_1757 vccd vssd sg13cmos5l_decap_8
XFILLER_41_2586 vccd vssd sg13cmos5l_decap_8
XFILLER_2_2002 vccd vssd sg13cmos5l_decap_8
XFILLER_41_1852 vccd vssd sg13cmos5l_decap_8
XFILLER_2_1323 vccd vssd sg13cmos5l_decap_8
XFILLER_6_1470 vccd vssd sg13cmos5l_decap_8
XFILLER_22_1273 vccd vssd sg13cmos5l_decap_8
XFILLER_2_2079 vccd vssd sg13cmos5l_decap_8
XFILLER_14_714 vccd vssd sg13cmos5l_decap_8
XFILLER_39_2493 vccd vssd sg13cmos5l_decap_8
XFILLER_35_2313 vccd vssd sg13cmos5l_decap_8
XFILLER_18_1309 vccd vssd sg13cmos5l_decap_8
XFILLER_13_224 vccd vssd sg13cmos5l_decap_8
XFILLER_41_544 vccd vssd sg13cmos5l_decap_8
XFILLER_39_1770 vccd vssd sg13cmos5l_decap_8
XFILLER_35_2357 vccd vssd sg13cmos5l_decap_8
XFILLER_35_1623 vccd vssd sg13cmos5l_decap_8
XFILLER_16_1022 vccd vssd sg13cmos5l_decap_8
XFILLER_9_217 vccd vssd sg13cmos5l_decap_8
XFILLER_35_1678 vccd vssd sg13cmos5l_decap_8
XFILLER_22_791 vccd vssd sg13cmos5l_decap_8
XFILLER_10_931 vccd vssd sg13cmos5l_decap_8
XFILLER_16_1099 vccd vssd sg13cmos5l_decap_8
XFILLER_6_924 vccd vssd sg13cmos5l_decap_8
XFILLER_13_1932 vccd vssd sg13cmos5l_decap_8
XFILLER_13_2688 vccd vssd sg13cmos5l_decap_8
XFILLER_33_1391 vccd vssd sg13cmos5l_decap_8
XFILLER_5_434 vccd vssd sg13cmos5l_decap_8
XFILLER_29_1405 vccd vssd sg13cmos5l_decap_8
Xtiedowns\[55\] status[55] vccd vssd sg13cmos5l_antennanp
XFILLER_42_2339 vccd vssd sg13cmos5l_decap_8
XFILLER_42_2306 vccd vssd sg13cmos5l_decap_8
XFILLER_1_651 vccd vssd sg13cmos5l_decap_8
XFILLER_27_1173 vccd vssd sg13cmos5l_decap_8
XFILLER_24_2762 vccd vssd sg13cmos5l_decap_8
XFILLER_0_161 vccd vssd sg13cmos5l_decap_8
XFILLER_37_817 vccd vssd sg13cmos5l_decap_8
XFILLER_20_2604 vccd vssd sg13cmos5l_decap_8
XFILLER_7_1267 vccd vssd sg13cmos5l_decap_8
XFILLER_40_2074 vccd vssd sg13cmos5l_decap_8
XFILLER_20_1903 vccd vssd sg13cmos5l_decap_4
XFILLER_0_2709 vccd vssd sg13cmos5l_decap_8
XFILLER_45_861 vccd vssd sg13cmos5l_decap_8
XFILLER_40_1395 vccd vssd sg13cmos5l_decap_8
XFILLER_18_2511 vccd vssd sg13cmos5l_decap_8
XFILLER_17_574 vccd vssd sg13cmos5l_decap_8
XFILLER_44_371 vccd vssd sg13cmos5l_decap_8
XFILLER_32_511 vccd vssd sg13cmos5l_decap_8
XFILLER_2_1890 vccd vssd sg13cmos5l_decap_8
XFILLER_18_2566 vccd vssd sg13cmos5l_decap_8
X_0993_ _0993_/Y _0879_/Y _1261_/B _1225_/B vccd vssd sg13cmos5l_a21oi_1
Xoutbuffers\[109\] control[109] _1777_/Q vccd vssd sg13cmos5l_buf_8
XFILLER_32_588 vccd vssd sg13cmos5l_decap_8
XFILLER_20_728 vccd vssd sg13cmos5l_decap_8
XFILLER_34_1166 vccd vssd sg13cmos5l_decap_4
XFILLER_12_2121 vccd vssd sg13cmos5l_decap_8
XFILLER_13_791 vccd vssd sg13cmos5l_decap_8
XFILLER_14_1729 vccd vssd sg13cmos5l_decap_8
XFILLER_34_1199 vccd vssd sg13cmos5l_decap_8
XFILLER_31_2766 vccd vssd sg13cmos5l_decap_8
XFILLER_9_784 vccd vssd sg13cmos5l_decap_8
XFILLER_8_294 vccd vssd sg13cmos5l_decap_8
XFILLER_12_1442 vccd vssd sg13cmos5l_decap_8
XFILLER_12_2187 vccd vssd sg13cmos5l_decap_8
X_1614_ _1614_/Y _1644_/A _1644_/B_N vccd vssd sg13cmos5l_nor2b_1
XFILLER_9_2701 vccd vssd sg13cmos5l_decap_8
X_1545_ _1545_/Y _1545_/A _1555_/S vccd vssd sg13cmos5l_nand2_1
XFILLER_5_2609 vccd vssd sg13cmos5l_decap_8
XFILLER_9_2756 vccd vssd sg13cmos5l_decap_8
XFILLER_25_2559 vccd vssd sg13cmos5l_decap_8
XFILLER_25_1825 vccd vssd sg13cmos5l_decap_8
X_1476_ _1476_/Y _1488_/A1 _1480_/S hold256/X vccd vssd sg13cmos5l_o21ai_1
XFILLER_45_1295 vccd vssd sg13cmos5l_decap_8
XFILLER_39_154 vccd vssd sg13cmos5l_decap_8
XFILLER_3_1610 vccd vssd sg13cmos5l_decap_8
XFILLER_3_2366 vccd vssd sg13cmos5l_decap_8
XFILLER_3_1687 vccd vssd sg13cmos5l_decap_8
XFILLER_36_883 vccd vssd sg13cmos5l_decap_8
XFILLER_35_371 vccd vssd sg13cmos5l_decap_8
XFILLER_23_511 vccd vssd sg13cmos5l_decap_8
XFILLER_39_1077 vccd vssd sg13cmos5l_decap_8
XFILLER_36_2644 vccd vssd sg13cmos5l_decap_8
XFILLER_23_588 vccd vssd sg13cmos5l_decap_8
XFILLER_11_728 vccd vssd sg13cmos5l_decap_8
XFILLER_36_1987 vccd vssd sg13cmos5l_decap_8
XFILLER_30_2232 vccd vssd sg13cmos5l_decap_8
XFILLER_17_1386 vccd vssd sg13cmos5l_decap_8
XFILLER_10_238 vccd vssd sg13cmos5l_decap_8
XFILLER_40_14 vccd vssd sg13cmos5l_decap_8
XFILLER_13_1239 vccd vssd sg13cmos5l_decap_8
XFILLER_30_1531 vccd vssd sg13cmos5l_decap_8
XFILLER_3_938 vccd vssd sg13cmos5l_decap_8
XFILLER_43_2604 vccd vssd sg13cmos5l_decap_4
Xhold261 _0841_/A _1686_/Q vccd vssd sg13cmos5l_dlygate4sd3_1
Xhold250 _0844_/A _1766_/Q vccd vssd sg13cmos5l_dlygate4sd3_1
XFILLER_2_448 vccd vssd sg13cmos5l_decap_8
Xhold272 hold272/X _0868_/Y vccd vssd sg13cmos5l_dlygate4sd3_1
XFILLER_28_2172 vccd vssd sg13cmos5l_decap_8
Xhold283 hold283/X _1511_/Y vccd vssd sg13cmos5l_dlygate4sd3_1
XFILLER_24_2014 vccd vssd sg13cmos5l_decap_8
Xhold294 hold294/X _0928_/Y vccd vssd sg13cmos5l_dlygate4sd3_1
XFILLER_8_2233 vccd vssd sg13cmos5l_decap_8
XFILLER_4_1407 vccd vssd sg13cmos5l_decap_8
XFILLER_8_1554 vccd vssd sg13cmos5l_decap_8
XFILLER_41_2394 vccd vssd sg13cmos5l_decap_8
XFILLER_2_1120 vccd vssd sg13cmos5l_decap_8
XFILLER_45_168 vccd vssd sg13cmos5l_decap_8
XFILLER_33_308 vccd vssd sg13cmos5l_decap_8
XFILLER_22_1092 vccd vssd sg13cmos5l_decap_8
XFILLER_27_883 vccd vssd sg13cmos5l_decap_8
XFILLER_26_371 vccd vssd sg13cmos5l_decap_8
XFILLER_2_1197 vccd vssd sg13cmos5l_decap_8
XFILLER_14_511 vccd vssd sg13cmos5l_decap_8
XFILLER_42_842 vccd vssd sg13cmos5l_decap_8
XFILLER_18_1106 vccd vssd sg13cmos5l_decap_8
XFILLER_35_2154 vccd vssd sg13cmos5l_decap_8
XFILLER_35_1431 vccd vssd sg13cmos5l_decap_4
XFILLER_31_2007 vccd vssd sg13cmos5l_decap_8
XFILLER_15_2739 vccd vssd sg13cmos5l_decap_4
XFILLER_14_588 vccd vssd sg13cmos5l_decap_8
XFILLER_14_70 vccd vssd sg13cmos5l_decap_8
XFILLER_6_721 vccd vssd sg13cmos5l_decap_8
XFILLER_5_231 vccd vssd sg13cmos5l_decap_8
XFILLER_13_2496 vccd vssd sg13cmos5l_decap_8
XFILLER_30_91 vccd vssd sg13cmos5l_decap_8
XFILLER_29_1213 vccd vssd sg13cmos5l_decap_8
XFILLER_6_798 vccd vssd sg13cmos5l_decap_8
X_1330_ _1330_/Y _1328_/Y _1327_/Y _1329_/Y vccd vssd sg13cmos5l_o21ai_1
XFILLER_29_1235 vccd vssd sg13cmos5l_decap_8
XFILLER_42_2125 vccd vssd sg13cmos5l_decap_4
X_1261_ _1265_/A status[82] _1261_/B vccd vssd sg13cmos5l_nand2_1
XFILLER_20_2401 vccd vssd sg13cmos5l_decap_8
XFILLER_37_614 vccd vssd sg13cmos5l_decap_8
X_1192_ _1192_/Y _1776_/Q _1192_/B vccd vssd sg13cmos5l_nor2_1
XFILLER_0_2506 vccd vssd sg13cmos5l_decap_8
XFILLER_4_2653 vccd vssd sg13cmos5l_decap_8
XFILLER_7_1064 vccd vssd sg13cmos5l_decap_8
XFILLER_20_2478 vccd vssd sg13cmos5l_decap_8
XFILLER_40_1181 vccd vssd sg13cmos5l_decap_8
XFILLER_36_168 vccd vssd sg13cmos5l_decap_8
XFILLER_24_308 vccd vssd sg13cmos5l_decap_8
XFILLER_20_1766 vccd vssd sg13cmos5l_decap_8
XFILLER_18_861 vccd vssd sg13cmos5l_decap_8
XFILLER_0_1827 vccd vssd sg13cmos5l_decap_8
XFILLER_4_1974 vccd vssd sg13cmos5l_decap_8
XFILLER_17_371 vccd vssd sg13cmos5l_decap_8
XFILLER_36_1228 vccd vssd sg13cmos5l_decap_8
XFILLER_18_2385 vccd vssd sg13cmos5l_decap_8
XFILLER_32_385 vccd vssd sg13cmos5l_decap_8
XFILLER_20_525 vccd vssd sg13cmos5l_decap_8
XFILLER_18_1673 vccd vssd sg13cmos5l_decap_8
XFILLER_31_2563 vccd vssd sg13cmos5l_decap_8
X_0976_ _1058_/B _0985_/A _1074_/A vccd vssd sg13cmos5l_nand2_1
XFILLER_14_1526 vccd vssd sg13cmos5l_decap_8
XFILLER_9_581 vccd vssd sg13cmos5l_decap_8
Xoutbuffers\[86\] control[86] _1754_/Q vccd vssd sg13cmos5l_buf_8
XFILLER_10_28 vccd vssd sg13cmos5l_decap_8
XFILLER_29_1780 vccd vssd sg13cmos5l_decap_8
X_1528_ _1528_/Y _1528_/A _1528_/B vccd vssd sg13cmos5l_nor2_1
XFILLER_25_2356 vccd vssd sg13cmos5l_decap_8
XFILLER_9_1841 vccd vssd sg13cmos5l_decap_8
X_1459_ _1459_/X hold520/X hold310/X _1461_/S vccd vssd sg13cmos5l_mux2_1
XFILLER_9_2597 vccd vssd sg13cmos5l_decap_8
XFILLER_45_1092 vccd vssd sg13cmos5l_decap_8
XFILLER_42_2692 vccd vssd sg13cmos5l_decap_8
XFILLER_21_1508 vccd vssd sg13cmos5l_decap_8
XFILLER_28_658 vccd vssd sg13cmos5l_decap_8
XFILLER_3_2163 vccd vssd sg13cmos5l_decap_8
XFILLER_43_606 vccd vssd sg13cmos5l_decap_8
XFILLER_38_2728 vccd vssd sg13cmos5l_decap_8
XFILLER_35_14 vccd vssd sg13cmos5l_decap_8
XFILLER_27_168 vccd vssd sg13cmos5l_decap_8
XFILLER_15_308 vccd vssd sg13cmos5l_decap_8
XFILLER_42_105 vccd vssd sg13cmos5l_decap_8
XFILLER_3_1484 vccd vssd sg13cmos5l_decap_8
XFILLER_36_2463 vccd vssd sg13cmos5l_decap_8
XFILLER_32_2305 vccd vssd sg13cmos5l_decap_8
XFILLER_24_875 vccd vssd sg13cmos5l_decap_8
XFILLER_32_1604 vccd vssd sg13cmos5l_decap_8
XFILLER_23_385 vccd vssd sg13cmos5l_decap_8
XFILLER_11_525 vccd vssd sg13cmos5l_decap_8
XFILLER_17_1183 vccd vssd sg13cmos5l_decap_8
XFILLER_7_518 vccd vssd sg13cmos5l_decap_8
XFILLER_30_2062 vccd vssd sg13cmos5l_decap_8
XFILLER_13_1036 vccd vssd sg13cmos5l_decap_8
XFILLER_10_1946 vccd vssd sg13cmos5l_decap_8
XFILLER_3_735 vccd vssd sg13cmos5l_decap_8
XFILLER_2_245 vccd vssd sg13cmos5l_decap_8
XFILLER_8_2030 vccd vssd sg13cmos5l_decap_8
Xclkbuf_5_16_0_SCK _1675_/CLK clkbuf_3_4_0_SCK/X vccd vssd sg13cmos5l_buf_8
XFILLER_26_1419 vccd vssd sg13cmos5l_decap_8
XFILLER_43_2456 vccd vssd sg13cmos5l_decap_4
XFILLER_43_1733 vccd vssd sg13cmos5l_decap_8
XFILLER_8_1351 vccd vssd sg13cmos5l_decap_8
XFILLER_4_1204 vccd vssd sg13cmos5l_decap_8
Xtiedowns\[18\] status[18] vccd vssd sg13cmos5l_antennanp
XFILLER_21_2776 vccd vssd sg13cmos5l_decap_8
XFILLER_20_1029 vccd vssd sg13cmos5l_decap_8
XFILLER_19_658 vccd vssd sg13cmos5l_decap_8
XFILLER_34_606 vccd vssd sg13cmos5l_decap_8
XFILLER_18_168 vccd vssd sg13cmos5l_decap_8
XFILLER_33_105 vccd vssd sg13cmos5l_decap_8
XFILLER_19_2650 vccd vssd sg13cmos5l_decap_8
XFILLER_37_1537 vccd vssd sg13cmos5l_decap_4
XFILLER_30_812 vccd vssd sg13cmos5l_decap_8
XFILLER_15_2514 vccd vssd sg13cmos5l_decap_4
XFILLER_15_875 vccd vssd sg13cmos5l_decap_8
XFILLER_41_182 vccd vssd sg13cmos5l_decap_8
XFILLER_25_91 vccd vssd sg13cmos5l_decap_8
XFILLER_19_1993 vccd vssd sg13cmos5l_decap_8
XFILLER_15_1813 vccd vssd sg13cmos5l_decap_8
XFILLER_14_385 vccd vssd sg13cmos5l_decap_8
XFILLER_31_1103 vccd vssd sg13cmos5l_decap_8
X_0830_ _0830_/Y _0830_/A vccd vssd sg13cmos5l_inv_1
XFILLER_6_595 vccd vssd sg13cmos5l_decap_8
XFILLER_26_2621 vccd vssd sg13cmos5l_decap_8
X_1313_ _1313_/Y _1311_/X _1307_/Y _1312_/Y vccd vssd sg13cmos5l_o21ai_1
XFILLER_26_2698 vccd vssd sg13cmos5l_decap_8
XFILLER_22_2529 vccd vssd sg13cmos5l_decap_8
XFILLER_9_1148 vccd vssd sg13cmos5l_decap_8
XFILLER_42_1221 vccd vssd sg13cmos5l_decap_8
X_1244_ _1244_/X _1244_/A _1244_/B vccd vssd sg13cmos5l_or2_1
XFILLER_26_1975 vccd vssd sg13cmos5l_decap_8
XFILLER_4_2450 vccd vssd sg13cmos5l_decap_8
XFILLER_2_84 vccd vssd sg13cmos5l_decap_8
XFILLER_0_2303 vccd vssd sg13cmos5l_decap_8
XFILLER_42_1298 vccd vssd sg13cmos5l_decap_4
XFILLER_38_967 vccd vssd sg13cmos5l_decap_8
XFILLER_20_2264 vccd vssd sg13cmos5l_decap_8
X_1175_ _1661_/D hold181/X _0945_/Y _1174_/Y vccd vssd sg13cmos5l_a21oi_1
XFILLER_4_1771 vccd vssd sg13cmos5l_decap_8
XFILLER_24_105 vccd vssd sg13cmos5l_decap_8
XFILLER_20_1563 vccd vssd sg13cmos5l_decap_8
XFILLER_0_1624 vccd vssd sg13cmos5l_decap_8
XFILLER_37_2772 vccd vssd sg13cmos5l_decap_8
XFILLER_33_683 vccd vssd sg13cmos5l_decap_4
XFILLER_21_812 vccd vssd sg13cmos5l_decap_8
XFILLER_14_2002 vccd vssd sg13cmos5l_decap_8
XFILLER_33_2636 vccd vssd sg13cmos5l_decap_8
XFILLER_32_182 vccd vssd sg13cmos5l_decap_8
XFILLER_20_322 vccd vssd sg13cmos5l_decap_8
XFILLER_18_2193 vccd vssd sg13cmos5l_decap_8
XFILLER_33_1946 vccd vssd sg13cmos5l_decap_8
XFILLER_21_889 vccd vssd sg13cmos5l_decap_8
XFILLER_18_1470 vccd vssd sg13cmos5l_decap_8
XFILLER_14_1323 vccd vssd sg13cmos5l_decap_8
XFILLER_31_2382 vccd vssd sg13cmos5l_decap_8
XFILLER_20_399 vccd vssd sg13cmos5l_decap_8
XFILLER_14_2079 vccd vssd sg13cmos5l_decap_8
X_0959_ _1067_/A _1046_/A _1070_/A vccd vssd sg13cmos5l_nor2_1
XFILLER_21_49 vccd vssd sg13cmos5l_decap_8
XFILLER_27_2429 vccd vssd sg13cmos5l_decap_8
XFILLER_44_2765 vccd vssd sg13cmos5l_decap_8
XFILLER_43_1018 vccd vssd sg13cmos5l_decap_8
XFILLER_25_2164 vccd vssd sg13cmos5l_decap_8
XFILLER_0_749 vccd vssd sg13cmos5l_decap_8
XFILLER_9_2394 vccd vssd sg13cmos5l_decap_8
XFILLER_25_1452 vccd vssd sg13cmos5l_decap_8
XFILLER_5_2247 vccd vssd sg13cmos5l_decap_8
XFILLER_21_1316 vccd vssd sg13cmos5l_decap_8
XFILLER_5_1568 vccd vssd sg13cmos5l_decap_8
XFILLER_44_915 vccd vssd sg13cmos5l_decap_8
XFILLER_28_455 vccd vssd sg13cmos5l_decap_8
XFILLER_38_2525 vccd vssd sg13cmos5l_decap_8
XFILLER_3_1281 vccd vssd sg13cmos5l_decap_8
XFILLER_15_105 vccd vssd sg13cmos5l_decap_8
XFILLER_30_119 vccd vssd sg13cmos5l_decap_8
XFILLER_24_672 vccd vssd sg13cmos5l_decap_8
XFILLER_12_812 vccd vssd sg13cmos5l_decap_8
XFILLER_36_2293 vccd vssd sg13cmos5l_decap_8
XFILLER_23_182 vccd vssd sg13cmos5l_decap_8
XFILLER_19_1267 vccd vssd sg13cmos5l_decap_8
XFILLER_8_805 vccd vssd sg13cmos5l_decap_8
XFILLER_11_322 vccd vssd sg13cmos5l_decap_8
XFILLER_32_1401 vccd vssd sg13cmos5l_decap_8
XFILLER_7_315 vccd vssd sg13cmos5l_decap_8
XFILLER_12_889 vccd vssd sg13cmos5l_decap_8
XFILLER_32_1456 vccd vssd sg13cmos5l_decap_8
XFILLER_10_2422 vccd vssd sg13cmos5l_decap_8
XFILLER_11_399 vccd vssd sg13cmos5l_decap_8
XFILLER_10_1743 vccd vssd sg13cmos5l_decap_8
XFILLER_10_2466 vccd vssd sg13cmos5l_decap_8
XFILLER_14_1890 vccd vssd sg13cmos5l_decap_8
XFILLER_3_532 vccd vssd sg13cmos5l_decap_8
XFILLER_2_0 vccd vssd sg13cmos5l_decap_8
XFILLER_45_1806 vccd vssd sg13cmos5l_decap_8
XFILLER_4_1001 vccd vssd sg13cmos5l_decap_8
XFILLER_21_2573 vccd vssd sg13cmos5l_decap_8
XFILLER_19_455 vccd vssd sg13cmos5l_decap_8
XFILLER_1_1911 vccd vssd sg13cmos5l_decap_8
XFILLER_21_1883 vccd vssd sg13cmos5l_decap_8
XFILLER_1_2667 vccd vssd sg13cmos5l_decap_8
XFILLER_4_1078 vccd vssd sg13cmos5l_decap_8
XFILLER_34_447 vccd vssd sg13cmos5l_decap_4
XFILLER_17_2609 vccd vssd sg13cmos5l_decap_8
XFILLER_1_1988 vccd vssd sg13cmos5l_decap_8
XFILLER_37_2068 vccd vssd sg13cmos5l_decap_8
XFILLER_22_609 vccd vssd sg13cmos5l_decap_8
XFILLER_15_672 vccd vssd sg13cmos5l_decap_8
XFILLER_37_1356 vccd vssd sg13cmos5l_decap_4
XFILLER_21_119 vccd vssd sg13cmos5l_decap_8
XFILLER_14_182 vccd vssd sg13cmos5l_decap_8
XFILLER_30_653 vccd vssd sg13cmos5l_decap_8
XFILLER_15_1610 vccd vssd sg13cmos5l_decap_8
XFILLER_30_686 vccd vssd sg13cmos5l_decap_8
XFILLER_15_2388 vccd vssd sg13cmos5l_decap_8
X_1793_ _1793_/Q _1793_/CLK _1793_/D fanout118/X vccd vssd sg13cmos5l_dfrbpq_1
XFILLER_15_1687 vccd vssd sg13cmos5l_decap_8
XFILLER_7_882 vccd vssd sg13cmos5l_decap_8
XFILLER_28_2749 vccd vssd sg13cmos5l_decap_8
XFILLER_6_392 vccd vssd sg13cmos5l_decap_8
XFILLER_35_0 vccd vssd sg13cmos5l_decap_8
XFILLER_6_2534 vccd vssd sg13cmos5l_decap_8
XFILLER_22_2315 vccd vssd sg13cmos5l_decap_8
XFILLER_42_1040 vccd vssd sg13cmos5l_decap_8
Xoutbuffers\[49\] control[49] _1717_/Q vccd vssd sg13cmos5l_buf_8
XFILLER_6_1855 vccd vssd sg13cmos5l_decap_8
X_1227_ _1227_/Y _0855_/Y _1315_/B1 _1226_/Y _1225_/Y vccd vssd sg13cmos5l_a22oi_1
XFILLER_38_753 vccd vssd sg13cmos5l_decap_4
XFILLER_22_1669 vccd vssd sg13cmos5l_decap_8
XFILLER_2_1708 vccd vssd sg13cmos5l_decap_8
XFILLER_0_2100 vccd vssd sg13cmos5l_decap_8
XFILLER_38_786 vccd vssd sg13cmos5l_decap_8
XFILLER_37_252 vccd vssd sg13cmos5l_decap_8
X_1158_ _1158_/Y _0863_/Y _1372_/B1 _1157_/Y _1156_/Y vccd vssd sg13cmos5l_a22oi_1
XFILLER_0_1421 vccd vssd sg13cmos5l_decap_8
XFILLER_20_1393 vccd vssd sg13cmos5l_decap_8
XFILLER_16_49 vccd vssd sg13cmos5l_decap_8
XFILLER_0_2177 vccd vssd sg13cmos5l_decap_8
X_1089_ _1089_/Y _1089_/A _1089_/B _1089_/C vccd vssd sg13cmos5l_nand3_1
XFILLER_41_929 vccd vssd sg13cmos5l_decap_8
XFILLER_40_406 vccd vssd sg13cmos5l_decap_8
XFILLER_25_469 vccd vssd sg13cmos5l_decap_8
XFILLER_0_1498 vccd vssd sg13cmos5l_decap_8
XFILLER_13_609 vccd vssd sg13cmos5l_decap_8
XFILLER_33_2411 vccd vssd sg13cmos5l_decap_8
XFILLER_16_1407 vccd vssd sg13cmos5l_decap_8
XFILLER_12_119 vccd vssd sg13cmos5l_decap_8
XFILLER_37_1890 vccd vssd sg13cmos5l_decap_8
XFILLER_33_2455 vccd vssd sg13cmos5l_decap_8
XFILLER_21_686 vccd vssd sg13cmos5l_decap_8
XFILLER_11_2720 vccd vssd sg13cmos5l_decap_8
XFILLER_14_1120 vccd vssd sg13cmos5l_decap_8
XFILLER_20_196 vccd vssd sg13cmos5l_decap_8
XFILLER_5_819 vccd vssd sg13cmos5l_decap_8
XFILLER_4_329 vccd vssd sg13cmos5l_decap_8
XFILLER_14_1197 vccd vssd sg13cmos5l_decap_8
XFILLER_27_2237 vccd vssd sg13cmos5l_decap_8
XFILLER_44_2562 vccd vssd sg13cmos5l_decap_8
XFILLER_27_1525 vccd vssd sg13cmos5l_decap_8
XFILLER_0_546 vccd vssd sg13cmos5l_decap_8
XFILLER_40_2415 vccd vssd sg13cmos5l_decap_8
XFILLER_5_2044 vccd vssd sg13cmos5l_decap_8
XFILLER_9_2191 vccd vssd sg13cmos5l_decap_8
XFILLER_40_1725 vccd vssd sg13cmos5l_decap_8
XFILLER_21_1113 vccd vssd sg13cmos5l_decap_8
XFILLER_5_1365 vccd vssd sg13cmos5l_decap_8
XFILLER_44_712 vccd vssd sg13cmos5l_decap_8
XFILLER_28_252 vccd vssd sg13cmos5l_decap_8
XFILLER_1_1218 vccd vssd sg13cmos5l_decap_8
XFILLER_44_756 vccd vssd sg13cmos5l_decap_8
XFILLER_17_959 vccd vssd sg13cmos5l_decap_8
XFILLER_38_1643 vccd vssd sg13cmos5l_decap_8
XFILLER_32_918 vccd vssd sg13cmos5l_decap_8
XFILLER_31_406 vccd vssd sg13cmos5l_decap_8
XFILLER_16_469 vccd vssd sg13cmos5l_decap_8
XFILLER_40_940 vccd vssd sg13cmos5l_decap_8
XFILLER_19_1064 vccd vssd sg13cmos5l_decap_8
XFILLER_16_1930 vccd vssd sg13cmos5l_decap_8
XFILLER_8_602 vccd vssd sg13cmos5l_decap_8
Xtiedowns\[85\] status[85] vccd vssd sg13cmos5l_antennanp
XFILLER_32_1220 vccd vssd sg13cmos5l_decap_8
XFILLER_7_112 vccd vssd sg13cmos5l_decap_8
XFILLER_12_686 vccd vssd sg13cmos5l_decap_8
XFILLER_12_2528 vccd vssd sg13cmos5l_decap_8
XFILLER_22_70 vccd vssd sg13cmos5l_decap_8
XFILLER_8_679 vccd vssd sg13cmos5l_decap_8
XFILLER_11_196 vccd vssd sg13cmos5l_decap_8
XFILLER_12_1827 vccd vssd sg13cmos5l_decap_8
XFILLER_7_189 vccd vssd sg13cmos5l_decap_8
XFILLER_10_1540 vccd vssd sg13cmos5l_decap_8
XFILLER_10_2296 vccd vssd sg13cmos5l_decap_8
XFILLER_45_1603 vccd vssd sg13cmos5l_decap_8
XFILLER_4_896 vccd vssd sg13cmos5l_decap_8
XFILLER_45_2359 vccd vssd sg13cmos5l_decap_8
XFILLER_26_1013 vccd vssd sg13cmos5l_decap_8
XFILLER_23_2613 vccd vssd sg13cmos5l_decap_8
XFILLER_26_1068 vccd vssd sg13cmos5l_decap_8
X_1012_ _1012_/Y status[31] _1144_/B _1232_/B vccd vssd sg13cmos5l_a21oi_1
XFILLER_35_723 vccd vssd sg13cmos5l_decap_4
XFILLER_21_2370 vccd vssd sg13cmos5l_decap_8
XFILLER_19_252 vccd vssd sg13cmos5l_decap_8
XFILLER_1_2464 vccd vssd sg13cmos5l_decap_8
XFILLER_34_266 vccd vssd sg13cmos5l_decap_8
XFILLER_22_406 vccd vssd sg13cmos5l_decap_8
XFILLER_17_2406 vccd vssd sg13cmos5l_decap_8
XFILLER_1_1785 vccd vssd sg13cmos5l_decap_8
XFILLER_37_1142 vccd vssd sg13cmos5l_decap_8
XFILLER_34_2742 vccd vssd sg13cmos5l_decap_8
XFILLER_33_1017 vccd vssd sg13cmos5l_decap_8
XFILLER_31_995 vccd vssd sg13cmos5l_decap_8
XFILLER_30_2617 vccd vssd sg13cmos5l_decap_8
XFILLER_11_2016 vccd vssd sg13cmos5l_decap_8
XFILLER_30_494 vccd vssd sg13cmos5l_decap_8
XFILLER_15_2196 vccd vssd sg13cmos5l_decap_8
X_1776_ _1776_/Q clkload6/A _1776_/D fanout118/X vccd vssd sg13cmos5l_dfrbpq_1
XFILLER_15_1484 vccd vssd sg13cmos5l_decap_8
XFILLER_11_1337 vccd vssd sg13cmos5l_decap_8
XFILLER_28_2513 vccd vssd sg13cmos5l_decap_8
XFILLER_28_1812 vccd vssd sg13cmos5l_decap_8
XFILLER_28_1889 vccd vssd sg13cmos5l_decap_8
XFILLER_6_2331 vccd vssd sg13cmos5l_decap_8
XFILLER_8_1939 vccd vssd sg13cmos5l_decap_8
XFILLER_44_1168 vccd vssd sg13cmos5l_decap_8
XFILLER_41_2768 vccd vssd sg13cmos5l_decap_8
XFILLER_22_2134 vccd vssd sg13cmos5l_decap_8
XFILLER_22_2167 vccd vssd sg13cmos5l_decap_8
XFILLER_2_1505 vccd vssd sg13cmos5l_decap_8
XFILLER_6_1652 vccd vssd sg13cmos5l_decap_8
XFILLER_26_734 vccd vssd sg13cmos5l_decap_4
XFILLER_22_1499 vccd vssd sg13cmos5l_decap_8
XFILLER_43_14 vccd vssd sg13cmos5l_decap_8
XFILLER_39_2675 vccd vssd sg13cmos5l_decap_8
XFILLER_25_266 vccd vssd sg13cmos5l_decap_8
XFILLER_20_1190 vccd vssd sg13cmos5l_decap_8
XFILLER_13_406 vccd vssd sg13cmos5l_decap_8
XFILLER_41_726 vccd vssd sg13cmos5l_decap_8
XFILLER_39_1985 vccd vssd sg13cmos5l_decap_8
XFILLER_40_203 vccd vssd sg13cmos5l_decap_8
XFILLER_35_2539 vccd vssd sg13cmos5l_decap_8
XFILLER_0_1295 vccd vssd sg13cmos5l_decap_8
XFILLER_16_1204 vccd vssd sg13cmos5l_decap_8
XFILLER_22_973 vccd vssd sg13cmos5l_decap_8
XFILLER_33_2285 vccd vssd sg13cmos5l_decap_8
XFILLER_21_483 vccd vssd sg13cmos5l_decap_8
XFILLER_5_616 vccd vssd sg13cmos5l_decap_8
XFILLER_4_126 vccd vssd sg13cmos5l_decap_8
XFILLER_27_2023 vccd vssd sg13cmos5l_decap_8
XFILLER_27_1322 vccd vssd sg13cmos5l_decap_8
XFILLER_1_833 vccd vssd sg13cmos5l_decap_8
XFILLER_7_2128 vccd vssd sg13cmos5l_decap_8
XFILLER_42_1809 vccd vssd sg13cmos5l_decap_8
XFILLER_40_2201 vccd vssd sg13cmos5l_decap_8
XFILLER_0_343 vccd vssd sg13cmos5l_decap_8
XFILLER_7_1449 vccd vssd sg13cmos5l_decap_8
XFILLER_40_1522 vccd vssd sg13cmos5l_decap_8
XFILLER_40_2289 vccd vssd sg13cmos5l_decap_8
XFILLER_29_572 vccd vssd sg13cmos5l_decap_8
XFILLER_22_2690 vccd vssd sg13cmos5l_decap_8
XFILLER_2_2751 vccd vssd sg13cmos5l_decap_8
XFILLER_1_1015 vccd vssd sg13cmos5l_decap_8
XFILLER_5_1162 vccd vssd sg13cmos5l_decap_8
XFILLER_40_1599 vccd vssd sg13cmos5l_decap_8
XFILLER_17_756 vccd vssd sg13cmos5l_decap_8
XFILLER_44_564 vccd vssd sg13cmos5l_decap_8
XFILLER_18_2715 vccd vssd sg13cmos5l_decap_8
XFILLER_17_70 vccd vssd sg13cmos5l_decap_8
XFILLER_16_266 vccd vssd sg13cmos5l_decap_8
XFILLER_31_203 vccd vssd sg13cmos5l_decap_8
XFILLER_38_1484 vccd vssd sg13cmos5l_decap_8
XFILLER_16_2472 vccd vssd sg13cmos5l_decap_8
XFILLER_12_2314 vccd vssd sg13cmos5l_decap_8
XFILLER_13_973 vccd vssd sg13cmos5l_decap_8
XFILLER_33_91 vccd vssd sg13cmos5l_decap_8
XFILLER_16_1771 vccd vssd sg13cmos5l_decap_8
XFILLER_9_966 vccd vssd sg13cmos5l_decap_8
XFILLER_12_483 vccd vssd sg13cmos5l_decap_8
X_1630_ _1630_/Y _1639_/A _1639_/B_N vccd vssd sg13cmos5l_nor2b_1
XFILLER_8_476 vccd vssd sg13cmos5l_decap_8
XFILLER_12_1624 vccd vssd sg13cmos5l_decap_8
X_1561_ _1561_/Y hold251/X _1567_/S _1560_/Y vccd vssd sg13cmos5l_a21oi_1
XFILLER_10_2093 vccd vssd sg13cmos5l_decap_8
XFILLER_45_2156 vccd vssd sg13cmos5l_decap_8
XFILLER_45_1400 vccd vssd sg13cmos5l_decap_8
X_1492_ _1719_/D hold227/X _1497_/S _1491_/Y vccd vssd sg13cmos5l_a21oi_1
XFILLER_28_1119 vccd vssd sg13cmos5l_decap_8
XFILLER_4_693 vccd vssd sg13cmos5l_decap_8
XFILLER_23_2410 vccd vssd sg13cmos5l_decap_8
XFILLER_7_2640 vccd vssd sg13cmos5l_decap_8
XFILLER_45_1477 vccd vssd sg13cmos5l_decap_8
XFILLER_39_336 vccd vssd sg13cmos5l_decap_8
XFILLER_23_2487 vccd vssd sg13cmos5l_decap_8
XFILLER_23_1720 vccd vssd sg13cmos5l_decap_8
XFILLER_3_2548 vccd vssd sg13cmos5l_decap_8
XFILLER_23_1797 vccd vssd sg13cmos5l_decap_8
XFILLER_3_1869 vccd vssd sg13cmos5l_decap_8
XFILLER_1_2261 vccd vssd sg13cmos5l_decap_8
XFILLER_39_1215 vccd vssd sg13cmos5l_decap_8
XFILLER_35_542 vccd vssd sg13cmos5l_decap_8
Xfanout29 _1453_/B _1048_/X vccd vssd sg13cmos5l_buf_1
Xfanout18 _1428_/S _1426_/S vccd vssd sg13cmos5l_buf_1
XFILLER_22_203 vccd vssd sg13cmos5l_decap_8
XFILLER_1_1582 vccd vssd sg13cmos5l_decap_8
XFILLER_17_1568 vccd vssd sg13cmos5l_decap_8
XFILLER_13_28 vccd vssd sg13cmos5l_decap_8
XFILLER_34_1871 vccd vssd sg13cmos5l_decap_8
XFILLER_30_280 vccd vssd sg13cmos5l_decap_8
XFILLER_30_2469 vccd vssd sg13cmos5l_decap_8
XFILLER_15_1281 vccd vssd sg13cmos5l_decap_8
Xhold410 _1677_/D _1432_/X vccd vssd sg13cmos5l_dlygate4sd3_1
XFILLER_11_1134 vccd vssd sg13cmos5l_decap_8
X_1759_ _1759_/Q _1763_/CLK _1759_/D fanout119/X vccd vssd sg13cmos5l_dfrbpq_1
Xhold421 hold421/X _1744_/Q vccd vssd sg13cmos5l_dlygate4sd3_1
Xhold432 _1749_/D _1534_/X vccd vssd sg13cmos5l_dlygate4sd3_1
Xhold443 hold443/X _1714_/Q vccd vssd sg13cmos5l_dlygate4sd3_1
Xhold454 _0942_/A _0940_/Y vccd vssd sg13cmos5l_dlygate4sd3_1
Xhold476 hold476/X _1790_/Q vccd vssd sg13cmos5l_dlygate4sd3_1
Xhold487 _1777_/D _1575_/X vccd vssd sg13cmos5l_dlygate4sd3_1
XFILLER_28_2343 vccd vssd sg13cmos5l_decap_8
Xhold465 hold465/X _1569_/Y vccd vssd sg13cmos5l_dlygate4sd3_1
XFILLER_8_2415 vccd vssd sg13cmos5l_decap_8
Xhold498 hold498/X _1778_/Q vccd vssd sg13cmos5l_dlygate4sd3_1
XFILLER_38_14 vccd vssd sg13cmos5l_decap_8
XFILLER_28_1686 vccd vssd sg13cmos5l_decap_8
XFILLER_24_1517 vccd vssd sg13cmos5l_decap_8
XFILLER_8_1736 vccd vssd sg13cmos5l_decap_8
XFILLER_41_2565 vccd vssd sg13cmos5l_decap_8
XFILLER_41_1831 vccd vssd sg13cmos5l_decap_8
XFILLER_22_1252 vccd vssd sg13cmos5l_decap_8
XFILLER_2_2058 vccd vssd sg13cmos5l_decap_8
XFILLER_2_1302 vccd vssd sg13cmos5l_decap_8
XFILLER_26_553 vccd vssd sg13cmos5l_decap_8
XFILLER_2_1379 vccd vssd sg13cmos5l_decap_8
XFILLER_41_512 vccd vssd sg13cmos5l_decap_8
XFILLER_39_2472 vccd vssd sg13cmos5l_decap_8
XFILLER_26_597 vccd vssd sg13cmos5l_decap_8
XFILLER_13_203 vccd vssd sg13cmos5l_decap_8
XFILLER_16_1001 vccd vssd sg13cmos5l_decap_8
XFILLER_0_1092 vccd vssd sg13cmos5l_decap_8
XFILLER_22_770 vccd vssd sg13cmos5l_decap_8
XFILLER_10_910 vccd vssd sg13cmos5l_decap_8
XFILLER_13_2612 vccd vssd sg13cmos5l_decap_8
XFILLER_33_2093 vccd vssd sg13cmos5l_decap_8
XFILLER_21_280 vccd vssd sg13cmos5l_decap_8
XFILLER_16_1078 vccd vssd sg13cmos5l_decap_8
XFILLER_6_903 vccd vssd sg13cmos5l_decap_8
XFILLER_13_1911 vccd vssd sg13cmos5l_decap_8
XFILLER_33_1370 vccd vssd sg13cmos5l_decap_8
XFILLER_5_413 vccd vssd sg13cmos5l_decap_8
XFILLER_10_987 vccd vssd sg13cmos5l_decap_8
XFILLER_13_2667 vccd vssd sg13cmos5l_decap_8
XFILLER_13_1988 vccd vssd sg13cmos5l_decap_8
Xtiedowns\[48\] status[48] vccd vssd sg13cmos5l_antennanp
XFILLER_1_630 vccd vssd sg13cmos5l_decap_8
XFILLER_27_1152 vccd vssd sg13cmos5l_decap_8
XFILLER_24_2741 vccd vssd sg13cmos5l_decap_8
XFILLER_0_140 vccd vssd sg13cmos5l_decap_8
XFILLER_40_2053 vccd vssd sg13cmos5l_decap_8
XFILLER_7_1246 vccd vssd sg13cmos5l_decap_8
XFILLER_23_1049 vccd vssd sg13cmos5l_decap_8
XFILLER_45_840 vccd vssd sg13cmos5l_decap_8
XFILLER_40_1374 vccd vssd sg13cmos5l_decap_8
XFILLER_28_91 vccd vssd sg13cmos5l_decap_8
XFILLER_17_553 vccd vssd sg13cmos5l_decap_8
XFILLER_32_567 vccd vssd sg13cmos5l_decap_8
XFILLER_20_707 vccd vssd sg13cmos5l_decap_8
X_0992_ _0992_/Y _1137_/B _1197_/C vccd vssd sg13cmos5l_nor2_1
XFILLER_38_1292 vccd vssd sg13cmos5l_decap_8
XFILLER_12_2100 vccd vssd sg13cmos5l_decap_8
XFILLER_13_770 vccd vssd sg13cmos5l_decap_8
XFILLER_14_1708 vccd vssd sg13cmos5l_decap_8
XFILLER_34_1145 vccd vssd sg13cmos5l_decap_8
XFILLER_31_2745 vccd vssd sg13cmos5l_decap_8
XFILLER_16_2280 vccd vssd sg13cmos5l_decap_8
XFILLER_9_763 vccd vssd sg13cmos5l_decap_8
XFILLER_12_280 vccd vssd sg13cmos5l_decap_8
XFILLER_30_1009 vccd vssd sg13cmos5l_decap_8
XFILLER_8_273 vccd vssd sg13cmos5l_decap_8
XFILLER_12_1421 vccd vssd sg13cmos5l_decap_8
X_1613_ _1613_/Y _1644_/A _1644_/B_N vccd vssd sg13cmos5l_nor2b_1
XFILLER_12_1498 vccd vssd sg13cmos5l_decap_8
X_1544_ _1549_/S _1588_/A _1544_/B vccd vssd sg13cmos5l_nand2_1
XFILLER_5_980 vccd vssd sg13cmos5l_decap_8
XFILLER_9_2724 vccd vssd sg13cmos5l_decap_8
XFILLER_29_2685 vccd vssd sg13cmos5l_decap_8
XFILLER_25_2538 vccd vssd sg13cmos5l_decap_8
XFILLER_4_490 vccd vssd sg13cmos5l_decap_8
XFILLER_5_84 vccd vssd sg13cmos5l_decap_8
XFILLER_29_1995 vccd vssd sg13cmos5l_decap_8
X_1475_ _1475_/Y _1475_/A _1485_/S vccd vssd sg13cmos5l_nand2_1
XFILLER_25_1804 vccd vssd sg13cmos5l_decap_8
XFILLER_45_1274 vccd vssd sg13cmos5l_decap_8
XFILLER_39_133 vccd vssd sg13cmos5l_decap_8
XFILLER_7_2492 vccd vssd sg13cmos5l_decap_8
XFILLER_28_829 vccd vssd sg13cmos5l_decap_8
XFILLER_23_2295 vccd vssd sg13cmos5l_decap_8
XFILLER_3_2345 vccd vssd sg13cmos5l_decap_8
Xoutbuffers\[31\] control[31] _1699_/Q vccd vssd sg13cmos5l_buf_8
XFILLER_23_1583 vccd vssd sg13cmos5l_decap_8
XFILLER_36_862 vccd vssd sg13cmos5l_decap_8
XFILLER_35_350 vccd vssd sg13cmos5l_decap_8
XFILLER_3_1666 vccd vssd sg13cmos5l_decap_8
XFILLER_36_2623 vccd vssd sg13cmos5l_decap_8
XFILLER_17_2000 vccd vssd sg13cmos5l_decap_8
XFILLER_39_1056 vccd vssd sg13cmos5l_decap_8
XFILLER_36_1911 vccd vssd sg13cmos5l_decap_8
XFILLER_24_49 vccd vssd sg13cmos5l_decap_8
XFILLER_11_707 vccd vssd sg13cmos5l_decap_8
XFILLER_36_1966 vccd vssd sg13cmos5l_decap_8
XFILLER_23_567 vccd vssd sg13cmos5l_decap_8
XFILLER_17_2088 vccd vssd sg13cmos5l_decap_8
XFILLER_17_1365 vccd vssd sg13cmos5l_decap_8
XFILLER_10_217 vccd vssd sg13cmos5l_decap_8
XFILLER_30_1510 vccd vssd sg13cmos5l_decap_8
XFILLER_13_1218 vccd vssd sg13cmos5l_decap_8
XFILLER_34_1690 vccd vssd sg13cmos5l_decap_8
XFILLER_3_917 vccd vssd sg13cmos5l_decap_8
Xhold240 hold240/X _0875_/Y vccd vssd sg13cmos5l_dlygate4sd3_1
Xhold251 hold251/X _0844_/Y vccd vssd sg13cmos5l_dlygate4sd3_1
Xhold262 hold262/X _0841_/Y vccd vssd sg13cmos5l_dlygate4sd3_1
XFILLER_2_427 vccd vssd sg13cmos5l_decap_8
XFILLER_6_7 vccd vssd sg13cmos5l_decap_8
XFILLER_8_2212 vccd vssd sg13cmos5l_decap_8
Xhold273 _1722_/D _1496_/Y vccd vssd sg13cmos5l_dlygate4sd3_1
XFILLER_28_2151 vccd vssd sg13cmos5l_decap_8
Xhold295 _1800_/D hold538/X vccd vssd sg13cmos5l_dlygate4sd3_1
Xhold284 _0898_/C _1805_/Q vccd vssd sg13cmos5l_dlygate4sd3_1
XFILLER_8_1533 vccd vssd sg13cmos5l_decap_8
XFILLER_28_1494 vccd vssd sg13cmos5l_decap_8
XFILLER_8_2289 vccd vssd sg13cmos5l_decap_8
XFILLER_41_2373 vccd vssd sg13cmos5l_decap_8
XFILLER_24_1369 vccd vssd sg13cmos5l_decap_4
XFILLER_45_147 vccd vssd sg13cmos5l_decap_8
XFILLER_27_862 vccd vssd sg13cmos5l_decap_8
XFILLER_22_1071 vccd vssd sg13cmos5l_decap_8
XFILLER_42_821 vccd vssd sg13cmos5l_decap_8
XFILLER_26_350 vccd vssd sg13cmos5l_decap_8
XFILLER_2_1176 vccd vssd sg13cmos5l_decap_8
XFILLER_35_2133 vccd vssd sg13cmos5l_decap_8
XFILLER_15_2718 vccd vssd sg13cmos5l_decap_8
XFILLER_42_898 vccd vssd sg13cmos5l_decap_8
XFILLER_35_1410 vccd vssd sg13cmos5l_decap_8
XFILLER_14_567 vccd vssd sg13cmos5l_decap_8
XFILLER_41_386 vccd vssd sg13cmos5l_decap_8
XFILLER_6_700 vccd vssd sg13cmos5l_decap_8
XFILLER_5_210 vccd vssd sg13cmos5l_decap_8
XFILLER_10_784 vccd vssd sg13cmos5l_decap_8
XFILLER_6_777 vccd vssd sg13cmos5l_decap_8
XFILLER_13_1785 vccd vssd sg13cmos5l_decap_8
XFILLER_30_70 vccd vssd sg13cmos5l_decap_8
XFILLER_5_287 vccd vssd sg13cmos5l_decap_8
XFILLER_9_2009 vccd vssd sg13cmos5l_decap_8
XFILLER_39_7 vccd vssd sg13cmos5l_decap_8
XFILLER_2_994 vccd vssd sg13cmos5l_decap_8
XFILLER_42_2159 vccd vssd sg13cmos5l_decap_8
X_1260_ _1659_/D hold183/X _1390_/A _1259_/Y vccd vssd sg13cmos5l_a21oi_1
XFILLER_4_2632 vccd vssd sg13cmos5l_decap_8
XFILLER_7_1043 vccd vssd sg13cmos5l_decap_8
XFILLER_42_1458 vccd vssd sg13cmos5l_decap_8
X_1191_ _1191_/Y _1792_/Q _1588_/B _1189_/Y _1188_/Y _1190_/X vccd vssd sg13cmos5l_a221oi_1
XFILLER_24_1892 vccd vssd sg13cmos5l_decap_8
XFILLER_20_2457 vccd vssd sg13cmos5l_decap_8
XFILLER_4_1953 vccd vssd sg13cmos5l_decap_8
XFILLER_40_1160 vccd vssd sg13cmos5l_decap_8
XFILLER_36_147 vccd vssd sg13cmos5l_decap_8
XFILLER_20_1745 vccd vssd sg13cmos5l_decap_8
XFILLER_18_840 vccd vssd sg13cmos5l_decap_8
XFILLER_0_1806 vccd vssd sg13cmos5l_decap_8
Xoutbuffers\[121\] control[121] _1789_/Q vccd vssd sg13cmos5l_buf_8
XFILLER_17_350 vccd vssd sg13cmos5l_decap_8
XFILLER_36_1207 vccd vssd sg13cmos5l_decap_8
XFILLER_33_843 vccd vssd sg13cmos5l_decap_8
XFILLER_18_2331 vccd vssd sg13cmos5l_decap_8
XFILLER_33_887 vccd vssd sg13cmos5l_decap_8
XFILLER_32_364 vccd vssd sg13cmos5l_decap_8
XFILLER_20_504 vccd vssd sg13cmos5l_decap_8
XFILLER_18_1652 vccd vssd sg13cmos5l_decap_8
XFILLER_14_1505 vccd vssd sg13cmos5l_decap_8
X_0975_ _1000_/B status[71] _1314_/B vccd vssd sg13cmos5l_nand2_1
XFILLER_31_2542 vccd vssd sg13cmos5l_decap_8
XFILLER_9_560 vccd vssd sg13cmos5l_decap_8
XFILLER_12_1295 vccd vssd sg13cmos5l_decap_8
Xoutbuffers\[79\] control[79] _1747_/Q vccd vssd sg13cmos5l_buf_8
XFILLER_29_2482 vccd vssd sg13cmos5l_decap_8
X_1527_ _1527_/X _1506_/A hold336/X _1530_/S vccd vssd sg13cmos5l_mux2_1
XFILLER_25_2335 vccd vssd sg13cmos5l_decap_8
XFILLER_9_1820 vccd vssd sg13cmos5l_decap_8
XFILLER_45_1071 vccd vssd sg13cmos5l_decap_8
X_1458_ _1458_/X hold524/X hold332/X _1461_/S vccd vssd sg13cmos5l_mux2_1
XFILLER_5_2429 vccd vssd sg13cmos5l_decap_8
XFILLER_42_2671 vccd vssd sg13cmos5l_decap_8
XFILLER_19_49 vccd vssd sg13cmos5l_decap_8
XFILLER_3_2142 vccd vssd sg13cmos5l_decap_8
XFILLER_9_1897 vccd vssd sg13cmos5l_decap_8
XFILLER_28_637 vccd vssd sg13cmos5l_decap_8
XFILLER_23_2092 vccd vssd sg13cmos5l_decap_8
X_1389_ _1390_/C mask_rev_in[24] _1389_/A2 _1387_/Y _1388_/Y _1258_/B vccd vssd sg13cmos5l_a221oi_1
XFILLER_38_2707 vccd vssd sg13cmos5l_decap_8
XFILLER_27_147 vccd vssd sg13cmos5l_decap_8
XFILLER_3_1463 vccd vssd sg13cmos5l_decap_8
XFILLER_43_629 vccd vssd sg13cmos5l_decap_8
XFILLER_36_670 vccd vssd sg13cmos5l_decap_8
XFILLER_36_2442 vccd vssd sg13cmos5l_decap_8
XFILLER_24_854 vccd vssd sg13cmos5l_decap_8
XFILLER_36_1741 vccd vssd sg13cmos5l_decap_8
XFILLER_23_364 vccd vssd sg13cmos5l_decap_8
XFILLER_19_1449 vccd vssd sg13cmos5l_decap_8
XFILLER_11_504 vccd vssd sg13cmos5l_decap_8
XFILLER_17_1162 vccd vssd sg13cmos5l_decap_8
XFILLER_13_1015 vccd vssd sg13cmos5l_decap_8
XFILLER_10_1925 vccd vssd sg13cmos5l_decap_8
XFILLER_30_1384 vccd vssd sg13cmos5l_decap_8
XFILLER_3_714 vccd vssd sg13cmos5l_decap_8
XFILLER_2_224 vccd vssd sg13cmos5l_decap_8
XFILLER_8_1330 vccd vssd sg13cmos5l_decap_8
XFILLER_8_2086 vccd vssd sg13cmos5l_decap_8
XFILLER_41_2181 vccd vssd sg13cmos5l_decap_8
XFILLER_21_2755 vccd vssd sg13cmos5l_decap_8
XFILLER_20_1008 vccd vssd sg13cmos5l_decap_8
XFILLER_19_637 vccd vssd sg13cmos5l_decap_8
XFILLER_18_147 vccd vssd sg13cmos5l_decap_8
XFILLER_15_854 vccd vssd sg13cmos5l_decap_8
XFILLER_25_70 vccd vssd sg13cmos5l_decap_8
XFILLER_14_364 vccd vssd sg13cmos5l_decap_8
XFILLER_41_161 vccd vssd sg13cmos5l_decap_8
XFILLER_19_1972 vccd vssd sg13cmos5l_decap_8
XFILLER_15_2548 vccd vssd sg13cmos5l_decap_8
XFILLER_35_1284 vccd vssd sg13cmos5l_decap_8
XFILLER_15_1869 vccd vssd sg13cmos5l_decap_8
XFILLER_10_581 vccd vssd sg13cmos5l_decap_8
XFILLER_13_2283 vccd vssd sg13cmos5l_decap_8
XFILLER_41_91 vccd vssd sg13cmos5l_decap_8
XFILLER_31_1159 vccd vssd sg13cmos5l_decap_8
XFILLER_6_574 vccd vssd sg13cmos5l_decap_8
XFILLER_13_1582 vccd vssd sg13cmos5l_decap_8
XFILLER_29_1000 vccd vssd sg13cmos5l_decap_8
XFILLER_26_2600 vccd vssd sg13cmos5l_decap_8
XFILLER_9_1127 vccd vssd sg13cmos5l_decap_8
X_1312_ _1312_/Y status[73] _1362_/A2 _1314_/B vccd vssd sg13cmos5l_a21oi_1
XFILLER_42_1200 vccd vssd sg13cmos5l_decap_8
XFILLER_29_1088 vccd vssd sg13cmos5l_decap_8
XFILLER_26_2677 vccd vssd sg13cmos5l_decap_8
XFILLER_22_2508 vccd vssd sg13cmos5l_decap_8
XFILLER_2_791 vccd vssd sg13cmos5l_decap_8
XFILLER_6_2749 vccd vssd sg13cmos5l_decap_8
X_1243_ _1244_/B _1735_/Q _1038_/Y _1036_/Y vccd vssd sg13cmos5l_o21ai_1
XFILLER_26_1954 vccd vssd sg13cmos5l_decap_8
XFILLER_42_1277 vccd vssd sg13cmos5l_decap_8
XFILLER_38_946 vccd vssd sg13cmos5l_decap_8
XFILLER_37_434 vccd vssd sg13cmos5l_decap_8
XFILLER_2_63 vccd vssd sg13cmos5l_decap_8
Xtiedowns\[111\] status[111] vccd vssd sg13cmos5l_antennanp
XFILLER_20_1542 vccd vssd sg13cmos5l_decap_8
XFILLER_0_1603 vccd vssd sg13cmos5l_decap_8
XFILLER_4_1750 vccd vssd sg13cmos5l_decap_8
X_1174_ _1174_/Y _0829_/A _0888_/C _1217_/B _1173_/Y _0945_/Y vccd vssd sg13cmos5l_a221oi_1
XFILLER_37_489 vccd vssd sg13cmos5l_decap_8
XFILLER_0_2359 vccd vssd sg13cmos5l_decap_8
XFILLER_37_2751 vccd vssd sg13cmos5l_decap_8
XFILLER_33_2615 vccd vssd sg13cmos5l_decap_8
XFILLER_33_662 vccd vssd sg13cmos5l_decap_8
XFILLER_32_161 vccd vssd sg13cmos5l_decap_8
XFILLER_20_301 vccd vssd sg13cmos5l_decap_8
XFILLER_18_2172 vccd vssd sg13cmos5l_decap_8
XFILLER_21_868 vccd vssd sg13cmos5l_decap_8
XFILLER_14_1302 vccd vssd sg13cmos5l_decap_8
XFILLER_14_2058 vccd vssd sg13cmos5l_decap_8
XFILLER_31_2361 vccd vssd sg13cmos5l_decap_8
X_0958_ _1021_/B _0997_/B _0997_/A vccd vssd sg13cmos5l_nand2b_2
XFILLER_21_28 vccd vssd sg13cmos5l_decap_8
XFILLER_20_378 vccd vssd sg13cmos5l_decap_8
XFILLER_14_1379 vccd vssd sg13cmos5l_decap_8
XFILLER_27_2408 vccd vssd sg13cmos5l_decap_8
X_0889_ _0889_/Y _0889_/A _0889_/B vccd vssd sg13cmos5l_nor2_1
XFILLER_12_1092 vccd vssd sg13cmos5l_decap_8
XFILLER_44_2744 vccd vssd sg13cmos5l_decap_8
XFILLER_0_728 vccd vssd sg13cmos5l_decap_8
XFILLER_25_2143 vccd vssd sg13cmos5l_decap_8
XFILLER_5_2226 vccd vssd sg13cmos5l_decap_8
XFILLER_9_2373 vccd vssd sg13cmos5l_decap_8
XFILLER_9_1694 vccd vssd sg13cmos5l_decap_8
XFILLER_29_946 vccd vssd sg13cmos5l_decap_8
XFILLER_5_1547 vccd vssd sg13cmos5l_decap_8
XFILLER_28_434 vccd vssd sg13cmos5l_decap_8
XFILLER_38_2504 vccd vssd sg13cmos5l_decap_8
XFILLER_3_1260 vccd vssd sg13cmos5l_decap_8
XFILLER_37_990 vccd vssd sg13cmos5l_decap_8
XFILLER_24_651 vccd vssd sg13cmos5l_decap_8
XFILLER_23_161 vccd vssd sg13cmos5l_decap_8
XFILLER_19_1246 vccd vssd sg13cmos5l_decap_8
XFILLER_11_301 vccd vssd sg13cmos5l_decap_8
XFILLER_12_868 vccd vssd sg13cmos5l_decap_8
XFILLER_32_1435 vccd vssd sg13cmos5l_decap_8
XFILLER_10_2401 vccd vssd sg13cmos5l_decap_8
XFILLER_11_378 vccd vssd sg13cmos5l_decap_8
XFILLER_14_2581 vccd vssd sg13cmos5l_decap_8
XFILLER_10_2445 vccd vssd sg13cmos5l_decap_8
XFILLER_3_511 vccd vssd sg13cmos5l_decap_8
XFILLER_10_1722 vccd vssd sg13cmos5l_decap_8
XFILLER_3_588 vccd vssd sg13cmos5l_decap_8
XFILLER_10_1799 vccd vssd sg13cmos5l_decap_8
Xtiedowns\[30\] status[30] vccd vssd sg13cmos5l_antennanp
XFILLER_43_1575 vccd vssd sg13cmos5l_decap_4
XFILLER_21_2552 vccd vssd sg13cmos5l_decap_8
XFILLER_5_2782 vccd vssd sg13cmos5l_decap_8
XFILLER_35_905 vccd vssd sg13cmos5l_decap_8
XFILLER_19_434 vccd vssd sg13cmos5l_decap_8
XFILLER_1_2646 vccd vssd sg13cmos5l_decap_8
XFILLER_4_1057 vccd vssd sg13cmos5l_decap_8
XFILLER_37_2003 vccd vssd sg13cmos5l_decap_4
XFILLER_21_1862 vccd vssd sg13cmos5l_decap_8
XFILLER_36_91 vccd vssd sg13cmos5l_decap_8
XFILLER_34_426 vccd vssd sg13cmos5l_decap_8
XFILLER_1_1967 vccd vssd sg13cmos5l_decap_8
XFILLER_43_971 vccd vssd sg13cmos5l_decap_4
XFILLER_37_2047 vccd vssd sg13cmos5l_decap_8
XFILLER_15_651 vccd vssd sg13cmos5l_decap_8
XFILLER_14_161 vccd vssd sg13cmos5l_decap_8
XFILLER_15_2367 vccd vssd sg13cmos5l_decap_8
XFILLER_15_1666 vccd vssd sg13cmos5l_decap_8
X_1792_ _1792_/Q clkload8/A _1792_/D fanout118/X vccd vssd sg13cmos5l_dfrbpq_1
XFILLER_7_861 vccd vssd sg13cmos5l_decap_8
XFILLER_11_1519 vccd vssd sg13cmos5l_decap_8
XFILLER_6_371 vccd vssd sg13cmos5l_decap_8
XFILLER_28_2728 vccd vssd sg13cmos5l_decap_8
XFILLER_6_2513 vccd vssd sg13cmos5l_decap_8
XFILLER_28_0 vccd vssd sg13cmos5l_decap_8
XFILLER_38_732 vccd vssd sg13cmos5l_decap_8
XFILLER_6_1834 vccd vssd sg13cmos5l_decap_8
X_1226_ _1226_/Y status[67] _1314_/B _1223_/Y _1224_/Y _1315_/B1 vccd vssd sg13cmos5l_a221oi_1
XFILLER_37_231 vccd vssd sg13cmos5l_decap_8
XFILLER_22_1648 vccd vssd sg13cmos5l_decap_8
X_1157_ _1157_/Y _1745_/Q _1284_/B1 _1198_/A _1737_/Q _1372_/B1 vccd vssd sg13cmos5l_a221oi_1
XFILLER_26_938 vccd vssd sg13cmos5l_decap_8
XFILLER_0_2156 vccd vssd sg13cmos5l_decap_8
XFILLER_0_1400 vccd vssd sg13cmos5l_decap_8
XFILLER_41_908 vccd vssd sg13cmos5l_decap_8
XFILLER_25_448 vccd vssd sg13cmos5l_decap_8
XFILLER_20_1372 vccd vssd sg13cmos5l_decap_8
XFILLER_16_28 vccd vssd sg13cmos5l_decap_8
X_1088_ _1089_/C status[102] _1357_/A2 wire74/X status[126] vccd vssd sg13cmos5l_a22oi_1
XFILLER_0_1477 vccd vssd sg13cmos5l_decap_8
Xclkbuf_5_15_0_SCK _1763_/CLK clkbuf_3_3_0_SCK/X vccd vssd sg13cmos5l_buf_8
XFILLER_21_665 vccd vssd sg13cmos5l_decap_8
XFILLER_33_1733 vccd vssd sg13cmos5l_decap_8
XFILLER_32_49 vccd vssd sg13cmos5l_decap_8
XFILLER_20_175 vccd vssd sg13cmos5l_decap_8
XFILLER_4_308 vccd vssd sg13cmos5l_decap_8
XFILLER_10_1029 vccd vssd sg13cmos5l_decap_8
XFILLER_11_2776 vccd vssd sg13cmos5l_decap_8
XFILLER_14_1176 vccd vssd sg13cmos5l_decap_8
XFILLER_27_2216 vccd vssd sg13cmos5l_decap_8
XFILLER_27_1504 vccd vssd sg13cmos5l_decap_8
XFILLER_44_2541 vccd vssd sg13cmos5l_decap_8
XFILLER_0_525 vccd vssd sg13cmos5l_decap_8
XFILLER_9_2170 vccd vssd sg13cmos5l_decap_8
XFILLER_5_2023 vccd vssd sg13cmos5l_decap_8
XFILLER_44_1884 vccd vssd sg13cmos5l_decap_8
XFILLER_40_1704 vccd vssd sg13cmos5l_decap_8
XFILLER_9_1491 vccd vssd sg13cmos5l_decap_8
XFILLER_28_231 vccd vssd sg13cmos5l_decap_8
XFILLER_5_1344 vccd vssd sg13cmos5l_decap_8
XFILLER_29_776 vccd vssd sg13cmos5l_decap_4
XFILLER_21_1169 vccd vssd sg13cmos5l_decap_8
XFILLER_17_938 vccd vssd sg13cmos5l_decap_8
XFILLER_16_448 vccd vssd sg13cmos5l_decap_8
XFILLER_38_1622 vccd vssd sg13cmos5l_decap_8
XFILLER_38_2389 vccd vssd sg13cmos5l_decap_8
XFILLER_19_1043 vccd vssd sg13cmos5l_decap_8
XFILLER_36_2080 vccd vssd sg13cmos5l_decap_8
XFILLER_40_996 vccd vssd sg13cmos5l_decap_8
XFILLER_12_665 vccd vssd sg13cmos5l_decap_8
XFILLER_16_1986 vccd vssd sg13cmos5l_decap_8
XFILLER_8_658 vccd vssd sg13cmos5l_decap_8
XFILLER_11_175 vccd vssd sg13cmos5l_decap_8
XFILLER_12_1806 vccd vssd sg13cmos5l_decap_8
Xtiedowns\[78\] status[78] vccd vssd sg13cmos5l_antennanp
XFILLER_7_168 vccd vssd sg13cmos5l_decap_8
XFILLER_10_2275 vccd vssd sg13cmos5l_decap_8
XFILLER_45_2338 vccd vssd sg13cmos5l_decap_8
XFILLER_4_875 vccd vssd sg13cmos5l_decap_8
XFILLER_10_1596 vccd vssd sg13cmos5l_decap_8
XFILLER_3_385 vccd vssd sg13cmos5l_decap_8
XFILLER_45_1659 vccd vssd sg13cmos5l_decap_8
XFILLER_26_1047 vccd vssd sg13cmos5l_decap_8
XFILLER_39_529 vccd vssd sg13cmos5l_decap_8
XFILLER_23_2669 vccd vssd sg13cmos5l_decap_8
XFILLER_21_7 vccd vssd sg13cmos5l_decap_8
XFILLER_19_231 vccd vssd sg13cmos5l_decap_8
X_1011_ _1011_/X _1029_/A _1050_/A vccd vssd sg13cmos5l_or2_1
XFILLER_35_702 vccd vssd sg13cmos5l_decap_8
XFILLER_1_2443 vccd vssd sg13cmos5l_decap_8
XFILLER_35_768 vccd vssd sg13cmos5l_decap_8
XFILLER_34_245 vccd vssd sg13cmos5l_decap_8
XFILLER_1_1764 vccd vssd sg13cmos5l_decap_8
XFILLER_37_1121 vccd vssd sg13cmos5l_decap_8
XFILLER_34_2721 vccd vssd sg13cmos5l_decap_8
XFILLER_15_2175 vccd vssd sg13cmos5l_decap_8
XFILLER_15_1463 vccd vssd sg13cmos5l_decap_8
XFILLER_8_84 vccd vssd sg13cmos5l_decap_8
X_1775_ _1775_/Q clkload8/A _1775_/D fanout116/X vccd vssd sg13cmos5l_dfrbpq_1
XFILLER_11_1316 vccd vssd sg13cmos5l_decap_8
Xoutbuffers\[61\] control[61] _1729_/Q vccd vssd sg13cmos5l_buf_8
XFILLER_28_2569 vccd vssd sg13cmos5l_decap_8
XFILLER_6_2310 vccd vssd sg13cmos5l_decap_8
XFILLER_8_1918 vccd vssd sg13cmos5l_decap_8
XFILLER_44_1147 vccd vssd sg13cmos5l_decap_8
XFILLER_28_1868 vccd vssd sg13cmos5l_decap_8
XFILLER_41_2747 vccd vssd sg13cmos5l_decap_8
XFILLER_22_2113 vccd vssd sg13cmos5l_decap_8
XFILLER_22_1401 vccd vssd sg13cmos5l_decap_8
XFILLER_6_1631 vccd vssd sg13cmos5l_decap_8
XFILLER_26_1592 vccd vssd sg13cmos5l_decap_8
XFILLER_6_2387 vccd vssd sg13cmos5l_decap_8
XFILLER_38_551 vccd vssd sg13cmos5l_decap_8
X_1209_ _1209_/Y _1672_/Q _1382_/A vccd vssd sg13cmos5l_nor2_1
XFILLER_26_713 vccd vssd sg13cmos5l_decap_8
XFILLER_27_49 vccd vssd sg13cmos5l_decap_8
XFILLER_41_705 vccd vssd sg13cmos5l_decap_8
XFILLER_39_2654 vccd vssd sg13cmos5l_decap_8
XFILLER_39_1931 vccd vssd sg13cmos5l_decap_8
XFILLER_25_245 vccd vssd sg13cmos5l_decap_8
XFILLER_39_1964 vccd vssd sg13cmos5l_decap_8
XFILLER_0_1274 vccd vssd sg13cmos5l_decap_8
XFILLER_40_259 vccd vssd sg13cmos5l_decap_8
XFILLER_22_952 vccd vssd sg13cmos5l_decap_8
XFILLER_33_2253 vccd vssd sg13cmos5l_decap_8
XFILLER_21_462 vccd vssd sg13cmos5l_decap_8
XFILLER_4_105 vccd vssd sg13cmos5l_decap_8
XFILLER_11_2562 vccd vssd sg13cmos5l_decap_8
XFILLER_11_2595 vccd vssd sg13cmos5l_decap_8
XFILLER_27_2002 vccd vssd sg13cmos5l_decap_8
XFILLER_11_1883 vccd vssd sg13cmos5l_decap_8
XFILLER_27_1301 vccd vssd sg13cmos5l_decap_8
XFILLER_1_812 vccd vssd sg13cmos5l_decap_8
XFILLER_7_2107 vccd vssd sg13cmos5l_decap_8
XFILLER_0_322 vccd vssd sg13cmos5l_decap_8
XFILLER_27_1389 vccd vssd sg13cmos5l_decap_8
XFILLER_1_889 vccd vssd sg13cmos5l_decap_8
XFILLER_7_1428 vccd vssd sg13cmos5l_decap_8
XFILLER_40_2268 vccd vssd sg13cmos5l_decap_8
XFILLER_40_1501 vccd vssd sg13cmos5l_decap_8
XFILLER_2_2730 vccd vssd sg13cmos5l_decap_8
XFILLER_0_399 vccd vssd sg13cmos5l_decap_8
XFILLER_5_1141 vccd vssd sg13cmos5l_decap_8
XFILLER_29_551 vccd vssd sg13cmos5l_decap_8
XFILLER_40_1578 vccd vssd sg13cmos5l_decap_8
XFILLER_17_735 vccd vssd sg13cmos5l_decap_8
XFILLER_44_543 vccd vssd sg13cmos5l_decap_8
XFILLER_16_245 vccd vssd sg13cmos5l_decap_8
XFILLER_38_1441 vccd vssd sg13cmos5l_decap_8
XFILLER_32_749 vccd vssd sg13cmos5l_decap_8
XFILLER_34_2028 vccd vssd sg13cmos5l_decap_8
XFILLER_31_259 vccd vssd sg13cmos5l_decap_8
XFILLER_16_2451 vccd vssd sg13cmos5l_decap_8
XFILLER_13_952 vccd vssd sg13cmos5l_decap_8
XFILLER_40_760 vccd vssd sg13cmos5l_decap_8
XFILLER_33_70 vccd vssd sg13cmos5l_decap_8
XFILLER_9_945 vccd vssd sg13cmos5l_decap_8
XFILLER_12_462 vccd vssd sg13cmos5l_decap_8
XFILLER_16_1750 vccd vssd sg13cmos5l_decap_8
XFILLER_8_455 vccd vssd sg13cmos5l_decap_8
XFILLER_12_1603 vccd vssd sg13cmos5l_decap_8
XFILLER_32_1051 vccd vssd sg13cmos5l_decap_4
X_1560_ _1560_/Y _1560_/A _1567_/S vccd vssd sg13cmos5l_nor2_1
XFILLER_10_2072 vccd vssd sg13cmos5l_decap_8
XFILLER_45_2135 vccd vssd sg13cmos5l_decap_8
X_1491_ _1491_/Y _1562_/A _1495_/B vccd vssd sg13cmos5l_nor2_1
XFILLER_4_672 vccd vssd sg13cmos5l_decap_8
XFILLER_10_1393 vccd vssd sg13cmos5l_decap_8
XFILLER_3_182 vccd vssd sg13cmos5l_decap_8
XFILLER_45_1456 vccd vssd sg13cmos5l_decap_8
XFILLER_39_315 vccd vssd sg13cmos5l_decap_8
XFILLER_27_1890 vccd vssd sg13cmos5l_decap_8
XFILLER_23_2466 vccd vssd sg13cmos5l_decap_8
XFILLER_3_2527 vccd vssd sg13cmos5l_decap_8
XFILLER_7_2696 vccd vssd sg13cmos5l_decap_8
XFILLER_43_1180 vccd vssd sg13cmos5l_decap_8
XFILLER_23_1776 vccd vssd sg13cmos5l_decap_8
XFILLER_3_1848 vccd vssd sg13cmos5l_decap_8
XFILLER_1_2240 vccd vssd sg13cmos5l_decap_8
XFILLER_7_1995 vccd vssd sg13cmos5l_decap_8
XFILLER_35_521 vccd vssd sg13cmos5l_decap_8
XFILLER_21_2190 vccd vssd sg13cmos5l_decap_8
XFILLER_1_1561 vccd vssd sg13cmos5l_decap_8
XFILLER_23_749 vccd vssd sg13cmos5l_decap_8
XFILLER_17_2204 vccd vssd sg13cmos5l_decap_8
Xfanout19 _1350_/B _1070_/Y vccd vssd sg13cmos5l_buf_1
XFILLER_22_259 vccd vssd sg13cmos5l_decap_8
Xoutbuffers\[5\] control[5] _1673_/Q vccd vssd sg13cmos5l_buf_8
XFILLER_31_760 vccd vssd sg13cmos5l_decap_8
XFILLER_30_2404 vccd vssd sg13cmos5l_decap_8
XFILLER_17_1547 vccd vssd sg13cmos5l_decap_8
XFILLER_34_2595 vccd vssd sg13cmos5l_decap_8
XFILLER_34_1850 vccd vssd sg13cmos5l_decap_8
XFILLER_30_1703 vccd vssd sg13cmos5l_decap_8
XFILLER_34_1894 vccd vssd sg13cmos5l_decap_8
XFILLER_15_1260 vccd vssd sg13cmos5l_decap_8
XFILLER_11_1113 vccd vssd sg13cmos5l_decap_8
Xhold411 hold411/X _1723_/Q vccd vssd sg13cmos5l_dlygate4sd3_1
XFILLER_30_1758 vccd vssd sg13cmos5l_decap_8
Xhold400 _1801_/D _0927_/Y vccd vssd sg13cmos5l_dlygate4sd3_1
XFILLER_28_2322 vccd vssd sg13cmos5l_decap_8
Xhold422 _1744_/D _1526_/X vccd vssd sg13cmos5l_dlygate4sd3_1
X_1758_ _1758_/Q clkload1/A _1758_/D fanout124/X vccd vssd sg13cmos5l_dfrbpq_1
Xhold444 _1714_/D _1484_/X vccd vssd sg13cmos5l_dlygate4sd3_1
Xhold433 hold433/X _1730_/Q vccd vssd sg13cmos5l_dlygate4sd3_1
XFILLER_2_609 vccd vssd sg13cmos5l_decap_8
Xhold477 _1790_/D _1592_/X vccd vssd sg13cmos5l_dlygate4sd3_1
X_1689_ _1689_/Q _1697_/CLK _1689_/D fanout134/X vccd vssd sg13cmos5l_dfrbpq_1
Xhold466 hold466/X _1718_/Q vccd vssd sg13cmos5l_dlygate4sd3_1
Xhold455 _1797_/D _0942_/Y vccd vssd sg13cmos5l_dlygate4sd3_1
XFILLER_1_119 vccd vssd sg13cmos5l_decap_8
Xhold488 hold488/X _1795_/Q vccd vssd sg13cmos5l_dlygate4sd3_1
Xhold499 _1778_/D _1576_/X vccd vssd sg13cmos5l_dlygate4sd3_1
XFILLER_8_1715 vccd vssd sg13cmos5l_decap_8
XFILLER_41_2544 vccd vssd sg13cmos5l_decap_8
XFILLER_28_1665 vccd vssd sg13cmos5l_decap_8
XFILLER_41_1810 vccd vssd sg13cmos5l_decap_8
XFILLER_6_2184 vccd vssd sg13cmos5l_decap_8
XFILLER_39_860 vccd vssd sg13cmos5l_decap_8
XFILLER_2_2037 vccd vssd sg13cmos5l_decap_8
XFILLER_45_329 vccd vssd sg13cmos5l_decap_8
XFILLER_41_1887 vccd vssd sg13cmos5l_decap_8
XFILLER_39_2451 vccd vssd sg13cmos5l_decap_8
XFILLER_38_392 vccd vssd sg13cmos5l_decap_8
XFILLER_2_1358 vccd vssd sg13cmos5l_decap_8
XFILLER_0_1071 vccd vssd sg13cmos5l_decap_8
XFILLER_14_749 vccd vssd sg13cmos5l_decap_8
XFILLER_41_579 vccd vssd sg13cmos5l_decap_8
XFILLER_13_259 vccd vssd sg13cmos5l_decap_8
XFILLER_33_2072 vccd vssd sg13cmos5l_decap_8
XFILLER_16_1057 vccd vssd sg13cmos5l_decap_8
XFILLER_13_2646 vccd vssd sg13cmos5l_decap_8
XFILLER_10_966 vccd vssd sg13cmos5l_decap_8
XFILLER_6_959 vccd vssd sg13cmos5l_decap_8
XFILLER_13_1967 vccd vssd sg13cmos5l_decap_8
XFILLER_5_469 vccd vssd sg13cmos5l_decap_8
XFILLER_11_1680 vccd vssd sg13cmos5l_decap_8
XFILLER_27_1131 vccd vssd sg13cmos5l_decap_8
XFILLER_24_2720 vccd vssd sg13cmos5l_decap_8
XFILLER_1_686 vccd vssd sg13cmos5l_decap_8
XFILLER_7_1225 vccd vssd sg13cmos5l_decap_8
XFILLER_42_1629 vccd vssd sg13cmos5l_decap_8
XFILLER_40_2032 vccd vssd sg13cmos5l_decap_8
XFILLER_0_196 vccd vssd sg13cmos5l_decap_8
XFILLER_20_2639 vccd vssd sg13cmos5l_decap_8
XFILLER_40_1353 vccd vssd sg13cmos5l_decap_8
XFILLER_36_329 vccd vssd sg13cmos5l_decap_8
XFILLER_28_70 vccd vssd sg13cmos5l_decap_8
XFILLER_29_392 vccd vssd sg13cmos5l_decap_8
XFILLER_17_532 vccd vssd sg13cmos5l_decap_8
XFILLER_45_896 vccd vssd sg13cmos5l_decap_8
XFILLER_32_546 vccd vssd sg13cmos5l_decap_8
XFILLER_44_91 vccd vssd sg13cmos5l_decap_8
XFILLER_38_1271 vccd vssd sg13cmos5l_decap_8
X_0991_ _1197_/C _1074_/B _1014_/B vccd vssd sg13cmos5l_nand2_2
XFILLER_31_2724 vccd vssd sg13cmos5l_decap_8
XFILLER_18_1889 vccd vssd sg13cmos5l_decap_4
XFILLER_9_742 vccd vssd sg13cmos5l_decap_8
XFILLER_8_252 vccd vssd sg13cmos5l_decap_8
XFILLER_12_1400 vccd vssd sg13cmos5l_decap_8
X_1612_ _1612_/Y _1639_/A _1639_/B_N vccd vssd sg13cmos5l_nor2b_1
XFILLER_12_1477 vccd vssd sg13cmos5l_decap_8
X_1543_ _1755_/D hold225/X _1542_/B _1542_/Y vccd vssd sg13cmos5l_a21oi_1
XFILLER_29_2664 vccd vssd sg13cmos5l_decap_8
XFILLER_5_63 vccd vssd sg13cmos5l_decap_8
X_1474_ _1480_/S _1655_/Q _1474_/B vccd vssd sg13cmos5l_nand2_1
XFILLER_25_2517 vccd vssd sg13cmos5l_decap_8
XFILLER_10_1190 vccd vssd sg13cmos5l_decap_8
XFILLER_45_1253 vccd vssd sg13cmos5l_decap_8
XFILLER_29_1974 vccd vssd sg13cmos5l_decap_8
XFILLER_41_1106 vccd vssd sg13cmos5l_decap_8
XFILLER_39_112 vccd vssd sg13cmos5l_decap_8
XFILLER_3_2324 vccd vssd sg13cmos5l_decap_8
XFILLER_7_2471 vccd vssd sg13cmos5l_decap_8
XFILLER_23_2274 vccd vssd sg13cmos5l_decap_8
XFILLER_10_0 vccd vssd sg13cmos5l_decap_8
XFILLER_39_189 vccd vssd sg13cmos5l_decap_8
XFILLER_27_329 vccd vssd sg13cmos5l_decap_8
XFILLER_3_1645 vccd vssd sg13cmos5l_decap_8
XFILLER_7_1792 vccd vssd sg13cmos5l_decap_8
Xoutbuffers\[24\] control[24] _1692_/Q vccd vssd sg13cmos5l_buf_8
XFILLER_39_1002 vccd vssd sg13cmos5l_decap_8
XFILLER_36_841 vccd vssd sg13cmos5l_decap_8
XFILLER_36_2602 vccd vssd sg13cmos5l_decap_8
XFILLER_24_28 vccd vssd sg13cmos5l_decap_8
XFILLER_23_546 vccd vssd sg13cmos5l_decap_8
X_1623__154 _1659_/CLK _1652_/CLK vccd vssd sg13cmos5l_inv_1
XFILLER_36_2679 vccd vssd sg13cmos5l_decap_8
XFILLER_17_2067 vccd vssd sg13cmos5l_decap_8
XFILLER_34_2392 vccd vssd sg13cmos5l_decap_8
XFILLER_30_2212 vccd vssd sg13cmos5l_decap_8
XFILLER_17_1344 vccd vssd sg13cmos5l_decap_8
XFILLER_40_49 vccd vssd sg13cmos5l_decap_8
XFILLER_30_1566 vccd vssd sg13cmos5l_decap_8
Xhold241 _1707_/D _1473_/Y vccd vssd sg13cmos5l_dlygate4sd3_1
Xhold252 _1766_/D _1561_/Y vccd vssd sg13cmos5l_dlygate4sd3_1
Xhold230 _0837_/A _1724_/Q vccd vssd sg13cmos5l_dlygate4sd3_1
XFILLER_2_406 vccd vssd sg13cmos5l_decap_8
Xhold296 hold296/X _1699_/Q vccd vssd sg13cmos5l_dlygate4sd3_1
Xhold263 _1686_/D _1444_/Y vccd vssd sg13cmos5l_dlygate4sd3_1
Xhold274 _0869_/A _1746_/Q vccd vssd sg13cmos5l_dlygate4sd3_1
Xhold285 _1805_/D _0896_/Y vccd vssd sg13cmos5l_dlygate4sd3_1
XFILLER_28_1451 vccd vssd sg13cmos5l_decap_8
XFILLER_8_1512 vccd vssd sg13cmos5l_decap_8
XFILLER_8_2268 vccd vssd sg13cmos5l_decap_8
XFILLER_19_819 vccd vssd sg13cmos5l_decap_8
XFILLER_8_1589 vccd vssd sg13cmos5l_decap_8
XFILLER_45_126 vccd vssd sg13cmos5l_decap_8
XFILLER_41_1684 vccd vssd sg13cmos5l_decap_8
XFILLER_22_1050 vccd vssd sg13cmos5l_decap_8
XFILLER_18_329 vccd vssd sg13cmos5l_decap_8
XFILLER_27_841 vccd vssd sg13cmos5l_decap_8
XFILLER_2_1155 vccd vssd sg13cmos5l_decap_8
XFILLER_42_800 vccd vssd sg13cmos5l_decap_8
XFILLER_14_546 vccd vssd sg13cmos5l_decap_8
XFILLER_42_877 vccd vssd sg13cmos5l_decap_8
XFILLER_41_354 vccd vssd sg13cmos5l_decap_8
XFILLER_39_1591 vccd vssd sg13cmos5l_decap_8
XFILLER_35_1466 vccd vssd sg13cmos5l_decap_8
XFILLER_31_1308 vccd vssd sg13cmos5l_decap_8
XFILLER_10_763 vccd vssd sg13cmos5l_decap_8
XFILLER_13_1764 vccd vssd sg13cmos5l_decap_8
XFILLER_6_756 vccd vssd sg13cmos5l_decap_8
Xtiedowns\[60\] status[60] vccd vssd sg13cmos5l_antennanp
XFILLER_5_266 vccd vssd sg13cmos5l_decap_8
XFILLER_9_1309 vccd vssd sg13cmos5l_decap_8
XFILLER_42_2105 vccd vssd sg13cmos5l_decap_8
XFILLER_2_973 vccd vssd sg13cmos5l_decap_8
XFILLER_1_483 vccd vssd sg13cmos5l_decap_8
XFILLER_4_2611 vccd vssd sg13cmos5l_decap_8
XFILLER_7_1022 vccd vssd sg13cmos5l_decap_8
XFILLER_42_1437 vccd vssd sg13cmos5l_decap_8
X_1190_ _1190_/X _1784_/Q _1578_/B _1151_/B vccd vssd sg13cmos5l_a21o_1
XFILLER_39_91 vccd vssd sg13cmos5l_decap_8
XFILLER_24_2594 vccd vssd sg13cmos5l_decap_8
XFILLER_36_126 vccd vssd sg13cmos5l_decap_8
XFILLER_20_2436 vccd vssd sg13cmos5l_decap_8
XFILLER_20_1724 vccd vssd sg13cmos5l_decap_8
XFILLER_4_1932 vccd vssd sg13cmos5l_decap_8
XFILLER_4_2688 vccd vssd sg13cmos5l_decap_8
XFILLER_7_1099 vccd vssd sg13cmos5l_decap_8
XFILLER_33_822 vccd vssd sg13cmos5l_decap_8
XFILLER_18_2310 vccd vssd sg13cmos5l_decap_8
XFILLER_18_896 vccd vssd sg13cmos5l_decap_8
XFILLER_45_693 vccd vssd sg13cmos5l_decap_8
XFILLER_44_192 vccd vssd sg13cmos5l_decap_8
Xoutbuffers\[114\] control[114] _1782_/Q vccd vssd sg13cmos5l_buf_8
XFILLER_32_343 vccd vssd sg13cmos5l_decap_8
XFILLER_18_1631 vccd vssd sg13cmos5l_decap_8
XFILLER_14_2229 vccd vssd sg13cmos5l_decap_8
X_0974_ _0974_/Y _1077_/A _1137_/B vccd vssd sg13cmos5l_nor2_1
XFILLER_31_2598 vccd vssd sg13cmos5l_decap_8
XFILLER_31_1897 vccd vssd sg13cmos5l_decap_8
XFILLER_12_1274 vccd vssd sg13cmos5l_decap_8
XFILLER_29_2461 vccd vssd sg13cmos5l_decap_8
X_1526_ _1526_/X _1481_/A hold421/X _1528_/B vccd vssd sg13cmos5l_mux2_1
XFILLER_25_2314 vccd vssd sg13cmos5l_decap_8
XFILLER_29_1771 vccd vssd sg13cmos5l_decap_4
XFILLER_5_2408 vccd vssd sg13cmos5l_decap_8
XFILLER_9_2566 vccd vssd sg13cmos5l_decap_8
XFILLER_45_1050 vccd vssd sg13cmos5l_decap_8
XFILLER_42_2650 vccd vssd sg13cmos5l_decap_8
X_1457_ _1457_/X _1478_/A hold344/X _1461_/S vccd vssd sg13cmos5l_mux2_1
XFILLER_19_28 vccd vssd sg13cmos5l_decap_8
XFILLER_9_1876 vccd vssd sg13cmos5l_decap_8
XFILLER_23_2071 vccd vssd sg13cmos5l_decap_8
XFILLER_3_2121 vccd vssd sg13cmos5l_decap_8
XFILLER_5_1729 vccd vssd sg13cmos5l_decap_8
X_1388_ _1388_/Y _0839_/Y _1066_/X _1389_/A2 vccd vssd sg13cmos5l_a21oi_1
XFILLER_42_1971 vccd vssd sg13cmos5l_decap_8
XFILLER_27_126 vccd vssd sg13cmos5l_decap_8
XFILLER_3_2198 vccd vssd sg13cmos5l_decap_8
XFILLER_3_1442 vccd vssd sg13cmos5l_decap_8
XFILLER_35_49 vccd vssd sg13cmos5l_decap_8
XFILLER_19_2129 vccd vssd sg13cmos5l_decap_8
XFILLER_24_833 vccd vssd sg13cmos5l_decap_8
XFILLER_19_1428 vccd vssd sg13cmos5l_decap_8
XFILLER_36_1720 vccd vssd sg13cmos5l_decap_8
XFILLER_23_343 vccd vssd sg13cmos5l_decap_8
XFILLER_36_2498 vccd vssd sg13cmos5l_decap_8
XFILLER_17_1141 vccd vssd sg13cmos5l_decap_8
XFILLER_32_1639 vccd vssd sg13cmos5l_decap_8
XFILLER_14_2785 vccd vssd sg13cmos5l_decap_4
XFILLER_30_2097 vccd vssd sg13cmos5l_decap_8
XFILLER_10_1904 vccd vssd sg13cmos5l_decap_8
XFILLER_10_2649 vccd vssd sg13cmos5l_decap_8
XFILLER_2_203 vccd vssd sg13cmos5l_decap_8
XFILLER_43_2447 vccd vssd sg13cmos5l_decap_4
XFILLER_28_1281 vccd vssd sg13cmos5l_decap_8
XFILLER_8_2065 vccd vssd sg13cmos5l_decap_8
XFILLER_41_2160 vccd vssd sg13cmos5l_decap_8
XFILLER_21_2734 vccd vssd sg13cmos5l_decap_8
XFILLER_8_1386 vccd vssd sg13cmos5l_decap_8
XFILLER_24_1156 vccd vssd sg13cmos5l_decap_8
XFILLER_19_616 vccd vssd sg13cmos5l_decap_8
XFILLER_4_1239 vccd vssd sg13cmos5l_decap_8
XFILLER_18_126 vccd vssd sg13cmos5l_decap_8
XFILLER_37_2229 vccd vssd sg13cmos5l_decap_8
XFILLER_15_833 vccd vssd sg13cmos5l_decap_8
XFILLER_42_674 vccd vssd sg13cmos5l_decap_4
XFILLER_41_140 vccd vssd sg13cmos5l_decap_8
XFILLER_19_2685 vccd vssd sg13cmos5l_decap_8
XFILLER_14_343 vccd vssd sg13cmos5l_decap_8
XFILLER_30_847 vccd vssd sg13cmos5l_decap_8
XFILLER_15_1848 vccd vssd sg13cmos5l_decap_8
XFILLER_31_1138 vccd vssd sg13cmos5l_decap_8
XFILLER_10_560 vccd vssd sg13cmos5l_decap_8
XFILLER_13_2262 vccd vssd sg13cmos5l_decap_8
XFILLER_41_70 vccd vssd sg13cmos5l_decap_8
XFILLER_6_553 vccd vssd sg13cmos5l_decap_8
XFILLER_13_1561 vccd vssd sg13cmos5l_decap_8
XFILLER_29_1067 vccd vssd sg13cmos5l_decap_8
XFILLER_26_1911 vccd vssd sg13cmos5l_decap_8
XFILLER_6_2706 vccd vssd sg13cmos5l_decap_8
XFILLER_9_1106 vccd vssd sg13cmos5l_decap_8
X_1311_ _1311_/X _1311_/A _1311_/B _1311_/C vccd vssd sg13cmos5l_and3_2
XFILLER_26_2656 vccd vssd sg13cmos5l_decap_8
XFILLER_2_770 vccd vssd sg13cmos5l_decap_8
X_1242_ _1244_/A _1743_/Q _1520_/B _1240_/Y _1241_/Y _1198_/A vccd vssd sg13cmos5l_a221oi_1
XFILLER_2_42 vccd vssd sg13cmos5l_decap_8
XFILLER_1_280 vccd vssd sg13cmos5l_decap_8
XFILLER_42_1256 vccd vssd sg13cmos5l_decap_8
XFILLER_38_925 vccd vssd sg13cmos5l_decap_8
XFILLER_37_413 vccd vssd sg13cmos5l_decap_8
XFILLER_20_1521 vccd vssd sg13cmos5l_decap_8
XFILLER_0_2338 vccd vssd sg13cmos5l_decap_8
XFILLER_4_2485 vccd vssd sg13cmos5l_decap_8
X_1173_ _1173_/Y _1171_/Y _1172_/Y _1217_/C vccd vssd sg13cmos5l_o21ai_1
Xtiedowns\[104\] status[104] vccd vssd sg13cmos5l_antennanp
XFILLER_25_619 vccd vssd sg13cmos5l_decap_8
XFILLER_45_490 vccd vssd sg13cmos5l_decap_8
XFILLER_37_2730 vccd vssd sg13cmos5l_decap_8
XFILLER_20_1598 vccd vssd sg13cmos5l_decap_8
XFILLER_18_693 vccd vssd sg13cmos5l_decap_8
XFILLER_0_1659 vccd vssd sg13cmos5l_decap_8
XFILLER_36_1016 vccd vssd sg13cmos5l_decap_8
XFILLER_32_140 vccd vssd sg13cmos5l_decap_8
XFILLER_18_2151 vccd vssd sg13cmos5l_decap_8
XFILLER_21_847 vccd vssd sg13cmos5l_decap_8
XFILLER_20_357 vccd vssd sg13cmos5l_decap_8
XFILLER_14_2037 vccd vssd sg13cmos5l_decap_8
X_0957_ _0997_/B _1800_/Q _1799_/Q _0957_/S vccd vssd sg13cmos5l_mux2_2
XFILLER_14_1358 vccd vssd sg13cmos5l_decap_8
Xoutbuffers\[91\] control[91] _1759_/Q vccd vssd sg13cmos5l_buf_8
XFILLER_31_1661 vccd vssd sg13cmos5l_decap_8
X_0888_ _0889_/B SDI _1394_/A _0888_/C vccd vssd sg13cmos5l_nor3_1
XFILLER_12_1071 vccd vssd sg13cmos5l_decap_8
XFILLER_44_2723 vccd vssd sg13cmos5l_decap_8
XFILLER_27_1719 vccd vssd sg13cmos5l_decap_8
XFILLER_0_707 vccd vssd sg13cmos5l_decap_8
XFILLER_9_2352 vccd vssd sg13cmos5l_decap_8
X_1509_ _1509_/X _1542_/A hold320/X _1509_/S vccd vssd sg13cmos5l_mux2_1
XFILLER_5_2205 vccd vssd sg13cmos5l_decap_8
XFILLER_25_1432 vccd vssd sg13cmos5l_decap_4
XFILLER_21_2008 vccd vssd sg13cmos5l_decap_4
XFILLER_9_1673 vccd vssd sg13cmos5l_decap_8
XFILLER_42_2480 vccd vssd sg13cmos5l_decap_4
XFILLER_29_925 vccd vssd sg13cmos5l_decap_8
XFILLER_28_413 vccd vssd sg13cmos5l_decap_8
XFILLER_25_2199 vccd vssd sg13cmos5l_decap_8
XFILLER_5_1526 vccd vssd sg13cmos5l_decap_8
XFILLER_43_405 vccd vssd sg13cmos5l_decap_8
XFILLER_24_630 vccd vssd sg13cmos5l_decap_8
XFILLER_38_1859 vccd vssd sg13cmos5l_decap_8
XFILLER_38_1848 vccd vssd sg13cmos5l_decap_4
XFILLER_23_140 vccd vssd sg13cmos5l_decap_8
XFILLER_19_1225 vccd vssd sg13cmos5l_decap_8
XFILLER_32_2104 vccd vssd sg13cmos5l_decap_8
XFILLER_12_847 vccd vssd sg13cmos5l_decap_8
XFILLER_36_1583 vccd vssd sg13cmos5l_decap_4
XFILLER_32_2159 vccd vssd sg13cmos5l_decap_8
XFILLER_11_357 vccd vssd sg13cmos5l_decap_8
XFILLER_10_1701 vccd vssd sg13cmos5l_decap_8
XFILLER_10_1778 vccd vssd sg13cmos5l_decap_8
XFILLER_11_84 vccd vssd sg13cmos5l_decap_8
XFILLER_43_2211 vccd vssd sg13cmos5l_decap_8
XFILLER_3_567 vccd vssd sg13cmos5l_decap_8
XFILLER_26_1229 vccd vssd sg13cmos5l_decap_8
Xtiedowns\[23\] status[23] vccd vssd sg13cmos5l_antennanp
XFILLER_21_2531 vccd vssd sg13cmos5l_decap_8
XFILLER_19_413 vccd vssd sg13cmos5l_decap_8
XFILLER_5_2761 vccd vssd sg13cmos5l_decap_8
XFILLER_8_1183 vccd vssd sg13cmos5l_decap_8
XFILLER_21_1841 vccd vssd sg13cmos5l_decap_8
XFILLER_1_2625 vccd vssd sg13cmos5l_decap_8
XFILLER_4_1036 vccd vssd sg13cmos5l_decap_8
XFILLER_34_405 vccd vssd sg13cmos5l_decap_8
XFILLER_28_980 vccd vssd sg13cmos5l_decap_8
XFILLER_1_1946 vccd vssd sg13cmos5l_decap_8
XFILLER_36_70 vccd vssd sg13cmos5l_decap_8
XFILLER_27_490 vccd vssd sg13cmos5l_decap_8
XFILLER_15_630 vccd vssd sg13cmos5l_decap_8
XFILLER_37_1325 vccd vssd sg13cmos5l_decap_8
XFILLER_14_140 vccd vssd sg13cmos5l_decap_8
XFILLER_30_622 vccd vssd sg13cmos5l_decap_8
X_1791_ _1791_/Q _1793_/CLK _1791_/D fanout118/X vccd vssd sg13cmos5l_dfrbpq_1
XFILLER_35_1082 vccd vssd sg13cmos5l_decap_8
XFILLER_15_1645 vccd vssd sg13cmos5l_decap_8
XFILLER_32_2693 vccd vssd sg13cmos5l_decap_8
XFILLER_7_840 vccd vssd sg13cmos5l_decap_8
XFILLER_28_2707 vccd vssd sg13cmos5l_decap_8
XFILLER_6_350 vccd vssd sg13cmos5l_decap_8
XFILLER_44_2019 vccd vssd sg13cmos5l_decap_8
XFILLER_44_1329 vccd vssd sg13cmos5l_decap_8
XFILLER_6_1813 vccd vssd sg13cmos5l_decap_8
XFILLER_6_2569 vccd vssd sg13cmos5l_decap_8
X_1225_ _1225_/Y status[75] _1225_/B vccd vssd sg13cmos5l_nand2_1
XFILLER_42_1075 vccd vssd sg13cmos5l_decap_4
XFILLER_37_210 vccd vssd sg13cmos5l_decap_8
XFILLER_26_1796 vccd vssd sg13cmos5l_decap_8
XFILLER_22_1627 vccd vssd sg13cmos5l_decap_8
XFILLER_4_2282 vccd vssd sg13cmos5l_decap_8
X_1156_ _1156_/Y _1154_/X _1153_/Y _1155_/Y vccd vssd sg13cmos5l_o21ai_1
XFILLER_26_917 vccd vssd sg13cmos5l_decap_8
XFILLER_0_2135 vccd vssd sg13cmos5l_decap_8
XFILLER_37_287 vccd vssd sg13cmos5l_decap_8
XFILLER_25_427 vccd vssd sg13cmos5l_decap_8
XFILLER_20_1351 vccd vssd sg13cmos5l_decap_8
XFILLER_19_980 vccd vssd sg13cmos5l_decap_8
X_1087_ _1089_/B status[118] wire81/X _1309_/B1 status[110] vccd vssd sg13cmos5l_a22oi_1
XFILLER_18_490 vccd vssd sg13cmos5l_decap_8
XFILLER_0_1456 vccd vssd sg13cmos5l_decap_8
XFILLER_34_983 vccd vssd sg13cmos5l_decap_8
XFILLER_33_1712 vccd vssd sg13cmos5l_decap_8
XFILLER_32_28 vccd vssd sg13cmos5l_decap_8
XFILLER_21_644 vccd vssd sg13cmos5l_decap_8
Xtiedowns\[7\] status[7] vccd vssd sg13cmos5l_antennanp
XFILLER_20_154 vccd vssd sg13cmos5l_decap_8
XFILLER_11_2711 vccd vssd sg13cmos5l_decap_4
XFILLER_31_2181 vccd vssd sg13cmos5l_decap_8
XFILLER_11_2755 vccd vssd sg13cmos5l_decap_4
XFILLER_14_1155 vccd vssd sg13cmos5l_decap_8
XFILLER_10_1008 vccd vssd sg13cmos5l_decap_8
XFILLER_31_1480 vccd vssd sg13cmos5l_decap_8
XFILLER_44_2520 vccd vssd sg13cmos5l_decap_8
XFILLER_0_504 vccd vssd sg13cmos5l_decap_8
XFILLER_5_2002 vccd vssd sg13cmos5l_decap_8
XFILLER_44_2597 vccd vssd sg13cmos5l_decap_8
XFILLER_44_1863 vccd vssd sg13cmos5l_decap_8
XFILLER_5_1323 vccd vssd sg13cmos5l_decap_8
XFILLER_9_1470 vccd vssd sg13cmos5l_decap_8
XFILLER_29_755 vccd vssd sg13cmos5l_decap_8
XFILLER_28_210 vccd vssd sg13cmos5l_decap_8
XFILLER_5_2079 vccd vssd sg13cmos5l_decap_8
XFILLER_21_1148 vccd vssd sg13cmos5l_decap_8
XFILLER_17_917 vccd vssd sg13cmos5l_decap_8
XFILLER_28_287 vccd vssd sg13cmos5l_decap_8
XFILLER_16_427 vccd vssd sg13cmos5l_decap_8
XFILLER_25_983 vccd vssd sg13cmos5l_decap_8
XFILLER_19_1022 vccd vssd sg13cmos5l_decap_8
XFILLER_16_2611 vccd vssd sg13cmos5l_decap_8
XFILLER_12_644 vccd vssd sg13cmos5l_decap_8
XFILLER_40_975 vccd vssd sg13cmos5l_decap_8
XFILLER_36_1391 vccd vssd sg13cmos5l_decap_8
XFILLER_19_1099 vccd vssd sg13cmos5l_decap_8
XFILLER_16_2699 vccd vssd sg13cmos5l_decap_8
XFILLER_16_1965 vccd vssd sg13cmos5l_decap_8
XFILLER_8_637 vccd vssd sg13cmos5l_decap_8
XFILLER_11_154 vccd vssd sg13cmos5l_decap_8
XFILLER_7_147 vccd vssd sg13cmos5l_decap_8
XFILLER_10_2254 vccd vssd sg13cmos5l_decap_8
XFILLER_45_2317 vccd vssd sg13cmos5l_decap_8
XFILLER_4_854 vccd vssd sg13cmos5l_decap_8
XFILLER_10_1575 vccd vssd sg13cmos5l_decap_8
XFILLER_3_364 vccd vssd sg13cmos5l_decap_8
XFILLER_45_1638 vccd vssd sg13cmos5l_decap_8
XFILLER_39_508 vccd vssd sg13cmos5l_decap_8
XFILLER_27_2784 vccd vssd sg13cmos5l_decap_8
XFILLER_43_1351 vccd vssd sg13cmos5l_decap_8
XFILLER_23_2648 vccd vssd sg13cmos5l_decap_8
XFILLER_3_2709 vccd vssd sg13cmos5l_decap_8
XFILLER_19_210 vccd vssd sg13cmos5l_decap_8
XFILLER_1_2422 vccd vssd sg13cmos5l_decap_8
XFILLER_14_7 vccd vssd sg13cmos5l_decap_8
X_1010_ _1010_/Y _1029_/A _1050_/A vccd vssd sg13cmos5l_nor2_1
XFILLER_23_1969 vccd vssd sg13cmos5l_decap_8
XFILLER_39_1409 vccd vssd sg13cmos5l_decap_8
XFILLER_35_747 vccd vssd sg13cmos5l_decap_8
XFILLER_34_224 vccd vssd sg13cmos5l_decap_8
XFILLER_19_287 vccd vssd sg13cmos5l_decap_8
XFILLER_1_2499 vccd vssd sg13cmos5l_decap_8
XFILLER_1_1743 vccd vssd sg13cmos5l_decap_8
XFILLER_5_1890 vccd vssd sg13cmos5l_decap_8
XFILLER_34_2700 vccd vssd sg13cmos5l_decap_8
XFILLER_16_994 vccd vssd sg13cmos5l_decap_8
XFILLER_31_964 vccd vssd sg13cmos5l_decap_8
XFILLER_17_1729 vccd vssd sg13cmos5l_decap_8
XFILLER_15_2121 vccd vssd sg13cmos5l_decap_8
XFILLER_34_2777 vccd vssd sg13cmos5l_decap_8
XFILLER_30_441 vccd vssd sg13cmos5l_decap_8
XFILLER_15_1442 vccd vssd sg13cmos5l_decap_8
XFILLER_8_63 vccd vssd sg13cmos5l_decap_8
X_1774_ _1774_/Q _1779_/CLK _1774_/D fanout116/X vccd vssd sg13cmos5l_dfrbpq_1
XFILLER_28_2548 vccd vssd sg13cmos5l_decap_8
XFILLER_40_0 vccd vssd sg13cmos5l_decap_8
XFILLER_44_1126 vccd vssd sg13cmos5l_decap_8
XFILLER_41_2726 vccd vssd sg13cmos5l_decap_8
XFILLER_28_1847 vccd vssd sg13cmos5l_decap_8
Xoutbuffers\[54\] control[54] _1722_/Q vccd vssd sg13cmos5l_buf_8
XFILLER_6_1610 vccd vssd sg13cmos5l_decap_8
XFILLER_6_2366 vccd vssd sg13cmos5l_decap_8
XFILLER_38_530 vccd vssd sg13cmos5l_decap_8
XFILLER_2_2219 vccd vssd sg13cmos5l_decap_8
X_1208_ _1208_/Y _1680_/Q _1429_/B _1207_/Y _1206_/Y _1419_/B vccd vssd sg13cmos5l_a221oi_1
XFILLER_27_28 vccd vssd sg13cmos5l_decap_8
XFILLER_22_1457 vccd vssd sg13cmos5l_decap_8
XFILLER_6_1687 vccd vssd sg13cmos5l_decap_8
XFILLER_39_2633 vccd vssd sg13cmos5l_decap_8
XFILLER_38_596 vccd vssd sg13cmos5l_decap_8
XFILLER_25_224 vccd vssd sg13cmos5l_decap_8
X_1139_ _1139_/Y status[69] _0974_/Y _1315_/B1 status[61] _1268_/B1 vccd vssd sg13cmos5l_a221oi_1
XFILLER_0_1253 vccd vssd sg13cmos5l_decap_8
XFILLER_39_1943 vccd vssd sg13cmos5l_decap_8
XFILLER_35_1807 vccd vssd sg13cmos5l_decap_8
XFILLER_40_238 vccd vssd sg13cmos5l_decap_8
XFILLER_37_2390 vccd vssd sg13cmos5l_decap_8
XFILLER_22_931 vccd vssd sg13cmos5l_decap_8
XFILLER_21_441 vccd vssd sg13cmos5l_decap_8
XFILLER_16_1239 vccd vssd sg13cmos5l_decap_8
XFILLER_33_1553 vccd vssd sg13cmos5l_decap_8
XFILLER_33_1597 vccd vssd sg13cmos5l_decap_8
XFILLER_11_2541 vccd vssd sg13cmos5l_decap_8
XFILLER_11_1862 vccd vssd sg13cmos5l_decap_8
XFILLER_0_301 vccd vssd sg13cmos5l_decap_8
XFILLER_1_868 vccd vssd sg13cmos5l_decap_8
XFILLER_7_1407 vccd vssd sg13cmos5l_decap_8
XFILLER_44_2394 vccd vssd sg13cmos5l_decap_8
XFILLER_27_1357 vccd vssd sg13cmos5l_decap_8
XFILLER_0_378 vccd vssd sg13cmos5l_decap_8
XFILLER_44_1693 vccd vssd sg13cmos5l_decap_8
XFILLER_40_2247 vccd vssd sg13cmos5l_decap_8
XFILLER_29_530 vccd vssd sg13cmos5l_decap_4
XFILLER_5_1120 vccd vssd sg13cmos5l_decap_8
XFILLER_40_1557 vccd vssd sg13cmos5l_decap_8
XFILLER_25_1092 vccd vssd sg13cmos5l_decap_8
XFILLER_17_714 vccd vssd sg13cmos5l_decap_8
XFILLER_44_522 vccd vssd sg13cmos5l_decap_8
XFILLER_16_224 vccd vssd sg13cmos5l_decap_8
XFILLER_2_2786 vccd vssd sg13cmos5l_decap_4
XFILLER_5_1197 vccd vssd sg13cmos5l_decap_8
XFILLER_44_599 vccd vssd sg13cmos5l_decap_8
XFILLER_38_2165 vccd vssd sg13cmos5l_decap_8
XFILLER_34_2007 vccd vssd sg13cmos5l_decap_8
XFILLER_32_728 vccd vssd sg13cmos5l_decap_8
XFILLER_25_780 vccd vssd sg13cmos5l_decap_8
XFILLER_31_238 vccd vssd sg13cmos5l_decap_8
XFILLER_16_2430 vccd vssd sg13cmos5l_decap_8
XFILLER_13_931 vccd vssd sg13cmos5l_decap_8
Xtiedowns\[90\] status[90] vccd vssd sg13cmos5l_antennanp
XFILLER_9_924 vccd vssd sg13cmos5l_decap_8
XFILLER_12_441 vccd vssd sg13cmos5l_decap_8
XFILLER_32_1030 vccd vssd sg13cmos5l_decap_8
XFILLER_8_434 vccd vssd sg13cmos5l_decap_8
XFILLER_12_2349 vccd vssd sg13cmos5l_decap_8
XFILLER_32_1085 vccd vssd sg13cmos5l_decap_8
XFILLER_10_2051 vccd vssd sg13cmos5l_decap_8
XFILLER_12_1659 vccd vssd sg13cmos5l_decap_8
XFILLER_45_2114 vccd vssd sg13cmos5l_decap_8
XFILLER_4_651 vccd vssd sg13cmos5l_decap_8
X_1490_ _1490_/X _1478_/A hold466/X _1495_/B vccd vssd sg13cmos5l_mux2_1
XFILLER_3_161 vccd vssd sg13cmos5l_decap_8
XFILLER_10_1372 vccd vssd sg13cmos5l_decap_8
XFILLER_45_1435 vccd vssd sg13cmos5l_decap_8
XFILLER_7_2620 vccd vssd sg13cmos5l_decap_4
Xclkbuf_5_14_0_SCK _1793_/CLK clkbuf_3_3_0_SCK/X vccd vssd sg13cmos5l_buf_8
XFILLER_23_2445 vccd vssd sg13cmos5l_decap_8
XFILLER_3_2506 vccd vssd sg13cmos5l_decap_8
XFILLER_7_2675 vccd vssd sg13cmos5l_decap_8
XFILLER_7_1974 vccd vssd sg13cmos5l_decap_8
XFILLER_23_1755 vccd vssd sg13cmos5l_decap_8
XFILLER_3_1827 vccd vssd sg13cmos5l_decap_8
XFILLER_35_500 vccd vssd sg13cmos5l_decap_8
Xclkbuf_5_29_0_SCK _1798_/CLK clkbuf_3_7_0_SCK/X vccd vssd sg13cmos5l_buf_8
XFILLER_1_2296 vccd vssd sg13cmos5l_decap_8
XFILLER_1_1540 vccd vssd sg13cmos5l_decap_8
XFILLER_35_599 vccd vssd sg13cmos5l_decap_8
XFILLER_23_728 vccd vssd sg13cmos5l_decap_8
XFILLER_22_238 vccd vssd sg13cmos5l_decap_8
XFILLER_17_2249 vccd vssd sg13cmos5l_decap_8
XFILLER_17_1526 vccd vssd sg13cmos5l_decap_8
XFILLER_16_791 vccd vssd sg13cmos5l_decap_8
XFILLER_34_2574 vccd vssd sg13cmos5l_decap_8
Xhold401 hold401/X _1781_/Q vccd vssd sg13cmos5l_dlygate4sd3_1
Xhold412 _1723_/D _1497_/X vccd vssd sg13cmos5l_dlygate4sd3_1
Xhold423 hold423/X _1675_/Q vccd vssd sg13cmos5l_dlygate4sd3_1
X_1757_ _1757_/Q _1757_/CLK _1757_/D fanout121/X vccd vssd sg13cmos5l_dfrbpq_1
XFILLER_28_2301 vccd vssd sg13cmos5l_decap_8
Xhold445 hold445/X _1774_/Q vccd vssd sg13cmos5l_dlygate4sd3_1
Xhold434 _1730_/D _1508_/X vccd vssd sg13cmos5l_dlygate4sd3_1
XFILLER_11_1169 vccd vssd sg13cmos5l_decap_8
Xhold478 hold478/X _1765_/Q vccd vssd sg13cmos5l_dlygate4sd3_1
X_1688_ _1688_/Q _1697_/CLK _1688_/D fanout137/X vccd vssd sg13cmos5l_dfrbpq_1
Xhold456 hold456/X _1754_/Q vccd vssd sg13cmos5l_dlygate4sd3_1
Xhold467 _1718_/D _1490_/X vccd vssd sg13cmos5l_dlygate4sd3_1
Xhold489 _1795_/D _1597_/X vccd vssd sg13cmos5l_dlygate4sd3_1
XFILLER_28_1644 vccd vssd sg13cmos5l_decap_8
XFILLER_45_2681 vccd vssd sg13cmos5l_decap_8
XFILLER_41_2523 vccd vssd sg13cmos5l_decap_8
XFILLER_26_2080 vccd vssd sg13cmos5l_decap_8
XFILLER_38_49 vccd vssd sg13cmos5l_decap_8
XFILLER_2_2016 vccd vssd sg13cmos5l_decap_8
XFILLER_6_2163 vccd vssd sg13cmos5l_decap_8
XFILLER_45_308 vccd vssd sg13cmos5l_decap_8
XFILLER_41_1866 vccd vssd sg13cmos5l_decap_8
XFILLER_38_371 vccd vssd sg13cmos5l_decap_8
XFILLER_26_511 vccd vssd sg13cmos5l_decap_8
XFILLER_2_1337 vccd vssd sg13cmos5l_decap_8
XFILLER_6_1484 vccd vssd sg13cmos5l_decap_8
XFILLER_22_1287 vccd vssd sg13cmos5l_decap_8
XFILLER_0_1050 vccd vssd sg13cmos5l_decap_8
XFILLER_14_728 vccd vssd sg13cmos5l_decap_8
XFILLER_41_558 vccd vssd sg13cmos5l_decap_8
XFILLER_39_1784 vccd vssd sg13cmos5l_decap_8
XFILLER_35_2327 vccd vssd sg13cmos5l_decap_8
XFILLER_13_238 vccd vssd sg13cmos5l_decap_8
XFILLER_35_1637 vccd vssd sg13cmos5l_decap_8
XFILLER_17_2783 vccd vssd sg13cmos5l_decap_8
XFILLER_33_2051 vccd vssd sg13cmos5l_decap_8
XFILLER_16_1036 vccd vssd sg13cmos5l_decap_8
XFILLER_10_945 vccd vssd sg13cmos5l_decap_8
XFILLER_13_1946 vccd vssd sg13cmos5l_decap_8
XFILLER_6_938 vccd vssd sg13cmos5l_decap_8
XFILLER_5_448 vccd vssd sg13cmos5l_decap_8
XFILLER_11_2382 vccd vssd sg13cmos5l_decap_8
XFILLER_29_1419 vccd vssd sg13cmos5l_decap_8
XFILLER_27_1110 vccd vssd sg13cmos5l_decap_8
XFILLER_1_665 vccd vssd sg13cmos5l_decap_8
XFILLER_7_1204 vccd vssd sg13cmos5l_decap_8
XFILLER_44_2180 vccd vssd sg13cmos5l_decap_8
XFILLER_40_2011 vccd vssd sg13cmos5l_decap_8
XFILLER_27_1187 vccd vssd sg13cmos5l_decap_8
XFILLER_24_2776 vccd vssd sg13cmos5l_decap_8
XFILLER_20_2618 vccd vssd sg13cmos5l_decap_8
XFILLER_0_175 vccd vssd sg13cmos5l_decap_8
XFILLER_44_1490 vccd vssd sg13cmos5l_decap_8
XFILLER_40_1332 vccd vssd sg13cmos5l_decap_4
XFILLER_36_308 vccd vssd sg13cmos5l_decap_8
XFILLER_40_2088 vccd vssd sg13cmos5l_decap_8
XFILLER_29_371 vccd vssd sg13cmos5l_decap_8
XFILLER_17_511 vccd vssd sg13cmos5l_decap_8
XFILLER_2_2583 vccd vssd sg13cmos5l_decap_8
XFILLER_45_875 vccd vssd sg13cmos5l_decap_8
XFILLER_18_2525 vccd vssd sg13cmos5l_decap_8
XFILLER_17_588 vccd vssd sg13cmos5l_decap_8
XFILLER_44_385 vccd vssd sg13cmos5l_decap_8
XFILLER_44_70 vccd vssd sg13cmos5l_decap_8
XFILLER_38_1250 vccd vssd sg13cmos5l_decap_8
XFILLER_32_525 vccd vssd sg13cmos5l_decap_8
XFILLER_18_1813 vccd vssd sg13cmos5l_decap_8
X_0990_ _0990_/Y _0990_/A _0990_/B _0990_/C vccd vssd sg13cmos5l_nand3_1
XFILLER_31_2703 vccd vssd sg13cmos5l_decap_8
XFILLER_18_1857 vccd vssd sg13cmos5l_decap_8
XFILLER_9_721 vccd vssd sg13cmos5l_decap_8
XFILLER_8_231 vccd vssd sg13cmos5l_decap_8
XFILLER_12_2135 vccd vssd sg13cmos5l_decap_8
XFILLER_9_798 vccd vssd sg13cmos5l_decap_8
XFILLER_12_1456 vccd vssd sg13cmos5l_decap_8
X_1611_ _1611_/Y _1639_/A _1639_/B_N vccd vssd sg13cmos5l_nor2b_1
X_1542_ _1542_/Y _1542_/A _1542_/B vccd vssd sg13cmos5l_nor2_1
XFILLER_29_2643 vccd vssd sg13cmos5l_decap_8
XFILLER_5_42 vccd vssd sg13cmos5l_decap_8
XFILLER_9_2715 vccd vssd sg13cmos5l_decap_4
X_1473_ _1473_/Y hold240/X _1472_/B _1472_/Y vccd vssd sg13cmos5l_a21oi_1
XFILLER_45_1232 vccd vssd sg13cmos5l_decap_8
XFILLER_7_2450 vccd vssd sg13cmos5l_decap_8
XFILLER_23_2253 vccd vssd sg13cmos5l_decap_8
XFILLER_3_2303 vccd vssd sg13cmos5l_decap_8
XFILLER_39_168 vccd vssd sg13cmos5l_decap_8
XFILLER_27_308 vccd vssd sg13cmos5l_decap_8
XFILLER_7_1771 vccd vssd sg13cmos5l_decap_8
XFILLER_36_820 vccd vssd sg13cmos5l_decap_8
XFILLER_3_1624 vccd vssd sg13cmos5l_decap_8
Xoutbuffers\[17\] control[17] _1685_/Q vccd vssd sg13cmos5l_buf_8
XFILLER_1_2093 vccd vssd sg13cmos5l_decap_8
XFILLER_36_2658 vccd vssd sg13cmos5l_decap_8
XFILLER_35_385 vccd vssd sg13cmos5l_decap_8
XFILLER_23_525 vccd vssd sg13cmos5l_decap_8
XFILLER_17_2046 vccd vssd sg13cmos5l_decap_8
XFILLER_17_1323 vccd vssd sg13cmos5l_decap_8
XFILLER_30_2246 vccd vssd sg13cmos5l_decap_8
XFILLER_40_28 vccd vssd sg13cmos5l_decap_8
XFILLER_30_1545 vccd vssd sg13cmos5l_decap_8
XFILLER_12_2680 vccd vssd sg13cmos5l_decap_8
Xhold220 hold220/X _1430_/Y vccd vssd sg13cmos5l_dlygate4sd3_1
X_1809_ _1809_/Q _1809_/CLK _1809_/D _1644_/Y vccd vssd sg13cmos5l_dfrbpq_1
Xhold242 _0867_/A _1690_/Q vccd vssd sg13cmos5l_dlygate4sd3_1
XFILLER_30_1589 vccd vssd sg13cmos5l_decap_8
Xhold253 _1532_/A _1748_/Q vccd vssd sg13cmos5l_dlygate4sd3_1
Xhold231 hold231/X _0837_/Y vccd vssd sg13cmos5l_dlygate4sd3_1
XFILLER_43_2618 vccd vssd sg13cmos5l_decap_8
Xhold286 _0840_/A _1757_/Q vccd vssd sg13cmos5l_dlygate4sd3_1
Xhold264 _0857_/A _1712_/Q vccd vssd sg13cmos5l_dlygate4sd3_1
Xhold275 hold275/X _0869_/Y vccd vssd sg13cmos5l_dlygate4sd3_1
XFILLER_28_1430 vccd vssd sg13cmos5l_decap_8
Xhold297 _1699_/D _1462_/X vccd vssd sg13cmos5l_dlygate4sd3_1
XFILLER_24_2028 vccd vssd sg13cmos5l_decap_8
XFILLER_8_2247 vccd vssd sg13cmos5l_decap_8
XFILLER_41_2342 vccd vssd sg13cmos5l_decap_8
XFILLER_24_1316 vccd vssd sg13cmos5l_decap_8
XFILLER_8_1568 vccd vssd sg13cmos5l_decap_8
XFILLER_41_1630 vccd vssd sg13cmos5l_decap_8
XFILLER_24_1338 vccd vssd sg13cmos5l_decap_8
XFILLER_18_308 vccd vssd sg13cmos5l_decap_8
XFILLER_45_105 vccd vssd sg13cmos5l_decap_8
XFILLER_41_1663 vccd vssd sg13cmos5l_decap_8
XFILLER_6_1281 vccd vssd sg13cmos5l_decap_8
XFILLER_2_1134 vccd vssd sg13cmos5l_decap_8
XFILLER_42_856 vccd vssd sg13cmos5l_decap_8
XFILLER_41_333 vccd vssd sg13cmos5l_decap_8
XFILLER_39_2293 vccd vssd sg13cmos5l_decap_8
XFILLER_35_2102 vccd vssd sg13cmos5l_decap_8
XFILLER_26_385 vccd vssd sg13cmos5l_decap_8
XFILLER_14_525 vccd vssd sg13cmos5l_decap_8
XFILLER_41_366 vccd vssd sg13cmos5l_decap_4
XFILLER_39_1570 vccd vssd sg13cmos5l_decap_8
XFILLER_35_2168 vccd vssd sg13cmos5l_decap_8
XFILLER_35_1489 vccd vssd sg13cmos5l_decap_8
XFILLER_10_742 vccd vssd sg13cmos5l_decap_8
XFILLER_14_84 vccd vssd sg13cmos5l_decap_8
XFILLER_6_735 vccd vssd sg13cmos5l_decap_8
XFILLER_13_1743 vccd vssd sg13cmos5l_decap_8
XFILLER_5_245 vccd vssd sg13cmos5l_decap_8
Xtiedowns\[53\] status[53] vccd vssd sg13cmos5l_antennanp
XFILLER_29_1249 vccd vssd sg13cmos5l_decap_8
XFILLER_2_952 vccd vssd sg13cmos5l_decap_8
XFILLER_1_462 vccd vssd sg13cmos5l_decap_8
XFILLER_7_1001 vccd vssd sg13cmos5l_decap_8
XFILLER_39_70 vccd vssd sg13cmos5l_decap_8
XFILLER_24_2573 vccd vssd sg13cmos5l_decap_8
XFILLER_20_2415 vccd vssd sg13cmos5l_decap_8
XFILLER_4_1911 vccd vssd sg13cmos5l_decap_8
XFILLER_7_1078 vccd vssd sg13cmos5l_decap_8
XFILLER_37_628 vccd vssd sg13cmos5l_decap_8
XFILLER_36_105 vccd vssd sg13cmos5l_decap_8
XFILLER_24_1861 vccd vssd sg13cmos5l_decap_8
XFILLER_20_1703 vccd vssd sg13cmos5l_decap_8
XFILLER_4_2667 vccd vssd sg13cmos5l_decap_8
XFILLER_2_2380 vccd vssd sg13cmos5l_decap_8
XFILLER_4_1988 vccd vssd sg13cmos5l_decap_8
XFILLER_45_672 vccd vssd sg13cmos5l_decap_8
XFILLER_40_1195 vccd vssd sg13cmos5l_decap_8
XFILLER_33_801 vccd vssd sg13cmos5l_decap_8
XFILLER_18_875 vccd vssd sg13cmos5l_decap_8
XFILLER_44_171 vccd vssd sg13cmos5l_decap_8
XFILLER_32_322 vccd vssd sg13cmos5l_decap_8
XFILLER_17_385 vccd vssd sg13cmos5l_decap_8
XFILLER_18_1610 vccd vssd sg13cmos5l_decap_8
XFILLER_14_2208 vccd vssd sg13cmos5l_decap_8
Xoutbuffers\[107\] control[107] _1775_/Q vccd vssd sg13cmos5l_buf_8
XFILLER_32_399 vccd vssd sg13cmos5l_decap_8
XFILLER_20_539 vccd vssd sg13cmos5l_decap_8
XFILLER_18_2399 vccd vssd sg13cmos5l_decap_8
X_0973_ _1137_/B _0982_/C _0988_/C vccd vssd sg13cmos5l_or2_1
XFILLER_18_1687 vccd vssd sg13cmos5l_decap_8
XFILLER_31_2577 vccd vssd sg13cmos5l_decap_8
XFILLER_31_1832 vccd vssd sg13cmos5l_decap_8
XFILLER_9_595 vccd vssd sg13cmos5l_decap_8
XFILLER_31_1876 vccd vssd sg13cmos5l_decap_8
XFILLER_31_1854 vccd vssd sg13cmos5l_decap_8
XFILLER_12_1253 vccd vssd sg13cmos5l_decap_8
X_1525_ _1525_/X _1562_/A hold330/X _1528_/B vccd vssd sg13cmos5l_mux2_1
XFILLER_9_2523 vccd vssd sg13cmos5l_decap_8
X_1456_ _1456_/X _1547_/A hold300/X _1461_/S vccd vssd sg13cmos5l_mux2_1
XFILLER_29_1794 vccd vssd sg13cmos5l_decap_8
XFILLER_3_2100 vccd vssd sg13cmos5l_decap_8
XFILLER_5_1708 vccd vssd sg13cmos5l_decap_8
XFILLER_9_1855 vccd vssd sg13cmos5l_decap_8
XFILLER_25_1658 vccd vssd sg13cmos5l_decap_8
X_1387_ _1387_/Y _1385_/Y _1387_/B vccd vssd sg13cmos5l_nand2b_1
XFILLER_27_105 vccd vssd sg13cmos5l_decap_8
XFILLER_3_1421 vccd vssd sg13cmos5l_decap_8
XFILLER_42_1994 vccd vssd sg13cmos5l_decap_8
XFILLER_3_2177 vccd vssd sg13cmos5l_decap_8
XFILLER_35_28 vccd vssd sg13cmos5l_decap_8
XFILLER_24_812 vccd vssd sg13cmos5l_decap_8
XFILLER_19_2108 vccd vssd sg13cmos5l_decap_8
XFILLER_3_1498 vccd vssd sg13cmos5l_decap_8
XFILLER_42_119 vccd vssd sg13cmos5l_decap_8
XFILLER_35_182 vccd vssd sg13cmos5l_decap_8
XFILLER_23_322 vccd vssd sg13cmos5l_decap_8
XFILLER_19_1407 vccd vssd sg13cmos5l_decap_8
XFILLER_24_889 vccd vssd sg13cmos5l_decap_8
XFILLER_36_2477 vccd vssd sg13cmos5l_decap_8
XFILLER_32_2319 vccd vssd sg13cmos5l_decap_8
XFILLER_23_399 vccd vssd sg13cmos5l_decap_8
XFILLER_17_1120 vccd vssd sg13cmos5l_decap_8
XFILLER_11_539 vccd vssd sg13cmos5l_decap_8
XFILLER_14_2720 vccd vssd sg13cmos5l_decap_4
XFILLER_36_1787 vccd vssd sg13cmos5l_decap_8
XFILLER_32_1618 vccd vssd sg13cmos5l_decap_8
XFILLER_14_2764 vccd vssd sg13cmos5l_decap_8
XFILLER_17_1197 vccd vssd sg13cmos5l_decap_8
XFILLER_10_2628 vccd vssd sg13cmos5l_decap_8
XFILLER_30_2076 vccd vssd sg13cmos5l_decap_8
XFILLER_30_1353 vccd vssd sg13cmos5l_decap_8
XFILLER_3_749 vccd vssd sg13cmos5l_decap_8
XFILLER_43_2404 vccd vssd sg13cmos5l_decap_8
XFILLER_2_259 vccd vssd sg13cmos5l_decap_8
XFILLER_8_2044 vccd vssd sg13cmos5l_decap_8
XFILLER_28_1260 vccd vssd sg13cmos5l_decap_8
XFILLER_24_1135 vccd vssd sg13cmos5l_decap_8
XFILLER_21_2713 vccd vssd sg13cmos5l_decap_8
XFILLER_8_1365 vccd vssd sg13cmos5l_decap_8
XFILLER_18_105 vccd vssd sg13cmos5l_decap_8
XFILLER_4_1218 vccd vssd sg13cmos5l_decap_8
XFILLER_41_1482 vccd vssd sg13cmos5l_decap_8
XFILLER_37_2208 vccd vssd sg13cmos5l_decap_8
XFILLER_15_812 vccd vssd sg13cmos5l_decap_8
XFILLER_33_119 vccd vssd sg13cmos5l_decap_8
XFILLER_26_182 vccd vssd sg13cmos5l_decap_8
XFILLER_14_322 vccd vssd sg13cmos5l_decap_8
XFILLER_39_2090 vccd vssd sg13cmos5l_decap_8
XFILLER_19_2664 vccd vssd sg13cmos5l_decap_8
XFILLER_15_889 vccd vssd sg13cmos5l_decap_8
XFILLER_30_826 vccd vssd sg13cmos5l_decap_8
XFILLER_14_399 vccd vssd sg13cmos5l_decap_8
XFILLER_41_196 vccd vssd sg13cmos5l_decap_8
XFILLER_15_1827 vccd vssd sg13cmos5l_decap_8
XFILLER_13_2230 vccd vssd sg13cmos5l_decap_8
XFILLER_31_1117 vccd vssd sg13cmos5l_decap_8
XFILLER_6_532 vccd vssd sg13cmos5l_decap_8
XFILLER_13_1540 vccd vssd sg13cmos5l_decap_8
XFILLER_44_7 vccd vssd sg13cmos5l_decap_8
XFILLER_26_2635 vccd vssd sg13cmos5l_decap_8
X_1310_ _1311_/C status[89] _1357_/C1 wire74/X status[121] vccd vssd sg13cmos5l_a22oi_1
XFILLER_42_1235 vccd vssd sg13cmos5l_decap_8
XFILLER_38_904 vccd vssd sg13cmos5l_decap_8
X_1241_ _1241_/Y _0853_/Y _1531_/B _1284_/B1 vccd vssd sg13cmos5l_a21oi_1
XFILLER_22_1809 vccd vssd sg13cmos5l_decap_8
XFILLER_2_21 vccd vssd sg13cmos5l_decap_8
XFILLER_26_1989 vccd vssd sg13cmos5l_decap_8
XFILLER_24_2381 vccd vssd sg13cmos5l_decap_8
XFILLER_4_2464 vccd vssd sg13cmos5l_decap_8
X_1172_ _1172_/Y mask_rev_in[29] _1350_/B vccd vssd sg13cmos5l_nor2b_1
XFILLER_24_1680 vccd vssd sg13cmos5l_decap_8
XFILLER_20_1500 vccd vssd sg13cmos5l_decap_8
XFILLER_2_98 vccd vssd sg13cmos5l_decap_8
XFILLER_0_2317 vccd vssd sg13cmos5l_decap_8
XFILLER_20_2278 vccd vssd sg13cmos5l_decap_8
XFILLER_18_672 vccd vssd sg13cmos5l_decap_8
XFILLER_0_1638 vccd vssd sg13cmos5l_decap_8
XFILLER_4_1785 vccd vssd sg13cmos5l_decap_8
XFILLER_24_119 vccd vssd sg13cmos5l_decap_8
XFILLER_20_1577 vccd vssd sg13cmos5l_decap_8
XFILLER_17_182 vccd vssd sg13cmos5l_decap_8
XFILLER_18_2130 vccd vssd sg13cmos5l_decap_8
XFILLER_37_2786 vccd vssd sg13cmos5l_decap_4
XFILLER_36_1039 vccd vssd sg13cmos5l_decap_8
XFILLER_21_826 vccd vssd sg13cmos5l_decap_8
XFILLER_14_2016 vccd vssd sg13cmos5l_decap_8
XFILLER_32_196 vccd vssd sg13cmos5l_decap_8
XFILLER_20_336 vccd vssd sg13cmos5l_decap_8
XFILLER_18_1484 vccd vssd sg13cmos5l_decap_8
XFILLER_31_2341 vccd vssd sg13cmos5l_decap_8
X_0956_ _0997_/A _1799_/Q _1798_/Q _0957_/S vccd vssd sg13cmos5l_mux2_1
XFILLER_14_1337 vccd vssd sg13cmos5l_decap_8
XFILLER_31_2396 vccd vssd sg13cmos5l_decap_8
XFILLER_31_1640 vccd vssd sg13cmos5l_decap_8
XFILLER_9_392 vccd vssd sg13cmos5l_decap_8
Xoutbuffers\[84\] control[84] _1752_/Q vccd vssd sg13cmos5l_buf_8
X_0887_ _0887_/Y _0887_/A _0887_/B vccd vssd sg13cmos5l_nor2_1
XFILLER_12_1050 vccd vssd sg13cmos5l_decap_8
XFILLER_44_2702 vccd vssd sg13cmos5l_decap_8
XFILLER_9_2331 vccd vssd sg13cmos5l_decap_8
XFILLER_25_1411 vccd vssd sg13cmos5l_decap_8
X_1508_ _1508_/X _1528_/A hold433/X _1508_/S vccd vssd sg13cmos5l_mux2_1
XFILLER_44_2779 vccd vssd sg13cmos5l_decap_8
X_1439_ _1439_/Y _1520_/A _1439_/B vccd vssd sg13cmos5l_nand2_1
XFILLER_29_904 vccd vssd sg13cmos5l_decap_8
XFILLER_25_2178 vccd vssd sg13cmos5l_decap_8
XFILLER_5_1505 vccd vssd sg13cmos5l_decap_8
XFILLER_9_1652 vccd vssd sg13cmos5l_decap_8
XFILLER_25_1466 vccd vssd sg13cmos5l_decap_8
XFILLER_28_469 vccd vssd sg13cmos5l_decap_8
XFILLER_16_609 vccd vssd sg13cmos5l_decap_8
XFILLER_38_2539 vccd vssd sg13cmos5l_decap_8
XFILLER_3_1295 vccd vssd sg13cmos5l_decap_8
XFILLER_15_119 vccd vssd sg13cmos5l_decap_8
XFILLER_19_1204 vccd vssd sg13cmos5l_decap_8
XFILLER_24_686 vccd vssd sg13cmos5l_decap_8
XFILLER_12_826 vccd vssd sg13cmos5l_decap_8
XFILLER_36_1562 vccd vssd sg13cmos5l_decap_8
XFILLER_23_196 vccd vssd sg13cmos5l_decap_8
XFILLER_8_819 vccd vssd sg13cmos5l_decap_8
XFILLER_11_336 vccd vssd sg13cmos5l_decap_8
XFILLER_7_329 vccd vssd sg13cmos5l_decap_8
XFILLER_14_2561 vccd vssd sg13cmos5l_decap_8
XFILLER_3_546 vccd vssd sg13cmos5l_decap_8
XFILLER_10_1757 vccd vssd sg13cmos5l_decap_8
XFILLER_11_63 vccd vssd sg13cmos5l_decap_8
XFILLER_43_2245 vccd vssd sg13cmos5l_decap_8
XFILLER_43_1522 vccd vssd sg13cmos5l_decap_8
XFILLER_21_2510 vccd vssd sg13cmos5l_decap_8
XFILLER_1_2604 vccd vssd sg13cmos5l_decap_8
XFILLER_4_1015 vccd vssd sg13cmos5l_decap_8
XFILLER_8_1162 vccd vssd sg13cmos5l_decap_8
Xtiedowns\[16\] status[16] vccd vssd sg13cmos5l_antennanp
XFILLER_41_1290 vccd vssd sg13cmos5l_decap_8
XFILLER_21_2587 vccd vssd sg13cmos5l_decap_8
XFILLER_19_469 vccd vssd sg13cmos5l_decap_8
XFILLER_1_1925 vccd vssd sg13cmos5l_decap_8
XFILLER_21_1897 vccd vssd sg13cmos5l_decap_8
XFILLER_37_1304 vccd vssd sg13cmos5l_decap_8
XFILLER_30_601 vccd vssd sg13cmos5l_decap_8
XFILLER_19_2483 vccd vssd sg13cmos5l_decap_8
XFILLER_15_686 vccd vssd sg13cmos5l_decap_8
XFILLER_19_1771 vccd vssd sg13cmos5l_decap_8
XFILLER_14_196 vccd vssd sg13cmos5l_decap_8
XFILLER_35_1061 vccd vssd sg13cmos5l_decap_8
X_1790_ _1790_/Q _1790_/CLK _1790_/D fanout114/X vccd vssd sg13cmos5l_dfrbpq_1
XFILLER_32_2672 vccd vssd sg13cmos5l_decap_8
XFILLER_15_1624 vccd vssd sg13cmos5l_decap_8
XFILLER_32_1982 vccd vssd sg13cmos5l_decap_8
XFILLER_13_2093 vccd vssd sg13cmos5l_decap_8
XFILLER_7_896 vccd vssd sg13cmos5l_decap_8
XFILLER_44_1308 vccd vssd sg13cmos5l_decap_8
XFILLER_26_2443 vccd vssd sg13cmos5l_decap_8
XFILLER_26_1720 vccd vssd sg13cmos5l_decap_8
XFILLER_22_2329 vccd vssd sg13cmos5l_decap_8
XFILLER_6_2548 vccd vssd sg13cmos5l_decap_8
XFILLER_26_1775 vccd vssd sg13cmos5l_decap_8
XFILLER_22_1606 vccd vssd sg13cmos5l_decap_8
X_1224_ _1224_/Y _0856_/Y _1359_/A2 _1225_/B vccd vssd sg13cmos5l_a21oi_1
XFILLER_42_1054 vccd vssd sg13cmos5l_decap_8
XFILLER_0_2114 vccd vssd sg13cmos5l_decap_8
XFILLER_4_2261 vccd vssd sg13cmos5l_decap_8
XFILLER_6_1869 vccd vssd sg13cmos5l_decap_8
X_1155_ _1155_/Y _1753_/Q _1155_/B vccd vssd sg13cmos5l_nand2b_1
XFILLER_37_266 vccd vssd sg13cmos5l_decap_8
XFILLER_25_406 vccd vssd sg13cmos5l_decap_8
XFILLER_20_1330 vccd vssd sg13cmos5l_decap_8
X_1086_ _1089_/A status[94] _1357_/C1 _1261_/B vccd vssd sg13cmos5l_a21oi_1
XFILLER_0_1435 vccd vssd sg13cmos5l_decap_8
XFILLER_4_1582 vccd vssd sg13cmos5l_decap_8
XFILLER_34_962 vccd vssd sg13cmos5l_decap_4
XFILLER_37_2583 vccd vssd sg13cmos5l_decap_8
XFILLER_33_2425 vccd vssd sg13cmos5l_decap_4
XFILLER_21_623 vccd vssd sg13cmos5l_decap_8
XFILLER_33_2469 vccd vssd sg13cmos5l_decap_8
XFILLER_20_133 vccd vssd sg13cmos5l_decap_8
XFILLER_18_1281 vccd vssd sg13cmos5l_decap_8
XFILLER_11_2734 vccd vssd sg13cmos5l_decap_8
XFILLER_14_1134 vccd vssd sg13cmos5l_decap_8
X_0939_ _0939_/Y hold449/X _0939_/B vccd vssd sg13cmos5l_nand2b_1
XFILLER_44_2576 vccd vssd sg13cmos5l_decap_8
XFILLER_27_1539 vccd vssd sg13cmos5l_decap_8
XFILLER_40_2429 vccd vssd sg13cmos5l_decap_8
XFILLER_25_1252 vccd vssd sg13cmos5l_decap_8
XFILLER_5_1302 vccd vssd sg13cmos5l_decap_8
XFILLER_5_2058 vccd vssd sg13cmos5l_decap_8
XFILLER_40_1739 vccd vssd sg13cmos5l_decap_8
XFILLER_29_734 vccd vssd sg13cmos5l_decap_8
XFILLER_21_1127 vccd vssd sg13cmos5l_decap_8
XFILLER_28_266 vccd vssd sg13cmos5l_decap_8
XFILLER_16_406 vccd vssd sg13cmos5l_decap_8
XFILLER_5_1379 vccd vssd sg13cmos5l_decap_8
XFILLER_44_726 vccd vssd sg13cmos5l_decap_8
XFILLER_38_2336 vccd vssd sg13cmos5l_decap_8
Xwire81 wire81/X wire81/A vccd vssd sg13cmos5l_buf_4
XFILLER_25_962 vccd vssd sg13cmos5l_decap_8
XFILLER_19_1001 vccd vssd sg13cmos5l_decap_8
XFILLER_3_1092 vccd vssd sg13cmos5l_decap_8
XFILLER_0_2681 vccd vssd sg13cmos5l_decap_8
XFILLER_38_1657 vccd vssd sg13cmos5l_decap_8
XFILLER_40_954 vccd vssd sg13cmos5l_decap_8
XFILLER_24_483 vccd vssd sg13cmos5l_decap_8
XFILLER_19_1078 vccd vssd sg13cmos5l_decap_8
XFILLER_12_623 vccd vssd sg13cmos5l_decap_8
XFILLER_16_1944 vccd vssd sg13cmos5l_decap_8
XFILLER_8_616 vccd vssd sg13cmos5l_decap_8
XFILLER_11_133 vccd vssd sg13cmos5l_decap_8
XFILLER_32_1234 vccd vssd sg13cmos5l_decap_8
XFILLER_7_126 vccd vssd sg13cmos5l_decap_8
XFILLER_22_84 vccd vssd sg13cmos5l_decap_8
XFILLER_10_2233 vccd vssd sg13cmos5l_decap_8
XFILLER_4_833 vccd vssd sg13cmos5l_decap_8
XFILLER_3_343 vccd vssd sg13cmos5l_decap_8
XFILLER_10_1554 vccd vssd sg13cmos5l_decap_8
XFILLER_45_1617 vccd vssd sg13cmos5l_decap_8
XFILLER_27_2763 vccd vssd sg13cmos5l_decap_8
XFILLER_0_0 vccd vssd sg13cmos5l_decap_8
XFILLER_43_2042 vccd vssd sg13cmos5l_decap_8
XFILLER_23_2627 vccd vssd sg13cmos5l_decap_8
XFILLER_23_1904 vccd vssd sg13cmos5l_decap_8
XFILLER_23_1948 vccd vssd sg13cmos5l_decap_8
XFILLER_23_1926 vccd vssd sg13cmos5l_decap_8
XFILLER_1_2401 vccd vssd sg13cmos5l_decap_8
XFILLER_5_2581 vccd vssd sg13cmos5l_decap_8
XFILLER_21_2384 vccd vssd sg13cmos5l_decap_8
XFILLER_34_203 vccd vssd sg13cmos5l_decap_8
XFILLER_21_1683 vccd vssd sg13cmos5l_decap_8
XFILLER_19_266 vccd vssd sg13cmos5l_decap_8
XFILLER_1_2478 vccd vssd sg13cmos5l_decap_8
XFILLER_1_1722 vccd vssd sg13cmos5l_decap_8
XFILLER_17_1708 vccd vssd sg13cmos5l_decap_8
XFILLER_16_973 vccd vssd sg13cmos5l_decap_8
XFILLER_15_2100 vccd vssd sg13cmos5l_decap_8
XFILLER_1_1799 vccd vssd sg13cmos5l_decap_8
XFILLER_37_1156 vccd vssd sg13cmos5l_decap_8
XFILLER_34_2756 vccd vssd sg13cmos5l_decap_8
XFILLER_31_943 vccd vssd sg13cmos5l_decap_8
XFILLER_30_420 vccd vssd sg13cmos5l_decap_8
XFILLER_15_483 vccd vssd sg13cmos5l_decap_8
XFILLER_15_1421 vccd vssd sg13cmos5l_decap_8
XFILLER_8_42 vccd vssd sg13cmos5l_decap_8
X_1773_ _1773_/Q _1779_/CLK _1773_/D fanout116/X vccd vssd sg13cmos5l_dfrbpq_1
XFILLER_15_1498 vccd vssd sg13cmos5l_decap_8
XFILLER_32_1790 vccd vssd sg13cmos5l_decap_8
XFILLER_7_693 vccd vssd sg13cmos5l_decap_8
XFILLER_28_2527 vccd vssd sg13cmos5l_decap_8
XFILLER_28_1826 vccd vssd sg13cmos5l_decap_8
XFILLER_44_1105 vccd vssd sg13cmos5l_decap_8
XFILLER_41_2705 vccd vssd sg13cmos5l_decap_8
XFILLER_33_0 vccd vssd sg13cmos5l_decap_8
XFILLER_6_2345 vccd vssd sg13cmos5l_decap_8
Xoutbuffers\[47\] control[47] _1715_/Q vccd vssd sg13cmos5l_buf_8
XFILLER_26_1572 vccd vssd sg13cmos5l_decap_4
XFILLER_22_2148 vccd vssd sg13cmos5l_decap_8
XFILLER_6_1666 vccd vssd sg13cmos5l_decap_8
X_1207_ _1207_/Y _1688_/Q _1342_/B vccd vssd sg13cmos5l_nand2b_1
XFILLER_22_1436 vccd vssd sg13cmos5l_decap_8
XFILLER_2_1519 vccd vssd sg13cmos5l_decap_8
XFILLER_39_2612 vccd vssd sg13cmos5l_decap_8
XFILLER_25_203 vccd vssd sg13cmos5l_decap_8
X_1138_ _1138_/X _1314_/B _1138_/B _1138_/C vccd vssd sg13cmos5l_or3_1
XFILLER_0_1232 vccd vssd sg13cmos5l_decap_8
XFILLER_43_28 vccd vssd sg13cmos5l_decap_8
XFILLER_39_2689 vccd vssd sg13cmos5l_decap_8
XFILLER_40_217 vccd vssd sg13cmos5l_decap_8
XFILLER_22_910 vccd vssd sg13cmos5l_decap_8
X_1069_ _1069_/Y _1062_/X _1065_/Y _1068_/Y vccd vssd sg13cmos5l_a21oi_2
XFILLER_33_280 vccd vssd sg13cmos5l_decap_8
XFILLER_21_420 vccd vssd sg13cmos5l_decap_8
XFILLER_16_1218 vccd vssd sg13cmos5l_decap_8
XFILLER_22_987 vccd vssd sg13cmos5l_decap_8
XFILLER_33_1532 vccd vssd sg13cmos5l_decap_8
XFILLER_21_497 vccd vssd sg13cmos5l_decap_8
XFILLER_33_1576 vccd vssd sg13cmos5l_decap_8
XFILLER_11_1841 vccd vssd sg13cmos5l_decap_8
XFILLER_27_2059 vccd vssd sg13cmos5l_decap_8
XFILLER_27_1336 vccd vssd sg13cmos5l_decap_8
XFILLER_1_847 vccd vssd sg13cmos5l_decap_8
XFILLER_44_2373 vccd vssd sg13cmos5l_decap_8
XFILLER_40_2215 vccd vssd sg13cmos5l_decap_8
XFILLER_0_357 vccd vssd sg13cmos5l_decap_8
XFILLER_44_1672 vccd vssd sg13cmos5l_decap_8
XFILLER_40_1536 vccd vssd sg13cmos5l_decap_8
XFILLER_25_1071 vccd vssd sg13cmos5l_decap_8
XFILLER_29_586 vccd vssd sg13cmos5l_decap_8
XFILLER_16_203 vccd vssd sg13cmos5l_decap_8
XFILLER_2_2765 vccd vssd sg13cmos5l_decap_8
XFILLER_1_1029 vccd vssd sg13cmos5l_decap_8
XFILLER_5_1176 vccd vssd sg13cmos5l_decap_8
XFILLER_32_707 vccd vssd sg13cmos5l_decap_8
XFILLER_44_578 vccd vssd sg13cmos5l_decap_8
XFILLER_31_217 vccd vssd sg13cmos5l_decap_8
XFILLER_18_2729 vccd vssd sg13cmos5l_decap_8
XFILLER_17_84 vccd vssd sg13cmos5l_decap_8
XFILLER_13_910 vccd vssd sg13cmos5l_decap_8
XFILLER_24_280 vccd vssd sg13cmos5l_decap_8
XFILLER_9_903 vccd vssd sg13cmos5l_decap_8
XFILLER_12_420 vccd vssd sg13cmos5l_decap_8
XFILLER_38_1498 vccd vssd sg13cmos5l_decap_8
XFILLER_8_413 vccd vssd sg13cmos5l_decap_8
XFILLER_13_987 vccd vssd sg13cmos5l_decap_8
Xtiedowns\[83\] status[83] vccd vssd sg13cmos5l_antennanp
XFILLER_16_2486 vccd vssd sg13cmos5l_decap_8
XFILLER_12_497 vccd vssd sg13cmos5l_decap_8
XFILLER_12_2328 vccd vssd sg13cmos5l_decap_8
XFILLER_16_1785 vccd vssd sg13cmos5l_decap_8
XFILLER_10_2030 vccd vssd sg13cmos5l_decap_8
XFILLER_12_1638 vccd vssd sg13cmos5l_decap_8
XFILLER_4_630 vccd vssd sg13cmos5l_decap_8
XFILLER_10_1351 vccd vssd sg13cmos5l_decap_8
XFILLER_3_140 vccd vssd sg13cmos5l_decap_8
XFILLER_45_1414 vccd vssd sg13cmos5l_decap_8
XFILLER_23_2424 vccd vssd sg13cmos5l_decap_8
XFILLER_7_2654 vccd vssd sg13cmos5l_decap_8
XFILLER_23_1734 vccd vssd sg13cmos5l_decap_8
XFILLER_7_1953 vccd vssd sg13cmos5l_decap_8
XFILLER_40_2771 vccd vssd sg13cmos5l_decap_8
XFILLER_3_1806 vccd vssd sg13cmos5l_decap_8
XFILLER_21_1480 vccd vssd sg13cmos5l_decap_8
XFILLER_1_2275 vccd vssd sg13cmos5l_decap_8
XFILLER_23_707 vccd vssd sg13cmos5l_decap_8
XFILLER_16_770 vccd vssd sg13cmos5l_decap_8
XFILLER_1_1596 vccd vssd sg13cmos5l_decap_8
XFILLER_22_217 vccd vssd sg13cmos5l_decap_8
XFILLER_17_1505 vccd vssd sg13cmos5l_decap_8
XFILLER_15_280 vccd vssd sg13cmos5l_decap_8
XFILLER_34_2553 vccd vssd sg13cmos5l_decap_8
XFILLER_34_1885 vccd vssd sg13cmos5l_decap_4
XFILLER_30_294 vccd vssd sg13cmos5l_decap_8
Xhold402 _1781_/D _1581_/X vccd vssd sg13cmos5l_dlygate4sd3_1
X_1756_ _1756_/Q clkload1/A _1756_/D fanout121/X vccd vssd sg13cmos5l_dfrbpq_1
XFILLER_15_1295 vccd vssd sg13cmos5l_decap_8
XFILLER_8_980 vccd vssd sg13cmos5l_decap_8
XFILLER_11_1148 vccd vssd sg13cmos5l_decap_8
Xhold424 _1675_/D _1428_/X vccd vssd sg13cmos5l_dlygate4sd3_1
Xhold413 hold413/X _1733_/Q vccd vssd sg13cmos5l_dlygate4sd3_1
Xhold435 hold435/X _1736_/Q vccd vssd sg13cmos5l_dlygate4sd3_1
XFILLER_7_490 vccd vssd sg13cmos5l_decap_8
X_1687_ _1687_/Q _1699_/CLK _1687_/D fanout134/X vccd vssd sg13cmos5l_dfrbpq_1
Xhold446 _1774_/D _1572_/X vccd vssd sg13cmos5l_dlygate4sd3_1
Xhold457 _1754_/D _1541_/X vccd vssd sg13cmos5l_dlygate4sd3_1
Xhold468 _0900_/A _1647_/Q vccd vssd sg13cmos5l_dlygate4sd3_1
XFILLER_45_2660 vccd vssd sg13cmos5l_decap_8
Xhold479 _1765_/D _1559_/X vccd vssd sg13cmos5l_dlygate4sd3_1
XFILLER_8_2429 vccd vssd sg13cmos5l_decap_8
XFILLER_41_2502 vccd vssd sg13cmos5l_decap_8
XFILLER_6_2142 vccd vssd sg13cmos5l_decap_8
XFILLER_45_1981 vccd vssd sg13cmos5l_decap_8
XFILLER_38_28 vccd vssd sg13cmos5l_decap_8
XFILLER_41_2579 vccd vssd sg13cmos5l_decap_8
XFILLER_41_1845 vccd vssd sg13cmos5l_decap_8
XFILLER_26_1391 vccd vssd sg13cmos5l_decap_8
XFILLER_22_1211 vccd vssd sg13cmos5l_decap_4
XFILLER_6_1463 vccd vssd sg13cmos5l_decap_8
XFILLER_38_350 vccd vssd sg13cmos5l_decap_8
XFILLER_22_1266 vccd vssd sg13cmos5l_decap_8
XFILLER_2_1316 vccd vssd sg13cmos5l_decap_8
XFILLER_39_2420 vccd vssd sg13cmos5l_decap_8
XFILLER_39_2486 vccd vssd sg13cmos5l_decap_8
XFILLER_35_2306 vccd vssd sg13cmos5l_decap_8
XFILLER_14_707 vccd vssd sg13cmos5l_decap_8
XFILLER_41_537 vccd vssd sg13cmos5l_decap_8
XFILLER_39_1763 vccd vssd sg13cmos5l_decap_8
XFILLER_13_217 vccd vssd sg13cmos5l_decap_8
XFILLER_35_1616 vccd vssd sg13cmos5l_decap_8
XFILLER_33_2030 vccd vssd sg13cmos5l_decap_8
XFILLER_17_2762 vccd vssd sg13cmos5l_decap_8
XFILLER_16_1015 vccd vssd sg13cmos5l_decap_8
XFILLER_22_784 vccd vssd sg13cmos5l_decap_8
XFILLER_10_924 vccd vssd sg13cmos5l_decap_8
XFILLER_21_294 vccd vssd sg13cmos5l_decap_8
XFILLER_6_917 vccd vssd sg13cmos5l_decap_8
XFILLER_13_1925 vccd vssd sg13cmos5l_decap_8
XFILLER_33_1384 vccd vssd sg13cmos5l_decap_8
XFILLER_5_427 vccd vssd sg13cmos5l_decap_8
XFILLER_11_2361 vccd vssd sg13cmos5l_decap_8
XFILLER_1_644 vccd vssd sg13cmos5l_decap_8
XFILLER_0_154 vccd vssd sg13cmos5l_decap_8
XFILLER_27_1166 vccd vssd sg13cmos5l_decap_8
XFILLER_24_2755 vccd vssd sg13cmos5l_decap_8
XFILLER_23_1008 vccd vssd sg13cmos5l_decap_8
XFILLER_40_2067 vccd vssd sg13cmos5l_decap_8
XFILLER_29_350 vccd vssd sg13cmos5l_decap_8
XFILLER_2_2562 vccd vssd sg13cmos5l_decap_8
XFILLER_45_854 vccd vssd sg13cmos5l_decap_8
XFILLER_40_1388 vccd vssd sg13cmos5l_decap_8
XFILLER_44_364 vccd vssd sg13cmos5l_decap_8
XFILLER_32_504 vccd vssd sg13cmos5l_decap_8
XFILLER_18_2504 vccd vssd sg13cmos5l_decap_8
XFILLER_17_567 vccd vssd sg13cmos5l_decap_8
XFILLER_2_1883 vccd vssd sg13cmos5l_decap_8
XFILLER_18_2559 vccd vssd sg13cmos5l_decap_8
XFILLER_9_700 vccd vssd sg13cmos5l_decap_8
XFILLER_8_210 vccd vssd sg13cmos5l_decap_8
XFILLER_12_2114 vccd vssd sg13cmos5l_decap_8
XFILLER_13_784 vccd vssd sg13cmos5l_decap_8
XFILLER_34_1159 vccd vssd sg13cmos5l_decap_8
XFILLER_31_2759 vccd vssd sg13cmos5l_decap_8
XFILLER_16_1582 vccd vssd sg13cmos5l_decap_8
XFILLER_9_777 vccd vssd sg13cmos5l_decap_8
XFILLER_12_294 vccd vssd sg13cmos5l_decap_8
X_1610_ _1610_/Y _1639_/A _1639_/B_N vccd vssd sg13cmos5l_nor2b_1
XFILLER_8_287 vccd vssd sg13cmos5l_decap_8
XFILLER_12_1435 vccd vssd sg13cmos5l_decap_8
XFILLER_29_2622 vccd vssd sg13cmos5l_decap_8
XFILLER_5_21 vccd vssd sg13cmos5l_decap_8
X_1541_ _1541_/X _1528_/A hold456/X _1541_/S vccd vssd sg13cmos5l_mux2_1
XFILLER_5_994 vccd vssd sg13cmos5l_decap_8
XFILLER_45_1211 vccd vssd sg13cmos5l_decap_8
X_1472_ _1472_/Y _1472_/A _1472_/B vccd vssd sg13cmos5l_nor2_1
XFILLER_29_2699 vccd vssd sg13cmos5l_decap_8
XFILLER_29_1932 vccd vssd sg13cmos5l_decap_4
XFILLER_5_98 vccd vssd sg13cmos5l_decap_8
XFILLER_9_2749 vccd vssd sg13cmos5l_decap_8
XFILLER_25_1818 vccd vssd sg13cmos5l_decap_8
XFILLER_45_1288 vccd vssd sg13cmos5l_decap_8
XFILLER_23_2232 vccd vssd sg13cmos5l_decap_8
Xtiedowns\[127\] status[127] vccd vssd sg13cmos5l_antennanp
XFILLER_39_147 vccd vssd sg13cmos5l_decap_8
XFILLER_3_1603 vccd vssd sg13cmos5l_decap_8
XFILLER_7_1750 vccd vssd sg13cmos5l_decap_8
XFILLER_3_2359 vccd vssd sg13cmos5l_decap_8
XFILLER_23_1597 vccd vssd sg13cmos5l_decap_8
XFILLER_1_2072 vccd vssd sg13cmos5l_decap_8
XFILLER_36_876 vccd vssd sg13cmos5l_decap_8
XFILLER_35_364 vccd vssd sg13cmos5l_decap_8
XFILLER_23_504 vccd vssd sg13cmos5l_decap_8
XFILLER_36_2637 vccd vssd sg13cmos5l_decap_8
XFILLER_1_1393 vccd vssd sg13cmos5l_decap_8
XFILLER_17_1302 vccd vssd sg13cmos5l_decap_8
XFILLER_31_592 vccd vssd sg13cmos5l_decap_8
XFILLER_30_2225 vccd vssd sg13cmos5l_decap_8
XFILLER_17_1379 vccd vssd sg13cmos5l_decap_8
XFILLER_30_1524 vccd vssd sg13cmos5l_decap_8
X_1808_ _1808_/Q _1809_/CLK _1808_/D _1643_/Y vccd vssd sg13cmos5l_dfrbpq_1
Xhold210 _1806_/D _0895_/Y vccd vssd sg13cmos5l_dlygate4sd3_1
XFILLER_15_1092 vccd vssd sg13cmos5l_decap_8
Xhold221 _0851_/A _1687_/Q vccd vssd sg13cmos5l_dlygate4sd3_1
Xhold232 _0874_/A _1691_/Q vccd vssd sg13cmos5l_dlygate4sd3_1
X_1739_ _1739_/Q _1757_/CLK _1739_/D fanout122/X vccd vssd sg13cmos5l_dfrbpq_1
Xhold243 hold243/X _0867_/Y vccd vssd sg13cmos5l_dlygate4sd3_1
Xhold287 hold287/X _0840_/Y vccd vssd sg13cmos5l_dlygate4sd3_1
Xhold265 hold265/X _0857_/Y vccd vssd sg13cmos5l_dlygate4sd3_1
Xhold276 _1746_/D _1529_/Y vccd vssd sg13cmos5l_dlygate4sd3_1
XFILLER_28_2165 vccd vssd sg13cmos5l_decap_8
Xhold254 hold254/X _1532_/Y vccd vssd sg13cmos5l_dlygate4sd3_1
XFILLER_8_2226 vccd vssd sg13cmos5l_decap_8
Xhold298 hold298/X _1705_/Q vccd vssd sg13cmos5l_dlygate4sd3_1
XFILLER_24_2007 vccd vssd sg13cmos5l_decap_8
XFILLER_41_2321 vccd vssd sg13cmos5l_decap_8
XFILLER_8_1547 vccd vssd sg13cmos5l_decap_8
XFILLER_41_1642 vccd vssd sg13cmos5l_decap_8
XFILLER_2_1113 vccd vssd sg13cmos5l_decap_8
XFILLER_6_1260 vccd vssd sg13cmos5l_decap_8
XFILLER_22_1085 vccd vssd sg13cmos5l_decap_8
XFILLER_27_876 vccd vssd sg13cmos5l_decap_8
XFILLER_26_364 vccd vssd sg13cmos5l_decap_8
XFILLER_14_504 vccd vssd sg13cmos5l_decap_8
XFILLER_42_835 vccd vssd sg13cmos5l_decap_8
XFILLER_41_312 vccd vssd sg13cmos5l_decap_8
XFILLER_39_2272 vccd vssd sg13cmos5l_decap_8
XFILLER_35_2147 vccd vssd sg13cmos5l_decap_8
XFILLER_35_1424 vccd vssd sg13cmos5l_decap_8
XFILLER_14_63 vccd vssd sg13cmos5l_decap_8
XFILLER_13_2412 vccd vssd sg13cmos5l_decap_8
Xclkbuf_5_13_0_SCK _1795_/CLK clkbuf_3_3_0_SCK/X vccd vssd sg13cmos5l_buf_8
XFILLER_22_581 vccd vssd sg13cmos5l_decap_8
XFILLER_10_721 vccd vssd sg13cmos5l_decap_8
XFILLER_6_714 vccd vssd sg13cmos5l_decap_8
XFILLER_13_1722 vccd vssd sg13cmos5l_decap_8
XFILLER_13_2489 vccd vssd sg13cmos5l_decap_8
XFILLER_5_224 vccd vssd sg13cmos5l_decap_8
XFILLER_10_798 vccd vssd sg13cmos5l_decap_8
XFILLER_29_1206 vccd vssd sg13cmos5l_decap_8
XFILLER_13_1799 vccd vssd sg13cmos5l_decap_8
XFILLER_30_84 vccd vssd sg13cmos5l_decap_8
Xclkbuf_5_28_0_SCK _1804_/CLK clkbuf_3_7_0_SCK/X vccd vssd sg13cmos5l_buf_8
XFILLER_2_931 vccd vssd sg13cmos5l_decap_8
Xtiedowns\[46\] status[46] vccd vssd sg13cmos5l_antennanp
XFILLER_1_441 vccd vssd sg13cmos5l_decap_8
XFILLER_24_2552 vccd vssd sg13cmos5l_decap_8
XFILLER_37_607 vccd vssd sg13cmos5l_decap_8
XFILLER_24_1840 vccd vssd sg13cmos5l_decap_8
XFILLER_4_2646 vccd vssd sg13cmos5l_decap_8
XFILLER_7_1057 vccd vssd sg13cmos5l_decap_8
XFILLER_40_1174 vccd vssd sg13cmos5l_decap_8
XFILLER_18_854 vccd vssd sg13cmos5l_decap_8
XFILLER_4_1967 vccd vssd sg13cmos5l_decap_8
XFILLER_45_651 vccd vssd sg13cmos5l_decap_8
XFILLER_20_1759 vccd vssd sg13cmos5l_decap_8
XFILLER_17_364 vccd vssd sg13cmos5l_decap_8
XFILLER_32_301 vccd vssd sg13cmos5l_decap_8
XFILLER_2_1680 vccd vssd sg13cmos5l_decap_8
XFILLER_33_857 vccd vssd sg13cmos5l_decap_8
XFILLER_18_2345 vccd vssd sg13cmos5l_decap_8
XFILLER_32_378 vccd vssd sg13cmos5l_decap_8
X_0972_ _0988_/C _1802_/Q _0947_/S _1042_/A vccd vssd sg13cmos5l_a21o_1
XFILLER_20_518 vccd vssd sg13cmos5l_decap_8
XFILLER_18_1666 vccd vssd sg13cmos5l_decap_8
XFILLER_31_1811 vccd vssd sg13cmos5l_decap_8
XFILLER_16_2091 vccd vssd sg13cmos5l_decap_8
XFILLER_13_581 vccd vssd sg13cmos5l_decap_8
XFILLER_14_1519 vccd vssd sg13cmos5l_decap_8
XFILLER_31_2556 vccd vssd sg13cmos5l_decap_8
XFILLER_9_574 vccd vssd sg13cmos5l_decap_8
XFILLER_12_1232 vccd vssd sg13cmos5l_decap_8
X_1524_ _1524_/X _1560_/A hold460/X _1528_/B vccd vssd sg13cmos5l_mux2_1
XFILLER_5_791 vccd vssd sg13cmos5l_decap_8
XFILLER_29_2496 vccd vssd sg13cmos5l_decap_8
XFILLER_29_1740 vccd vssd sg13cmos5l_decap_8
XFILLER_9_1834 vccd vssd sg13cmos5l_decap_8
X_1455_ _1692_/D _1600_/A1 _1461_/S hold238/X vccd vssd sg13cmos5l_o21ai_1
XFILLER_25_2349 vccd vssd sg13cmos5l_decap_8
XFILLER_45_1085 vccd vssd sg13cmos5l_decap_8
XFILLER_42_2685 vccd vssd sg13cmos5l_decap_8
X_1386_ _1387_/B mask_rev_in[8] _1063_/X _1066_/X vccd vssd sg13cmos5l_a21oi_1
XFILLER_3_2156 vccd vssd sg13cmos5l_decap_8
XFILLER_3_1400 vccd vssd sg13cmos5l_decap_8
XFILLER_3_1477 vccd vssd sg13cmos5l_decap_8
XFILLER_36_2412 vccd vssd sg13cmos5l_decap_8
XFILLER_36_695 vccd vssd sg13cmos5l_decap_8
XFILLER_35_161 vccd vssd sg13cmos5l_decap_8
XFILLER_23_301 vccd vssd sg13cmos5l_decap_8
XFILLER_36_2456 vccd vssd sg13cmos5l_decap_8
XFILLER_24_868 vccd vssd sg13cmos5l_decap_8
XFILLER_1_1190 vccd vssd sg13cmos5l_decap_8
XFILLER_23_378 vccd vssd sg13cmos5l_decap_8
XFILLER_11_518 vccd vssd sg13cmos5l_decap_8
XFILLER_34_2191 vccd vssd sg13cmos5l_decap_8
XFILLER_17_1176 vccd vssd sg13cmos5l_decap_8
XFILLER_13_1029 vccd vssd sg13cmos5l_decap_8
XFILLER_30_1332 vccd vssd sg13cmos5l_decap_8
XFILLER_3_728 vccd vssd sg13cmos5l_decap_8
XFILLER_10_1939 vccd vssd sg13cmos5l_decap_8
XFILLER_30_1398 vccd vssd sg13cmos5l_decap_8
XFILLER_2_238 vccd vssd sg13cmos5l_decap_8
XFILLER_4_7 vccd vssd sg13cmos5l_decap_8
XFILLER_8_2023 vccd vssd sg13cmos5l_decap_8
XFILLER_8_1344 vccd vssd sg13cmos5l_decap_8
XFILLER_41_2195 vccd vssd sg13cmos5l_decap_8
XFILLER_21_2769 vccd vssd sg13cmos5l_decap_8
XFILLER_26_161 vccd vssd sg13cmos5l_decap_8
XFILLER_19_2643 vccd vssd sg13cmos5l_decap_8
XFILLER_14_301 vccd vssd sg13cmos5l_decap_8
XFILLER_42_632 vccd vssd sg13cmos5l_decap_8
XFILLER_15_2507 vccd vssd sg13cmos5l_decap_8
XFILLER_15_868 vccd vssd sg13cmos5l_decap_8
XFILLER_42_698 vccd vssd sg13cmos5l_decap_8
XFILLER_41_175 vccd vssd sg13cmos5l_decap_8
XFILLER_35_1232 vccd vssd sg13cmos5l_decap_8
XFILLER_25_84 vccd vssd sg13cmos5l_decap_8
XFILLER_15_1806 vccd vssd sg13cmos5l_decap_8
XFILLER_14_378 vccd vssd sg13cmos5l_decap_8
XFILLER_19_1986 vccd vssd sg13cmos5l_decap_8
XFILLER_35_1298 vccd vssd sg13cmos5l_decap_8
XFILLER_6_511 vccd vssd sg13cmos5l_decap_8
XFILLER_10_595 vccd vssd sg13cmos5l_decap_8
XFILLER_13_2297 vccd vssd sg13cmos5l_decap_4
XFILLER_13_1596 vccd vssd sg13cmos5l_decap_8
XFILLER_29_1014 vccd vssd sg13cmos5l_decap_8
XFILLER_6_588 vccd vssd sg13cmos5l_decap_8
XFILLER_26_2614 vccd vssd sg13cmos5l_decap_8
XFILLER_37_7 vccd vssd sg13cmos5l_decap_8
XFILLER_42_1214 vccd vssd sg13cmos5l_decap_8
X_1240_ _1240_/Y _1237_/Y _1238_/X _1239_/Y vccd vssd sg13cmos5l_o21ai_1
XFILLER_26_1968 vccd vssd sg13cmos5l_decap_8
XFILLER_8_2590 vccd vssd sg13cmos5l_decap_8
XFILLER_2_77 vccd vssd sg13cmos5l_decap_8
XFILLER_4_2443 vccd vssd sg13cmos5l_decap_8
X_1171_ _1171_/Y mask_rev_in[21] _1347_/B1 _1169_/Y _1170_/Y _1350_/B vccd vssd sg13cmos5l_a221oi_1
XFILLER_37_448 vccd vssd sg13cmos5l_decap_4
XFILLER_20_2257 vccd vssd sg13cmos5l_decap_8
XFILLER_4_1764 vccd vssd sg13cmos5l_decap_8
XFILLER_20_1556 vccd vssd sg13cmos5l_decap_8
XFILLER_18_651 vccd vssd sg13cmos5l_decap_8
XFILLER_0_1617 vccd vssd sg13cmos5l_decap_8
XFILLER_17_161 vccd vssd sg13cmos5l_decap_8
XFILLER_37_2765 vccd vssd sg13cmos5l_decap_8
XFILLER_21_805 vccd vssd sg13cmos5l_decap_8
XFILLER_33_2629 vccd vssd sg13cmos5l_decap_8
XFILLER_33_676 vccd vssd sg13cmos5l_decap_8
XFILLER_20_315 vccd vssd sg13cmos5l_decap_8
XFILLER_18_2186 vccd vssd sg13cmos5l_decap_8
XFILLER_32_175 vccd vssd sg13cmos5l_decap_8
XFILLER_31_2320 vccd vssd sg13cmos5l_decap_8
XFILLER_18_1463 vccd vssd sg13cmos5l_decap_8
XFILLER_33_1939 vccd vssd sg13cmos5l_decap_8
X_0955_ _1046_/A _1074_/A _0985_/A vccd vssd sg13cmos5l_nand2b_1
XFILLER_14_1316 vccd vssd sg13cmos5l_decap_8
XFILLER_31_2375 vccd vssd sg13cmos5l_decap_8
X_0886_ _0887_/B _1664_/Q _0888_/C vccd vssd sg13cmos5l_nor2_1
XFILLER_9_371 vccd vssd sg13cmos5l_decap_8
XFILLER_9_2310 vccd vssd sg13cmos5l_decap_8
Xoutbuffers\[77\] control[77] _1745_/Q vccd vssd sg13cmos5l_buf_8
XFILLER_44_2758 vccd vssd sg13cmos5l_decap_8
X_1507_ _1507_/Y hold246/X _1509_/S _1506_/Y vccd vssd sg13cmos5l_a21oi_1
XFILLER_25_2124 vccd vssd sg13cmos5l_decap_8
XFILLER_9_1631 vccd vssd sg13cmos5l_decap_8
XFILLER_9_2387 vccd vssd sg13cmos5l_decap_8
X_1438_ _1438_/X _1472_/A hold316/X _1438_/S vccd vssd sg13cmos5l_mux2_1
XFILLER_25_2157 vccd vssd sg13cmos5l_decap_8
XFILLER_25_1445 vccd vssd sg13cmos5l_decap_8
XFILLER_21_1309 vccd vssd sg13cmos5l_decap_8
XFILLER_42_1781 vccd vssd sg13cmos5l_decap_8
XFILLER_42_1770 vccd vssd sg13cmos5l_decap_4
X_1369_ _1369_/Y _1369_/A _1369_/B _1369_/C _1369_/D vccd vssd sg13cmos5l_nand4_1
XFILLER_28_448 vccd vssd sg13cmos5l_decap_8
XFILLER_44_908 vccd vssd sg13cmos5l_decap_8
XFILLER_38_2518 vccd vssd sg13cmos5l_decap_8
XFILLER_36_481 vccd vssd sg13cmos5l_decap_4
XFILLER_3_1274 vccd vssd sg13cmos5l_decap_8
XFILLER_36_2242 vccd vssd sg13cmos5l_decap_8
XFILLER_24_665 vccd vssd sg13cmos5l_decap_8
XFILLER_12_805 vccd vssd sg13cmos5l_decap_8
XFILLER_36_2286 vccd vssd sg13cmos5l_decap_8
XFILLER_36_1541 vccd vssd sg13cmos5l_decap_8
XFILLER_23_175 vccd vssd sg13cmos5l_decap_8
XFILLER_11_315 vccd vssd sg13cmos5l_decap_8
XFILLER_14_2540 vccd vssd sg13cmos5l_decap_8
XFILLER_7_308 vccd vssd sg13cmos5l_decap_8
XFILLER_32_1449 vccd vssd sg13cmos5l_decap_8
XFILLER_20_882 vccd vssd sg13cmos5l_decap_8
XFILLER_10_2415 vccd vssd sg13cmos5l_decap_8
XFILLER_14_2595 vccd vssd sg13cmos5l_decap_8
XFILLER_10_1736 vccd vssd sg13cmos5l_decap_8
XFILLER_10_2459 vccd vssd sg13cmos5l_decap_8
XFILLER_11_42 vccd vssd sg13cmos5l_decap_8
XFILLER_14_1883 vccd vssd sg13cmos5l_decap_8
XFILLER_3_525 vccd vssd sg13cmos5l_decap_8
XFILLER_8_1141 vccd vssd sg13cmos5l_decap_8
XFILLER_21_2566 vccd vssd sg13cmos5l_decap_8
XFILLER_21_1810 vccd vssd sg13cmos5l_decap_8
XFILLER_19_448 vccd vssd sg13cmos5l_decap_8
XFILLER_1_1904 vccd vssd sg13cmos5l_decap_8
XFILLER_21_1876 vccd vssd sg13cmos5l_decap_8
XFILLER_43_985 vccd vssd sg13cmos5l_decap_8
XFILLER_42_451 vccd vssd sg13cmos5l_decap_8
XFILLER_37_1349 vccd vssd sg13cmos5l_decap_8
XFILLER_19_2462 vccd vssd sg13cmos5l_decap_8
XFILLER_15_665 vccd vssd sg13cmos5l_decap_8
XFILLER_35_1040 vccd vssd sg13cmos5l_decap_8
XFILLER_19_1750 vccd vssd sg13cmos5l_decap_8
XFILLER_15_1603 vccd vssd sg13cmos5l_decap_8
XFILLER_14_175 vccd vssd sg13cmos5l_decap_8
XFILLER_32_2651 vccd vssd sg13cmos5l_decap_8
XFILLER_30_679 vccd vssd sg13cmos5l_decap_8
XFILLER_32_1961 vccd vssd sg13cmos5l_decap_8
XFILLER_11_882 vccd vssd sg13cmos5l_decap_8
XFILLER_13_2072 vccd vssd sg13cmos5l_decap_8
XFILLER_7_875 vccd vssd sg13cmos5l_decap_8
XFILLER_10_392 vccd vssd sg13cmos5l_decap_8
XFILLER_6_385 vccd vssd sg13cmos5l_decap_8
XFILLER_13_1393 vccd vssd sg13cmos5l_decap_8
XFILLER_26_2422 vccd vssd sg13cmos5l_decap_8
XFILLER_22_2308 vccd vssd sg13cmos5l_decap_8
XFILLER_6_2527 vccd vssd sg13cmos5l_decap_8
XFILLER_42_1033 vccd vssd sg13cmos5l_decap_8
X_1223_ _1223_/Y _1223_/A _1223_/B _1223_/C vccd vssd sg13cmos5l_nand3_1
XFILLER_26_2499 vccd vssd sg13cmos5l_decap_8
XFILLER_4_2240 vccd vssd sg13cmos5l_decap_8
XFILLER_6_1848 vccd vssd sg13cmos5l_decap_8
XFILLER_38_746 vccd vssd sg13cmos5l_decap_8
XFILLER_37_245 vccd vssd sg13cmos5l_decap_8
X_1154_ _1154_/X _1761_/Q _1544_/B _1155_/B vccd vssd sg13cmos5l_a21o_1
XFILLER_4_1561 vccd vssd sg13cmos5l_decap_8
X_1085_ _1085_/Y status[6] _1148_/B vccd vssd sg13cmos5l_nand2b_1
XFILLER_0_1414 vccd vssd sg13cmos5l_decap_8
XFILLER_20_1386 vccd vssd sg13cmos5l_decap_8
XFILLER_37_2562 vccd vssd sg13cmos5l_decap_8
XFILLER_33_2404 vccd vssd sg13cmos5l_decap_8
XFILLER_21_602 vccd vssd sg13cmos5l_decap_8
XFILLER_33_2448 vccd vssd sg13cmos5l_decap_8
XFILLER_20_112 vccd vssd sg13cmos5l_decap_8
XFILLER_37_1883 vccd vssd sg13cmos5l_decap_8
XFILLER_21_679 vccd vssd sg13cmos5l_decap_8
XFILLER_18_1260 vccd vssd sg13cmos5l_decap_8
XFILLER_14_1113 vccd vssd sg13cmos5l_decap_8
X_0938_ _0939_/B _0938_/A _0938_/B _0938_/C vccd vssd sg13cmos5l_nand3_1
XFILLER_20_189 vccd vssd sg13cmos5l_decap_8
X_0869_ _0869_/Y _0869_/A vccd vssd sg13cmos5l_inv_1
XFILLER_27_1518 vccd vssd sg13cmos5l_decap_8
XFILLER_44_2555 vccd vssd sg13cmos5l_decap_8
XFILLER_44_1821 vccd vssd sg13cmos5l_decap_8
XFILLER_40_2408 vccd vssd sg13cmos5l_decap_8
XFILLER_0_539 vccd vssd sg13cmos5l_decap_8
XFILLER_9_2184 vccd vssd sg13cmos5l_decap_8
XFILLER_5_2037 vccd vssd sg13cmos5l_decap_8
XFILLER_44_1898 vccd vssd sg13cmos5l_decap_8
XFILLER_40_1718 vccd vssd sg13cmos5l_decap_8
XFILLER_21_1106 vccd vssd sg13cmos5l_decap_8
XFILLER_5_1358 vccd vssd sg13cmos5l_decap_8
XFILLER_44_705 vccd vssd sg13cmos5l_decap_8
XFILLER_28_245 vccd vssd sg13cmos5l_decap_8
XFILLER_43_204 vccd vssd sg13cmos5l_decap_8
XFILLER_3_1071 vccd vssd sg13cmos5l_decap_8
XFILLER_0_2660 vccd vssd sg13cmos5l_decap_8
XFILLER_25_941 vccd vssd sg13cmos5l_decap_8
XFILLER_38_1636 vccd vssd sg13cmos5l_decap_8
XFILLER_24_462 vccd vssd sg13cmos5l_decap_8
XFILLER_0_1981 vccd vssd sg13cmos5l_decap_8
XFILLER_12_602 vccd vssd sg13cmos5l_decap_8
XFILLER_40_933 vccd vssd sg13cmos5l_decap_8
XFILLER_19_1057 vccd vssd sg13cmos5l_decap_8
XFILLER_11_112 vccd vssd sg13cmos5l_decap_8
XFILLER_32_1213 vccd vssd sg13cmos5l_decap_8
XFILLER_16_1923 vccd vssd sg13cmos5l_decap_8
XFILLER_7_105 vccd vssd sg13cmos5l_decap_8
XFILLER_12_679 vccd vssd sg13cmos5l_decap_8
XFILLER_10_2212 vccd vssd sg13cmos5l_decap_8
XFILLER_11_189 vccd vssd sg13cmos5l_decap_8
XFILLER_22_63 vccd vssd sg13cmos5l_decap_8
XFILLER_4_812 vccd vssd sg13cmos5l_decap_8
XFILLER_10_1533 vccd vssd sg13cmos5l_decap_8
XFILLER_10_2289 vccd vssd sg13cmos5l_decap_8
XFILLER_14_1680 vccd vssd sg13cmos5l_decap_8
XFILLER_3_322 vccd vssd sg13cmos5l_decap_8
XFILLER_27_2742 vccd vssd sg13cmos5l_decap_8
XFILLER_4_889 vccd vssd sg13cmos5l_decap_8
XFILLER_26_1006 vccd vssd sg13cmos5l_decap_8
XFILLER_23_2606 vccd vssd sg13cmos5l_decap_8
XFILLER_3_399 vccd vssd sg13cmos5l_decap_8
XFILLER_43_2098 vccd vssd sg13cmos5l_decap_8
XFILLER_21_2363 vccd vssd sg13cmos5l_decap_8
XFILLER_19_245 vccd vssd sg13cmos5l_decap_8
XFILLER_1_1701 vccd vssd sg13cmos5l_decap_8
XFILLER_35_716 vccd vssd sg13cmos5l_decap_8
XFILLER_21_1662 vccd vssd sg13cmos5l_decap_8
XFILLER_1_2457 vccd vssd sg13cmos5l_decap_8
XFILLER_16_952 vccd vssd sg13cmos5l_decap_8
XFILLER_1_1778 vccd vssd sg13cmos5l_decap_8
XFILLER_34_259 vccd vssd sg13cmos5l_decap_8
XFILLER_15_462 vccd vssd sg13cmos5l_decap_8
XFILLER_37_1135 vccd vssd sg13cmos5l_decap_8
XFILLER_34_2735 vccd vssd sg13cmos5l_decap_8
XFILLER_31_922 vccd vssd sg13cmos5l_decap_8
XFILLER_42_292 vccd vssd sg13cmos5l_decap_8
XFILLER_15_1400 vccd vssd sg13cmos5l_decap_8
XFILLER_8_21 vccd vssd sg13cmos5l_decap_8
XFILLER_30_487 vccd vssd sg13cmos5l_decap_8
XFILLER_15_2189 vccd vssd sg13cmos5l_decap_8
XFILLER_11_2009 vccd vssd sg13cmos5l_decap_8
X_1772_ _1772_/Q _1779_/CLK _1772_/D fanout115/X vccd vssd sg13cmos5l_dfrbpq_1
XFILLER_15_1477 vccd vssd sg13cmos5l_decap_8
XFILLER_8_98 vccd vssd sg13cmos5l_decap_8
XFILLER_28_2506 vccd vssd sg13cmos5l_decap_8
XFILLER_7_672 vccd vssd sg13cmos5l_decap_8
XFILLER_6_182 vccd vssd sg13cmos5l_decap_8
XFILLER_13_1190 vccd vssd sg13cmos5l_decap_8
XFILLER_28_1805 vccd vssd sg13cmos5l_decap_8
XFILLER_26_2241 vccd vssd sg13cmos5l_decap_4
XFILLER_6_2324 vccd vssd sg13cmos5l_decap_8
XFILLER_26_0 vccd vssd sg13cmos5l_decap_8
XFILLER_22_2127 vccd vssd sg13cmos5l_decap_8
XFILLER_22_1415 vccd vssd sg13cmos5l_decap_8
XFILLER_6_1645 vccd vssd sg13cmos5l_decap_8
X_1206_ _1206_/Y _1206_/A _1206_/B _1206_/C vccd vssd sg13cmos5l_nand3_1
X_1137_ _1138_/B status[77] _1137_/B _1197_/C vccd vssd sg13cmos5l_nor3_1
XFILLER_26_727 vccd vssd sg13cmos5l_decap_8
XFILLER_0_1211 vccd vssd sg13cmos5l_decap_8
XFILLER_39_2668 vccd vssd sg13cmos5l_decap_8
XFILLER_20_1183 vccd vssd sg13cmos5l_decap_8
XFILLER_41_719 vccd vssd sg13cmos5l_decap_8
XFILLER_25_259 vccd vssd sg13cmos5l_decap_8
XFILLER_0_1288 vccd vssd sg13cmos5l_decap_8
X_1068_ _1068_/Y mask_rev_in[15] _1064_/Y _1348_/B vccd vssd sg13cmos5l_o21ai_1
XFILLER_39_1978 vccd vssd sg13cmos5l_decap_8
XFILLER_34_793 vccd vssd sg13cmos5l_decap_8
XFILLER_33_1511 vccd vssd sg13cmos5l_decap_8
XFILLER_22_966 vccd vssd sg13cmos5l_decap_8
XFILLER_33_2267 vccd vssd sg13cmos5l_decap_8
XFILLER_21_476 vccd vssd sg13cmos5l_decap_8
XFILLER_15_2690 vccd vssd sg13cmos5l_decap_8
XFILLER_5_609 vccd vssd sg13cmos5l_decap_8
XFILLER_4_119 vccd vssd sg13cmos5l_decap_8
XFILLER_11_1820 vccd vssd sg13cmos5l_decap_8
XFILLER_27_2016 vccd vssd sg13cmos5l_decap_8
XFILLER_1_826 vccd vssd sg13cmos5l_decap_8
XFILLER_11_1897 vccd vssd sg13cmos5l_decap_8
XFILLER_44_2352 vccd vssd sg13cmos5l_decap_8
XFILLER_27_1315 vccd vssd sg13cmos5l_decap_8
XFILLER_0_336 vccd vssd sg13cmos5l_decap_8
XFILLER_44_1651 vccd vssd sg13cmos5l_decap_8
XFILLER_40_1515 vccd vssd sg13cmos5l_decap_8
XFILLER_25_1050 vccd vssd sg13cmos5l_decap_8
XFILLER_22_2683 vccd vssd sg13cmos5l_decap_8
XFILLER_2_2744 vccd vssd sg13cmos5l_decap_8
XFILLER_5_1155 vccd vssd sg13cmos5l_decap_8
XFILLER_29_565 vccd vssd sg13cmos5l_decap_8
XFILLER_1_1008 vccd vssd sg13cmos5l_decap_8
XFILLER_44_557 vccd vssd sg13cmos5l_decap_8
XFILLER_18_2708 vccd vssd sg13cmos5l_decap_8
XFILLER_17_749 vccd vssd sg13cmos5l_decap_8
XFILLER_17_63 vccd vssd sg13cmos5l_decap_8
XFILLER_16_259 vccd vssd sg13cmos5l_decap_8
XFILLER_38_1455 vccd vssd sg13cmos5l_decap_8
XFILLER_38_1477 vccd vssd sg13cmos5l_decap_8
XFILLER_16_2465 vccd vssd sg13cmos5l_decap_8
XFILLER_12_2307 vccd vssd sg13cmos5l_decap_8
XFILLER_13_966 vccd vssd sg13cmos5l_decap_8
XFILLER_33_84 vccd vssd sg13cmos5l_decap_8
XFILLER_16_1764 vccd vssd sg13cmos5l_decap_8
XFILLER_9_959 vccd vssd sg13cmos5l_decap_8
XFILLER_12_476 vccd vssd sg13cmos5l_decap_8
XFILLER_8_469 vccd vssd sg13cmos5l_decap_8
XFILLER_12_1617 vccd vssd sg13cmos5l_decap_8
Xtiedowns\[76\] status[76] vccd vssd sg13cmos5l_antennanp
XFILLER_10_1330 vccd vssd sg13cmos5l_decap_8
XFILLER_10_2086 vccd vssd sg13cmos5l_decap_8
XFILLER_4_686 vccd vssd sg13cmos5l_decap_8
XFILLER_45_2149 vccd vssd sg13cmos5l_decap_8
XFILLER_3_196 vccd vssd sg13cmos5l_decap_8
XFILLER_27_2572 vccd vssd sg13cmos5l_decap_8
XFILLER_23_2403 vccd vssd sg13cmos5l_decap_8
XFILLER_39_329 vccd vssd sg13cmos5l_decap_8
XFILLER_23_1713 vccd vssd sg13cmos5l_decap_8
XFILLER_7_1932 vccd vssd sg13cmos5l_decap_8
XFILLER_40_2750 vccd vssd sg13cmos5l_decap_8
XFILLER_1_2254 vccd vssd sg13cmos5l_decap_8
XFILLER_39_1208 vccd vssd sg13cmos5l_decap_8
XFILLER_35_535 vccd vssd sg13cmos5l_decap_8
XFILLER_1_1575 vccd vssd sg13cmos5l_decap_8
XFILLER_34_2532 vccd vssd sg13cmos5l_decap_8
XFILLER_34_1820 vccd vssd sg13cmos5l_decap_8
XFILLER_31_774 vccd vssd sg13cmos5l_decap_8
XFILLER_30_2418 vccd vssd sg13cmos5l_decap_8
XFILLER_30_273 vccd vssd sg13cmos5l_decap_8
XFILLER_34_1864 vccd vssd sg13cmos5l_decap_8
XFILLER_30_1717 vccd vssd sg13cmos5l_decap_4
XFILLER_15_1274 vccd vssd sg13cmos5l_decap_8
X_1755_ _1755_/Q _1763_/CLK _1755_/D fanout121/X vccd vssd sg13cmos5l_dfrbpq_1
XFILLER_11_1127 vccd vssd sg13cmos5l_decap_8
Xhold403 hold403/X _1753_/Q vccd vssd sg13cmos5l_dlygate4sd3_1
Xhold414 _1733_/D _1513_/X vccd vssd sg13cmos5l_dlygate4sd3_1
Xhold425 hold425/X _1720_/Q vccd vssd sg13cmos5l_dlygate4sd3_1
Xhold436 _1736_/D _1516_/X vccd vssd sg13cmos5l_dlygate4sd3_1
Xhold458 hold458/X _1787_/Q vccd vssd sg13cmos5l_dlygate4sd3_1
X_1686_ _1686_/Q _1697_/CLK _1686_/D fanout134/X vccd vssd sg13cmos5l_dfrbpq_1
XFILLER_28_2336 vccd vssd sg13cmos5l_decap_8
XFILLER_28_1602 vccd vssd sg13cmos5l_decap_8
Xhold447 _0940_/A _1797_/Q vccd vssd sg13cmos5l_dlygate4sd3_1
Xhold469 _0901_/B _1403_/C vccd vssd sg13cmos5l_dlygate4sd3_1
XFILLER_8_2408 vccd vssd sg13cmos5l_decap_8
XFILLER_28_1679 vccd vssd sg13cmos5l_decap_8
XFILLER_6_2121 vccd vssd sg13cmos5l_decap_8
XFILLER_8_1729 vccd vssd sg13cmos5l_decap_8
XFILLER_45_1960 vccd vssd sg13cmos5l_decap_8
XFILLER_41_2558 vccd vssd sg13cmos5l_decap_8
XFILLER_41_1824 vccd vssd sg13cmos5l_decap_8
XFILLER_26_1370 vccd vssd sg13cmos5l_decap_8
XFILLER_6_1442 vccd vssd sg13cmos5l_decap_8
XFILLER_6_2198 vccd vssd sg13cmos5l_decap_8
XFILLER_26_546 vccd vssd sg13cmos5l_decap_8
XFILLER_41_505 vccd vssd sg13cmos5l_decap_8
XFILLER_39_2465 vccd vssd sg13cmos5l_decap_8
XFILLER_39_1742 vccd vssd sg13cmos5l_decap_8
XFILLER_17_2741 vccd vssd sg13cmos5l_decap_8
XFILLER_0_1085 vccd vssd sg13cmos5l_decap_8
XFILLER_22_763 vccd vssd sg13cmos5l_decap_8
XFILLER_10_903 vccd vssd sg13cmos5l_decap_8
XFILLER_13_2605 vccd vssd sg13cmos5l_decap_8
XFILLER_21_273 vccd vssd sg13cmos5l_decap_8
XFILLER_13_1904 vccd vssd sg13cmos5l_decap_8
XFILLER_33_2086 vccd vssd sg13cmos5l_decap_8
XFILLER_33_1363 vccd vssd sg13cmos5l_decap_8
XFILLER_5_406 vccd vssd sg13cmos5l_decap_8
XFILLER_11_2340 vccd vssd sg13cmos5l_decap_8
XFILLER_11_1694 vccd vssd sg13cmos5l_decap_8
XFILLER_1_623 vccd vssd sg13cmos5l_decap_8
XFILLER_27_1145 vccd vssd sg13cmos5l_decap_8
XFILLER_24_2734 vccd vssd sg13cmos5l_decap_8
XFILLER_0_133 vccd vssd sg13cmos5l_decap_8
XFILLER_7_1239 vccd vssd sg13cmos5l_decap_8
XFILLER_40_2046 vccd vssd sg13cmos5l_decap_8
XFILLER_40_1367 vccd vssd sg13cmos5l_decap_8
XFILLER_28_84 vccd vssd sg13cmos5l_decap_8
XFILLER_22_2480 vccd vssd sg13cmos5l_decap_8
XFILLER_2_2541 vccd vssd sg13cmos5l_decap_8
XFILLER_45_833 vccd vssd sg13cmos5l_decap_8
XFILLER_17_546 vccd vssd sg13cmos5l_decap_8
XFILLER_2_1862 vccd vssd sg13cmos5l_decap_8
XFILLER_18_1826 vccd vssd sg13cmos5l_decap_4
XFILLER_38_1285 vccd vssd sg13cmos5l_decap_8
XFILLER_34_1138 vccd vssd sg13cmos5l_decap_8
XFILLER_31_2738 vccd vssd sg13cmos5l_decap_8
XFILLER_16_2273 vccd vssd sg13cmos5l_decap_8
XFILLER_13_763 vccd vssd sg13cmos5l_decap_8
XFILLER_16_1561 vccd vssd sg13cmos5l_decap_8
XFILLER_9_756 vccd vssd sg13cmos5l_decap_8
XFILLER_12_273 vccd vssd sg13cmos5l_decap_8
XFILLER_8_266 vccd vssd sg13cmos5l_decap_8
XFILLER_12_1414 vccd vssd sg13cmos5l_decap_8
X_1540_ _1540_/X _1595_/A0 hold403/X _1542_/B vccd vssd sg13cmos5l_mux2_1
XFILLER_29_2601 vccd vssd sg13cmos5l_decap_8
XFILLER_5_973 vccd vssd sg13cmos5l_decap_8
XFILLER_29_2678 vccd vssd sg13cmos5l_decap_8
X_1471_ _1471_/X _1495_/A hold350/X _1471_/S vccd vssd sg13cmos5l_mux2_1
XFILLER_4_483 vccd vssd sg13cmos5l_decap_8
XFILLER_5_77 vccd vssd sg13cmos5l_decap_8
XFILLER_23_2211 vccd vssd sg13cmos5l_decap_8
XFILLER_45_1267 vccd vssd sg13cmos5l_decap_8
XFILLER_29_1988 vccd vssd sg13cmos5l_decap_8
XFILLER_39_126 vccd vssd sg13cmos5l_decap_8
XFILLER_3_2338 vccd vssd sg13cmos5l_decap_8
XFILLER_7_2485 vccd vssd sg13cmos5l_decap_8
XFILLER_23_2288 vccd vssd sg13cmos5l_decap_8
XFILLER_23_1576 vccd vssd sg13cmos5l_decap_8
XFILLER_36_855 vccd vssd sg13cmos5l_decap_8
XFILLER_3_1659 vccd vssd sg13cmos5l_decap_8
XFILLER_1_2051 vccd vssd sg13cmos5l_decap_8
XFILLER_40_1890 vccd vssd sg13cmos5l_decap_8
XFILLER_36_2616 vccd vssd sg13cmos5l_decap_8
XFILLER_35_343 vccd vssd sg13cmos5l_decap_8
XFILLER_39_1049 vccd vssd sg13cmos5l_decap_8
XFILLER_36_1904 vccd vssd sg13cmos5l_decap_8
XFILLER_1_1372 vccd vssd sg13cmos5l_decap_8
Xoutbuffers\[3\] control[3] _1671_/Q vccd vssd sg13cmos5l_buf_8
XFILLER_31_571 vccd vssd sg13cmos5l_decap_8
XFILLER_17_1358 vccd vssd sg13cmos5l_decap_8
XFILLER_30_1503 vccd vssd sg13cmos5l_decap_8
XFILLER_34_1683 vccd vssd sg13cmos5l_decap_8
XFILLER_15_1071 vccd vssd sg13cmos5l_decap_8
X_1807_ _1807_/Q _1807_/CLK _1807_/D _1642_/Y vccd vssd sg13cmos5l_dfrbpq_1
Xhold211 _0887_/A _1808_/Q vccd vssd sg13cmos5l_dlygate4sd3_1
Xhold200 _1802_/D _0923_/Y vccd vssd sg13cmos5l_dlygate4sd3_1
Xhold222 hold222/X _0851_/Y vccd vssd sg13cmos5l_dlygate4sd3_1
Xhold233 hold233/X _0874_/Y vccd vssd sg13cmos5l_dlygate4sd3_1
Xhold244 _1690_/D _1450_/Y vccd vssd sg13cmos5l_dlygate4sd3_1
X_1738_ _1738_/Q clkload1/A _1738_/D fanout122/X vccd vssd sg13cmos5l_dfrbpq_1
XFILLER_12_1981 vccd vssd sg13cmos5l_decap_8
Xhold277 _0870_/A _1762_/Q vccd vssd sg13cmos5l_dlygate4sd3_1
Xhold266 _0858_/A _1728_/Q vccd vssd sg13cmos5l_dlygate4sd3_1
X_1669_ _1669_/Q _1675_/CLK _1669_/D _1644_/B_N vccd vssd sg13cmos5l_dfrbpq_1
Xhold255 _1475_/A _1708_/Q vccd vssd sg13cmos5l_dlygate4sd3_1
XFILLER_8_2205 vccd vssd sg13cmos5l_decap_8
XFILLER_41_2300 vccd vssd sg13cmos5l_decap_8
Xhold288 _1757_/D _1548_/Y vccd vssd sg13cmos5l_dlygate4sd3_1
Xhold299 _1705_/D _1470_/X vccd vssd sg13cmos5l_dlygate4sd3_1
XFILLER_8_1526 vccd vssd sg13cmos5l_decap_8
XFILLER_28_1487 vccd vssd sg13cmos5l_decap_8
XFILLER_41_2366 vccd vssd sg13cmos5l_decap_8
XFILLER_41_1698 vccd vssd sg13cmos5l_decap_8
XFILLER_27_855 vccd vssd sg13cmos5l_decap_8
XFILLER_22_1064 vccd vssd sg13cmos5l_decap_8
XFILLER_42_814 vccd vssd sg13cmos5l_decap_8
XFILLER_26_343 vccd vssd sg13cmos5l_decap_8
XFILLER_2_1169 vccd vssd sg13cmos5l_decap_8
XFILLER_35_2126 vccd vssd sg13cmos5l_decap_8
XFILLER_35_1403 vccd vssd sg13cmos5l_decap_8
XFILLER_41_379 vccd vssd sg13cmos5l_decap_8
XFILLER_22_560 vccd vssd sg13cmos5l_decap_8
XFILLER_10_700 vccd vssd sg13cmos5l_decap_8
XFILLER_14_42 vccd vssd sg13cmos5l_decap_8
XFILLER_17_1881 vccd vssd sg13cmos5l_decap_8
XFILLER_13_1701 vccd vssd sg13cmos5l_decap_8
XFILLER_5_203 vccd vssd sg13cmos5l_decap_8
XFILLER_10_777 vccd vssd sg13cmos5l_decap_8
XFILLER_30_2771 vccd vssd sg13cmos5l_decap_8
XFILLER_13_1778 vccd vssd sg13cmos5l_decap_8
XFILLER_30_63 vccd vssd sg13cmos5l_decap_8
XFILLER_2_910 vccd vssd sg13cmos5l_decap_8
XFILLER_11_1491 vccd vssd sg13cmos5l_decap_8
XFILLER_1_420 vccd vssd sg13cmos5l_decap_8
Xtiedowns\[39\] status[39] vccd vssd sg13cmos5l_antennanp
XFILLER_24_2531 vccd vssd sg13cmos5l_decap_8
XFILLER_2_987 vccd vssd sg13cmos5l_decap_8
XFILLER_8_2772 vccd vssd sg13cmos5l_decap_8
XFILLER_1_497 vccd vssd sg13cmos5l_decap_8
XFILLER_4_2625 vccd vssd sg13cmos5l_decap_8
XFILLER_7_1036 vccd vssd sg13cmos5l_decap_8
XFILLER_4_1946 vccd vssd sg13cmos5l_decap_8
XFILLER_45_630 vccd vssd sg13cmos5l_decap_8
XFILLER_40_1153 vccd vssd sg13cmos5l_decap_8
XFILLER_24_1885 vccd vssd sg13cmos5l_decap_8
XFILLER_20_1738 vccd vssd sg13cmos5l_decap_8
XFILLER_18_833 vccd vssd sg13cmos5l_decap_8
XFILLER_44_140 vccd vssd sg13cmos5l_decap_8
XFILLER_17_343 vccd vssd sg13cmos5l_decap_8
XFILLER_33_836 vccd vssd sg13cmos5l_decap_8
XFILLER_18_2324 vccd vssd sg13cmos5l_decap_8
XFILLER_32_357 vccd vssd sg13cmos5l_decap_8
XFILLER_41_880 vccd vssd sg13cmos5l_decap_8
XFILLER_38_1093 vccd vssd sg13cmos5l_decap_8
X_0971_ _0988_/B _0971_/A _1803_/Q _0971_/C vccd vssd sg13cmos5l_or3_2
XFILLER_18_1645 vccd vssd sg13cmos5l_decap_8
XFILLER_13_560 vccd vssd sg13cmos5l_decap_8
XFILLER_35_2693 vccd vssd sg13cmos5l_decap_8
XFILLER_31_2535 vccd vssd sg13cmos5l_decap_8
XFILLER_16_2070 vccd vssd sg13cmos5l_decap_8
XFILLER_9_553 vccd vssd sg13cmos5l_decap_8
XFILLER_12_1211 vccd vssd sg13cmos5l_decap_8
XFILLER_12_1288 vccd vssd sg13cmos5l_decap_8
X_1523_ _1523_/X _1591_/A0 hold462/X _1528_/B vccd vssd sg13cmos5l_mux2_1
XFILLER_5_770 vccd vssd sg13cmos5l_decap_8
X_1454_ _1454_/Y _1454_/A _1461_/S vccd vssd sg13cmos5l_nand2_1
XFILLER_29_2475 vccd vssd sg13cmos5l_decap_8
XFILLER_25_2328 vccd vssd sg13cmos5l_decap_8
XFILLER_4_280 vccd vssd sg13cmos5l_decap_8
XFILLER_9_1813 vccd vssd sg13cmos5l_decap_8
XFILLER_9_2547 vccd vssd sg13cmos5l_decap_8
XFILLER_45_1064 vccd vssd sg13cmos5l_decap_8
XFILLER_42_2664 vccd vssd sg13cmos5l_decap_8
XFILLER_7_2282 vccd vssd sg13cmos5l_decap_8
X_1385_ _1385_/Y _0838_/Y _1058_/Y _1383_/Y _1384_/Y _1063_/X vccd vssd sg13cmos5l_a221oi_1
XFILLER_42_1941 vccd vssd sg13cmos5l_decap_4
XFILLER_23_2085 vccd vssd sg13cmos5l_decap_8
XFILLER_3_2135 vccd vssd sg13cmos5l_decap_8
XFILLER_3_1456 vccd vssd sg13cmos5l_decap_8
Xoutbuffers\[22\] control[22] _1690_/Q vccd vssd sg13cmos5l_buf_8
XFILLER_36_663 vccd vssd sg13cmos5l_decap_8
XFILLER_35_140 vccd vssd sg13cmos5l_decap_8
XFILLER_24_847 vccd vssd sg13cmos5l_decap_8
XFILLER_23_357 vccd vssd sg13cmos5l_decap_8
XFILLER_36_1734 vccd vssd sg13cmos5l_decap_8
XFILLER_34_2170 vccd vssd sg13cmos5l_decap_8
XFILLER_30_2001 vccd vssd sg13cmos5l_decap_8
XFILLER_17_1155 vccd vssd sg13cmos5l_decap_8
XFILLER_30_1311 vccd vssd sg13cmos5l_decap_8
XFILLER_13_1008 vccd vssd sg13cmos5l_decap_8
XFILLER_10_1918 vccd vssd sg13cmos5l_decap_8
XFILLER_30_1377 vccd vssd sg13cmos5l_decap_4
XFILLER_3_707 vccd vssd sg13cmos5l_decap_8
XFILLER_2_217 vccd vssd sg13cmos5l_decap_8
XFILLER_8_2002 vccd vssd sg13cmos5l_decap_8
XFILLER_8_1323 vccd vssd sg13cmos5l_decap_8
XFILLER_8_2079 vccd vssd sg13cmos5l_decap_8
XFILLER_28_1295 vccd vssd sg13cmos5l_decap_8
XFILLER_41_2174 vccd vssd sg13cmos5l_decap_8
XFILLER_41_1440 vccd vssd sg13cmos5l_decap_8
XFILLER_21_2748 vccd vssd sg13cmos5l_decap_8
XFILLER_26_140 vccd vssd sg13cmos5l_decap_8
XFILLER_42_611 vccd vssd sg13cmos5l_decap_8
XFILLER_19_2622 vccd vssd sg13cmos5l_decap_8
XFILLER_25_63 vccd vssd sg13cmos5l_decap_8
XFILLER_15_847 vccd vssd sg13cmos5l_decap_8
XFILLER_41_154 vccd vssd sg13cmos5l_decap_8
XFILLER_35_1211 vccd vssd sg13cmos5l_decap_8
XFILLER_19_2699 vccd vssd sg13cmos5l_decap_8
XFILLER_19_1965 vccd vssd sg13cmos5l_decap_8
XFILLER_14_357 vccd vssd sg13cmos5l_decap_8
XFILLER_35_1255 vccd vssd sg13cmos5l_decap_4
XFILLER_41_84 vccd vssd sg13cmos5l_decap_8
XFILLER_10_574 vccd vssd sg13cmos5l_decap_8
XFILLER_13_2276 vccd vssd sg13cmos5l_decap_8
Xrebuffer160 _1358_/A2 _1135_/B vccd vssd sg13cmos5l_buf_16
XFILLER_6_567 vccd vssd sg13cmos5l_decap_8
XFILLER_13_1575 vccd vssd sg13cmos5l_decap_8
XFILLER_29_1037 vccd vssd sg13cmos5l_decap_8
XFILLER_26_1925 vccd vssd sg13cmos5l_decap_4
XFILLER_2_784 vccd vssd sg13cmos5l_decap_8
XFILLER_26_1947 vccd vssd sg13cmos5l_decap_8
XFILLER_1_294 vccd vssd sg13cmos5l_decap_8
XFILLER_4_2422 vccd vssd sg13cmos5l_decap_8
XFILLER_38_939 vccd vssd sg13cmos5l_decap_8
XFILLER_20_2225 vccd vssd sg13cmos5l_decap_4
XFILLER_2_56 vccd vssd sg13cmos5l_decap_8
X_1170_ _1170_/Y _0862_/Y _1306_/B _1347_/B1 vccd vssd sg13cmos5l_a21oi_1
XFILLER_8_1890 vccd vssd sg13cmos5l_decap_8
XFILLER_37_427 vccd vssd sg13cmos5l_decap_8
XFILLER_4_1743 vccd vssd sg13cmos5l_decap_8
XFILLER_4_2499 vccd vssd sg13cmos5l_decap_8
XFILLER_20_1535 vccd vssd sg13cmos5l_decap_8
XFILLER_18_630 vccd vssd sg13cmos5l_decap_8
XFILLER_17_140 vccd vssd sg13cmos5l_decap_8
XFILLER_37_2744 vccd vssd sg13cmos5l_decap_8
Xoutbuffers\[112\] control[112] _1780_/Q vccd vssd sg13cmos5l_buf_8
XFILLER_33_2608 vccd vssd sg13cmos5l_decap_8
XFILLER_32_154 vccd vssd sg13cmos5l_decap_8
XFILLER_18_2165 vccd vssd sg13cmos5l_decap_8
XFILLER_33_699 vccd vssd sg13cmos5l_decap_8
XFILLER_18_1442 vccd vssd sg13cmos5l_decap_8
XFILLER_31_2354 vccd vssd sg13cmos5l_decap_8
X_0954_ _1074_/A _1798_/Q _1797_/Q _0957_/S vccd vssd sg13cmos5l_mux2_1
XFILLER_9_350 vccd vssd sg13cmos5l_decap_8
X_0885_ _0885_/X _0898_/A _0898_/B _1805_/Q vccd vssd sg13cmos5l_or3_1
XFILLER_12_1085 vccd vssd sg13cmos5l_decap_8
XFILLER_29_2261 vccd vssd sg13cmos5l_decap_4
XFILLER_44_2737 vccd vssd sg13cmos5l_decap_8
X_1506_ _1506_/Y _1506_/A _1509_/S vccd vssd sg13cmos5l_nor2_1
XFILLER_9_1610 vccd vssd sg13cmos5l_decap_8
XFILLER_9_2366 vccd vssd sg13cmos5l_decap_8
X_1437_ _1437_/X _1495_/A hold365/X _1437_/S vccd vssd sg13cmos5l_mux2_1
XFILLER_29_1582 vccd vssd sg13cmos5l_decap_8
XFILLER_5_2219 vccd vssd sg13cmos5l_decap_8
X_1368_ _1369_/D _1788_/Q _1588_/B _1279_/B _1780_/Q vccd vssd sg13cmos5l_a22oi_1
XFILLER_29_939 vccd vssd sg13cmos5l_decap_8
XFILLER_9_1687 vccd vssd sg13cmos5l_decap_8
Xclkbuf_5_12_0_SCK _1790_/CLK clkbuf_3_3_0_SCK/X vccd vssd sg13cmos5l_buf_8
XFILLER_28_427 vccd vssd sg13cmos5l_decap_8
XFILLER_37_950 vccd vssd sg13cmos5l_decap_8
XFILLER_3_1253 vccd vssd sg13cmos5l_decap_8
X_1299_ _1299_/Y mask_rev_in[2] _1210_/B _1298_/Y vccd vssd sg13cmos5l_a21oi_1
XFILLER_36_2221 vccd vssd sg13cmos5l_decap_8
Xclkbuf_5_27_0_SCK _1699_/CLK clkbuf_3_6_0_SCK/X vccd vssd sg13cmos5l_buf_8
XFILLER_24_644 vccd vssd sg13cmos5l_decap_8
XFILLER_36_1520 vccd vssd sg13cmos5l_decap_8
XFILLER_23_154 vccd vssd sg13cmos5l_decap_8
XFILLER_19_1239 vccd vssd sg13cmos5l_decap_8
XFILLER_20_861 vccd vssd sg13cmos5l_decap_8
XFILLER_10_2438 vccd vssd sg13cmos5l_decap_8
XFILLER_14_1862 vccd vssd sg13cmos5l_decap_8
XFILLER_14_2574 vccd vssd sg13cmos5l_decap_8
XFILLER_30_1152 vccd vssd sg13cmos5l_decap_8
XFILLER_10_1715 vccd vssd sg13cmos5l_decap_8
XFILLER_11_21 vccd vssd sg13cmos5l_decap_8
XFILLER_3_504 vccd vssd sg13cmos5l_decap_8
XFILLER_11_98 vccd vssd sg13cmos5l_decap_8
XFILLER_5_2731 vccd vssd sg13cmos5l_decap_8
XFILLER_8_1120 vccd vssd sg13cmos5l_decap_8
XFILLER_21_2545 vccd vssd sg13cmos5l_decap_8
XFILLER_19_427 vccd vssd sg13cmos5l_decap_8
XFILLER_1_2639 vccd vssd sg13cmos5l_decap_8
XFILLER_5_2775 vccd vssd sg13cmos5l_decap_8
XFILLER_8_1197 vccd vssd sg13cmos5l_decap_8
XFILLER_21_1855 vccd vssd sg13cmos5l_decap_8
XFILLER_43_920 vccd vssd sg13cmos5l_decap_4
XFILLER_34_419 vccd vssd sg13cmos5l_decap_8
XFILLER_28_994 vccd vssd sg13cmos5l_decap_8
XFILLER_36_84 vccd vssd sg13cmos5l_decap_8
XFILLER_19_2441 vccd vssd sg13cmos5l_decap_8
XFILLER_15_644 vccd vssd sg13cmos5l_decap_8
XFILLER_14_154 vccd vssd sg13cmos5l_decap_8
XFILLER_32_2630 vccd vssd sg13cmos5l_decap_8
XFILLER_19_1795 vccd vssd sg13cmos5l_decap_8
XFILLER_11_861 vccd vssd sg13cmos5l_decap_8
XFILLER_15_1659 vccd vssd sg13cmos5l_decap_8
XFILLER_10_371 vccd vssd sg13cmos5l_decap_8
XFILLER_13_2051 vccd vssd sg13cmos5l_decap_8
XFILLER_7_854 vccd vssd sg13cmos5l_decap_8
XFILLER_13_1372 vccd vssd sg13cmos5l_decap_8
XFILLER_6_364 vccd vssd sg13cmos5l_decap_8
XFILLER_26_2401 vccd vssd sg13cmos5l_decap_8
XFILLER_6_2506 vccd vssd sg13cmos5l_decap_8
XFILLER_2_581 vccd vssd sg13cmos5l_decap_8
XFILLER_43_2770 vccd vssd sg13cmos5l_decap_8
X_1222_ _1223_/A status[115] wire81/X _1357_/C1 status[91] vccd vssd sg13cmos5l_a22oi_1
XFILLER_42_1012 vccd vssd sg13cmos5l_decap_8
XFILLER_6_1827 vccd vssd sg13cmos5l_decap_8
XFILLER_38_725 vccd vssd sg13cmos5l_decap_8
XFILLER_37_224 vccd vssd sg13cmos5l_decap_8
X_1153_ _1153_/Y _1153_/A _1153_/B _1153_/C _1153_/D vccd vssd sg13cmos5l_nand4_1
XFILLER_4_1540 vccd vssd sg13cmos5l_decap_8
XFILLER_4_2296 vccd vssd sg13cmos5l_decap_8
Xtiedowns\[102\] status[102] vccd vssd sg13cmos5l_antennanp
XFILLER_20_1365 vccd vssd sg13cmos5l_decap_8
XFILLER_19_994 vccd vssd sg13cmos5l_decap_8
XFILLER_0_2149 vccd vssd sg13cmos5l_decap_8
X_1084_ _1663_/D hold204/X _1390_/A _1083_/Y _1082_/Y vccd vssd sg13cmos5l_a22oi_1
XFILLER_37_2541 vccd vssd sg13cmos5l_decap_8
XFILLER_33_441 vccd vssd sg13cmos5l_decap_8
XFILLER_37_1862 vccd vssd sg13cmos5l_decap_8
XFILLER_33_1726 vccd vssd sg13cmos5l_decap_8
XFILLER_21_658 vccd vssd sg13cmos5l_decap_8
XFILLER_31_2162 vccd vssd sg13cmos5l_decap_8
X_0937_ _0937_/Y _0938_/A _1394_/C _0938_/C vccd vssd sg13cmos5l_a21oi_1
XFILLER_20_168 vccd vssd sg13cmos5l_decap_8
XFILLER_31_2195 vccd vssd sg13cmos5l_decap_8
XFILLER_11_2769 vccd vssd sg13cmos5l_decap_8
XFILLER_14_1169 vccd vssd sg13cmos5l_decap_8
XFILLER_31_1494 vccd vssd sg13cmos5l_decap_8
X_0868_ _0868_/Y _0868_/A vccd vssd sg13cmos5l_inv_1
XFILLER_27_2209 vccd vssd sg13cmos5l_decap_8
XFILLER_44_2534 vccd vssd sg13cmos5l_decap_8
XFILLER_44_1800 vccd vssd sg13cmos5l_decap_8
XFILLER_0_518 vccd vssd sg13cmos5l_decap_8
XFILLER_29_2091 vccd vssd sg13cmos5l_decap_8
XFILLER_25_1210 vccd vssd sg13cmos5l_decap_8
XFILLER_5_2016 vccd vssd sg13cmos5l_decap_8
XFILLER_9_2163 vccd vssd sg13cmos5l_decap_8
XFILLER_9_1484 vccd vssd sg13cmos5l_decap_8
XFILLER_44_1877 vccd vssd sg13cmos5l_decap_8
XFILLER_5_1337 vccd vssd sg13cmos5l_decap_8
XFILLER_29_769 vccd vssd sg13cmos5l_decap_8
XFILLER_28_224 vccd vssd sg13cmos5l_decap_8
XFILLER_25_920 vccd vssd sg13cmos5l_decap_8
XFILLER_3_1050 vccd vssd sg13cmos5l_decap_8
XFILLER_40_912 vccd vssd sg13cmos5l_decap_8
XFILLER_24_441 vccd vssd sg13cmos5l_decap_8
XFILLER_19_1036 vccd vssd sg13cmos5l_decap_8
XFILLER_0_1960 vccd vssd sg13cmos5l_decap_8
XFILLER_36_2073 vccd vssd sg13cmos5l_decap_8
XFILLER_25_997 vccd vssd sg13cmos5l_decap_8
XFILLER_40_989 vccd vssd sg13cmos5l_decap_8
XFILLER_12_658 vccd vssd sg13cmos5l_decap_8
XFILLER_22_42 vccd vssd sg13cmos5l_decap_8
XFILLER_16_1979 vccd vssd sg13cmos5l_decap_8
XFILLER_11_168 vccd vssd sg13cmos5l_decap_8
XFILLER_14_2393 vccd vssd sg13cmos5l_decap_8
XFILLER_3_301 vccd vssd sg13cmos5l_decap_8
XFILLER_10_1512 vccd vssd sg13cmos5l_decap_8
XFILLER_10_2268 vccd vssd sg13cmos5l_decap_8
XFILLER_4_868 vccd vssd sg13cmos5l_decap_8
XFILLER_27_2721 vccd vssd sg13cmos5l_decap_8
XFILLER_3_378 vccd vssd sg13cmos5l_decap_8
XFILLER_10_1589 vccd vssd sg13cmos5l_decap_8
Xtiedowns\[21\] status[21] vccd vssd sg13cmos5l_antennanp
XFILLER_21_2342 vccd vssd sg13cmos5l_decap_8
XFILLER_19_224 vccd vssd sg13cmos5l_decap_8
XFILLER_1_2436 vccd vssd sg13cmos5l_decap_8
XFILLER_21_1641 vccd vssd sg13cmos5l_decap_8
XFILLER_34_238 vccd vssd sg13cmos5l_decap_8
XFILLER_16_931 vccd vssd sg13cmos5l_decap_8
XFILLER_1_1757 vccd vssd sg13cmos5l_decap_8
XFILLER_43_761 vccd vssd sg13cmos5l_decap_8
XFILLER_37_1114 vccd vssd sg13cmos5l_decap_8
XFILLER_34_2714 vccd vssd sg13cmos5l_decap_8
XFILLER_31_901 vccd vssd sg13cmos5l_decap_8
XFILLER_15_441 vccd vssd sg13cmos5l_decap_8
XFILLER_19_2282 vccd vssd sg13cmos5l_decap_4
XFILLER_30_455 vccd vssd sg13cmos5l_decap_4
XFILLER_15_1456 vccd vssd sg13cmos5l_decap_8
XFILLER_32_2493 vccd vssd sg13cmos5l_decap_8
X_1771_ _1771_/Q clkload7/A _1771_/D fanout116/X vccd vssd sg13cmos5l_dfrbpq_1
XFILLER_7_651 vccd vssd sg13cmos5l_decap_8
XFILLER_8_77 vccd vssd sg13cmos5l_decap_8
XFILLER_11_1309 vccd vssd sg13cmos5l_decap_8
XFILLER_6_161 vccd vssd sg13cmos5l_decap_8
XFILLER_10_2780 vccd vssd sg13cmos5l_decap_8
XFILLER_26_2220 vccd vssd sg13cmos5l_decap_8
XFILLER_6_2303 vccd vssd sg13cmos5l_decap_8
XFILLER_26_1541 vccd vssd sg13cmos5l_decap_8
XFILLER_22_2106 vccd vssd sg13cmos5l_decap_8
XFILLER_26_1585 vccd vssd sg13cmos5l_decap_8
XFILLER_6_1624 vccd vssd sg13cmos5l_decap_8
XFILLER_38_544 vccd vssd sg13cmos5l_decap_8
X_1205_ _1206_/C _1696_/Q _1164_/B _1439_/B vccd vssd sg13cmos5l_a21oi_1
XFILLER_19_0 vccd vssd sg13cmos5l_decap_8
X_1136_ _1138_/C status[85] _1359_/A2 _1135_/Y _1134_/Y _1225_/B vccd vssd sg13cmos5l_a221oi_1
XFILLER_26_706 vccd vssd sg13cmos5l_decap_8
XFILLER_4_2093 vccd vssd sg13cmos5l_decap_8
XFILLER_39_2647 vccd vssd sg13cmos5l_decap_8
XFILLER_39_1924 vccd vssd sg13cmos5l_decap_8
XFILLER_25_238 vccd vssd sg13cmos5l_decap_8
XFILLER_20_1162 vccd vssd sg13cmos5l_decap_8
XFILLER_19_791 vccd vssd sg13cmos5l_decap_8
XFILLER_39_1957 vccd vssd sg13cmos5l_decap_8
XFILLER_34_761 vccd vssd sg13cmos5l_decap_8
XFILLER_0_1267 vccd vssd sg13cmos5l_decap_8
X_1067_ _1348_/B _1067_/A _1074_/C vccd vssd sg13cmos5l_nand2_1
XFILLER_22_945 vccd vssd sg13cmos5l_decap_8
XFILLER_21_455 vccd vssd sg13cmos5l_decap_8
Xtiedowns\[5\] status[5] vccd vssd sg13cmos5l_antennanp
XFILLER_37_1692 vccd vssd sg13cmos5l_decap_4
XFILLER_11_2555 vccd vssd sg13cmos5l_decap_8
XFILLER_11_2588 vccd vssd sg13cmos5l_decap_8
XFILLER_11_1876 vccd vssd sg13cmos5l_decap_8
XFILLER_1_805 vccd vssd sg13cmos5l_decap_8
XFILLER_44_2320 vccd vssd sg13cmos5l_decap_8
XFILLER_0_315 vccd vssd sg13cmos5l_decap_8
XFILLER_44_1630 vccd vssd sg13cmos5l_decap_8
XFILLER_9_1281 vccd vssd sg13cmos5l_decap_8
XFILLER_29_544 vccd vssd sg13cmos5l_decap_8
XFILLER_22_2662 vccd vssd sg13cmos5l_decap_8
XFILLER_2_2723 vccd vssd sg13cmos5l_decap_8
XFILLER_5_1134 vccd vssd sg13cmos5l_decap_8
XFILLER_22_1972 vccd vssd sg13cmos5l_decap_8
XFILLER_17_728 vccd vssd sg13cmos5l_decap_8
XFILLER_44_536 vccd vssd sg13cmos5l_decap_8
XFILLER_17_42 vccd vssd sg13cmos5l_decap_8
XFILLER_16_238 vccd vssd sg13cmos5l_decap_8
XFILLER_38_2179 vccd vssd sg13cmos5l_decap_4
XFILLER_25_794 vccd vssd sg13cmos5l_decap_8
XFILLER_13_945 vccd vssd sg13cmos5l_decap_8
XFILLER_40_753 vccd vssd sg13cmos5l_decap_8
XFILLER_16_2444 vccd vssd sg13cmos5l_decap_8
XFILLER_12_455 vccd vssd sg13cmos5l_decap_8
XFILLER_40_797 vccd vssd sg13cmos5l_decap_8
XFILLER_33_63 vccd vssd sg13cmos5l_decap_8
XFILLER_16_1743 vccd vssd sg13cmos5l_decap_8
XFILLER_9_938 vccd vssd sg13cmos5l_decap_8
XFILLER_32_1044 vccd vssd sg13cmos5l_decap_8
XFILLER_8_448 vccd vssd sg13cmos5l_decap_8
Xtiedowns\[69\] status[69] vccd vssd sg13cmos5l_antennanp
XFILLER_32_1099 vccd vssd sg13cmos5l_decap_8
XFILLER_10_2065 vccd vssd sg13cmos5l_decap_8
XFILLER_45_2128 vccd vssd sg13cmos5l_decap_8
XFILLER_4_665 vccd vssd sg13cmos5l_decap_8
XFILLER_10_1386 vccd vssd sg13cmos5l_decap_8
XFILLER_27_2551 vccd vssd sg13cmos5l_decap_8
XFILLER_3_175 vccd vssd sg13cmos5l_decap_8
XFILLER_45_1449 vccd vssd sg13cmos5l_decap_8
XFILLER_39_308 vccd vssd sg13cmos5l_decap_8
XFILLER_27_2595 vccd vssd sg13cmos5l_decap_8
XFILLER_7_1911 vccd vssd sg13cmos5l_decap_8
XFILLER_27_1883 vccd vssd sg13cmos5l_decap_8
XFILLER_23_2459 vccd vssd sg13cmos5l_decap_8
XFILLER_0_882 vccd vssd sg13cmos5l_decap_8
XFILLER_7_2689 vccd vssd sg13cmos5l_decap_8
XFILLER_43_1173 vccd vssd sg13cmos5l_decap_8
XFILLER_5_2380 vccd vssd sg13cmos5l_decap_8
XFILLER_7_1988 vccd vssd sg13cmos5l_decap_8
XFILLER_12_7 vccd vssd sg13cmos5l_decap_8
XFILLER_35_514 vccd vssd sg13cmos5l_decap_8
XFILLER_23_1769 vccd vssd sg13cmos5l_decap_8
XFILLER_1_2233 vccd vssd sg13cmos5l_decap_8
XFILLER_1_1554 vccd vssd sg13cmos5l_decap_8
XFILLER_31_753 vccd vssd sg13cmos5l_decap_8
XFILLER_34_2588 vccd vssd sg13cmos5l_decap_8
XFILLER_34_1843 vccd vssd sg13cmos5l_decap_8
XFILLER_30_252 vccd vssd sg13cmos5l_decap_8
XFILLER_15_1253 vccd vssd sg13cmos5l_decap_8
X_1754_ _1754_/Q clkload6/A _1754_/D fanout119/X vccd vssd sg13cmos5l_dfrbpq_1
XFILLER_11_1106 vccd vssd sg13cmos5l_decap_8
Xhold404 _1753_/D _1540_/X vccd vssd sg13cmos5l_dlygate4sd3_1
Xhold415 hold415/X _1739_/Q vccd vssd sg13cmos5l_dlygate4sd3_1
Xhold426 _1720_/D _1493_/X vccd vssd sg13cmos5l_dlygate4sd3_1
X_1685_ _1685_/Q _1685_/CLK _1685_/D fanout137/X vccd vssd sg13cmos5l_dfrbpq_1
Xhold459 _1787_/D _1587_/X vccd vssd sg13cmos5l_dlygate4sd3_1
XFILLER_28_2315 vccd vssd sg13cmos5l_decap_8
Xhold437 hold437/X _1760_/Q vccd vssd sg13cmos5l_dlygate4sd3_1
Xhold448 _0938_/C _0936_/Y vccd vssd sg13cmos5l_dlygate4sd3_1
XFILLER_6_2100 vccd vssd sg13cmos5l_decap_8
XFILLER_8_1708 vccd vssd sg13cmos5l_decap_8
XFILLER_28_1658 vccd vssd sg13cmos5l_decap_8
XFILLER_45_2695 vccd vssd sg13cmos5l_decap_8
Xoutbuffers\[52\] control[52] _1720_/Q vccd vssd sg13cmos5l_buf_8
XFILLER_41_2537 vccd vssd sg13cmos5l_decap_8
XFILLER_41_1803 vccd vssd sg13cmos5l_decap_8
XFILLER_6_1421 vccd vssd sg13cmos5l_decap_8
XFILLER_6_2177 vccd vssd sg13cmos5l_decap_8
XFILLER_6_1498 vccd vssd sg13cmos5l_decap_8
XFILLER_38_385 vccd vssd sg13cmos5l_decap_8
XFILLER_39_1721 vccd vssd sg13cmos5l_decap_8
X_1119_ _1119_/X _1118_/Y _0867_/Y _1342_/B vccd vssd sg13cmos5l_mux2_1
XFILLER_17_2720 vccd vssd sg13cmos5l_decap_8
XFILLER_0_1064 vccd vssd sg13cmos5l_decap_8
XFILLER_39_1798 vccd vssd sg13cmos5l_decap_8
XFILLER_22_742 vccd vssd sg13cmos5l_decap_8
XFILLER_33_2065 vccd vssd sg13cmos5l_decap_8
XFILLER_21_252 vccd vssd sg13cmos5l_decap_8
XFILLER_13_2639 vccd vssd sg13cmos5l_decap_8
XFILLER_33_1342 vccd vssd sg13cmos5l_decap_8
XFILLER_10_959 vccd vssd sg13cmos5l_decap_8
XFILLER_11_2396 vccd vssd sg13cmos5l_decap_8
XFILLER_1_602 vccd vssd sg13cmos5l_decap_8
XFILLER_11_1673 vccd vssd sg13cmos5l_decap_8
XFILLER_0_112 vccd vssd sg13cmos5l_decap_8
XFILLER_27_1124 vccd vssd sg13cmos5l_decap_8
XFILLER_24_2713 vccd vssd sg13cmos5l_decap_8
XFILLER_7_1218 vccd vssd sg13cmos5l_decap_8
XFILLER_40_2025 vccd vssd sg13cmos5l_decap_8
XFILLER_1_679 vccd vssd sg13cmos5l_decap_8
XFILLER_2_2520 vccd vssd sg13cmos5l_decap_8
XFILLER_0_189 vccd vssd sg13cmos5l_decap_8
XFILLER_45_812 vccd vssd sg13cmos5l_decap_8
XFILLER_40_1346 vccd vssd sg13cmos5l_decap_8
XFILLER_28_63 vccd vssd sg13cmos5l_decap_8
XFILLER_44_322 vccd vssd sg13cmos5l_decap_8
XFILLER_29_385 vccd vssd sg13cmos5l_decap_8
XFILLER_17_525 vccd vssd sg13cmos5l_decap_8
XFILLER_2_2597 vccd vssd sg13cmos5l_decap_8
XFILLER_2_1841 vccd vssd sg13cmos5l_decap_8
XFILLER_45_889 vccd vssd sg13cmos5l_decap_8
XFILLER_44_399 vccd vssd sg13cmos5l_decap_8
XFILLER_32_539 vccd vssd sg13cmos5l_decap_8
XFILLER_18_2539 vccd vssd sg13cmos5l_decap_8
XFILLER_44_84 vccd vssd sg13cmos5l_decap_8
XFILLER_38_1264 vccd vssd sg13cmos5l_decap_8
XFILLER_25_591 vccd vssd sg13cmos5l_decap_8
XFILLER_16_2230 vccd vssd sg13cmos5l_decap_8
XFILLER_13_742 vccd vssd sg13cmos5l_decap_8
XFILLER_31_2717 vccd vssd sg13cmos5l_decap_8
XFILLER_9_735 vccd vssd sg13cmos5l_decap_8
XFILLER_12_252 vccd vssd sg13cmos5l_decap_8
XFILLER_16_1540 vccd vssd sg13cmos5l_decap_8
XFILLER_8_245 vccd vssd sg13cmos5l_decap_8
XFILLER_5_952 vccd vssd sg13cmos5l_decap_8
XFILLER_29_2657 vccd vssd sg13cmos5l_decap_8
X_1470_ _1470_/X hold522/X hold298/X _1471_/S vccd vssd sg13cmos5l_mux2_1
XFILLER_4_462 vccd vssd sg13cmos5l_decap_8
XFILLER_5_56 vccd vssd sg13cmos5l_decap_8
XFILLER_10_1183 vccd vssd sg13cmos5l_decap_8
XFILLER_45_1246 vccd vssd sg13cmos5l_decap_8
XFILLER_39_105 vccd vssd sg13cmos5l_decap_8
XFILLER_7_2464 vccd vssd sg13cmos5l_decap_8
XFILLER_23_2267 vccd vssd sg13cmos5l_decap_8
XFILLER_3_2317 vccd vssd sg13cmos5l_decap_8
XFILLER_3_1638 vccd vssd sg13cmos5l_decap_8
XFILLER_1_2030 vccd vssd sg13cmos5l_decap_8
XFILLER_7_1785 vccd vssd sg13cmos5l_decap_8
XFILLER_36_834 vccd vssd sg13cmos5l_decap_8
XFILLER_35_322 vccd vssd sg13cmos5l_decap_8
XFILLER_1_1351 vccd vssd sg13cmos5l_decap_8
XFILLER_35_399 vccd vssd sg13cmos5l_decap_8
XFILLER_23_539 vccd vssd sg13cmos5l_decap_8
XFILLER_31_550 vccd vssd sg13cmos5l_decap_8
XFILLER_30_2205 vccd vssd sg13cmos5l_decap_8
XFILLER_17_1337 vccd vssd sg13cmos5l_decap_8
XFILLER_34_2385 vccd vssd sg13cmos5l_decap_8
XFILLER_34_1662 vccd vssd sg13cmos5l_decap_8
XFILLER_15_1050 vccd vssd sg13cmos5l_decap_8
X_1806_ _1806_/Q _1807_/CLK _1806_/D _1641_/Y vccd vssd sg13cmos5l_dfrbpq_1
Xhold201 _1420_/A _1668_/Q vccd vssd sg13cmos5l_dlygate4sd3_1
XFILLER_30_1559 vccd vssd sg13cmos5l_decap_8
XFILLER_12_1960 vccd vssd sg13cmos5l_decap_8
XFILLER_12_2694 vccd vssd sg13cmos5l_decap_8
Xhold234 _1691_/D _1452_/Y vccd vssd sg13cmos5l_dlygate4sd3_1
Xhold223 _1687_/D _1446_/Y vccd vssd sg13cmos5l_dlygate4sd3_1
X_1737_ _1737_/Q _1757_/CLK _1737_/D fanout122/X vccd vssd sg13cmos5l_dfrbpq_1
XFILLER_28_2101 vccd vssd sg13cmos5l_decap_8
Xhold212 _0889_/A _0887_/Y vccd vssd sg13cmos5l_dlygate4sd3_1
Xhold245 _0863_/A _1729_/Q vccd vssd sg13cmos5l_dlygate4sd3_1
X_1668_ _1668_/Q _1675_/CLK _1668_/D _1644_/B_N vccd vssd sg13cmos5l_dfrbpq_1
Xhold267 hold267/X _0858_/Y vccd vssd sg13cmos5l_dlygate4sd3_1
Xhold278 hold278/X _0870_/Y vccd vssd sg13cmos5l_dlygate4sd3_1
Xhold256 hold256/X _1475_/Y vccd vssd sg13cmos5l_dlygate4sd3_1
XFILLER_28_1444 vccd vssd sg13cmos5l_decap_8
Xhold289 _1394_/B _1665_/Q vccd vssd sg13cmos5l_dlygate4sd3_1
XFILLER_8_1505 vccd vssd sg13cmos5l_decap_8
XFILLER_45_2492 vccd vssd sg13cmos5l_decap_8
X_1599_ _1599_/Y _1599_/A _1599_/B vccd vssd sg13cmos5l_nand2_1
XFILLER_22_1043 vccd vssd sg13cmos5l_decap_8
XFILLER_45_119 vccd vssd sg13cmos5l_decap_8
XFILLER_41_1677 vccd vssd sg13cmos5l_decap_8
XFILLER_38_182 vccd vssd sg13cmos5l_decap_8
XFILLER_27_834 vccd vssd sg13cmos5l_decap_8
XFILLER_26_322 vccd vssd sg13cmos5l_decap_8
XFILLER_2_1148 vccd vssd sg13cmos5l_decap_8
XFILLER_6_1295 vccd vssd sg13cmos5l_decap_8
XFILLER_39_2230 vccd vssd sg13cmos5l_decap_8
XFILLER_14_539 vccd vssd sg13cmos5l_decap_8
XFILLER_41_347 vccd vssd sg13cmos5l_decap_8
XFILLER_26_399 vccd vssd sg13cmos5l_decap_8
XFILLER_39_1584 vccd vssd sg13cmos5l_decap_8
XFILLER_14_21 vccd vssd sg13cmos5l_decap_8
XFILLER_35_1459 vccd vssd sg13cmos5l_decap_8
XFILLER_17_1860 vccd vssd sg13cmos5l_decap_8
XFILLER_30_2750 vccd vssd sg13cmos5l_decap_8
XFILLER_10_756 vccd vssd sg13cmos5l_decap_8
XFILLER_14_98 vccd vssd sg13cmos5l_decap_8
XFILLER_6_749 vccd vssd sg13cmos5l_decap_8
XFILLER_13_1757 vccd vssd sg13cmos5l_decap_8
XFILLER_30_42 vccd vssd sg13cmos5l_decap_8
XFILLER_5_259 vccd vssd sg13cmos5l_decap_8
XFILLER_11_2193 vccd vssd sg13cmos5l_decap_8
XFILLER_11_1470 vccd vssd sg13cmos5l_decap_8
XFILLER_24_2510 vccd vssd sg13cmos5l_decap_8
XFILLER_2_966 vccd vssd sg13cmos5l_decap_8
XFILLER_1_476 vccd vssd sg13cmos5l_decap_8
XFILLER_4_2604 vccd vssd sg13cmos5l_decap_8
XFILLER_7_1015 vccd vssd sg13cmos5l_decap_8
XFILLER_39_84 vccd vssd sg13cmos5l_decap_8
XFILLER_40_1121 vccd vssd sg13cmos5l_decap_8
XFILLER_24_2587 vccd vssd sg13cmos5l_decap_8
XFILLER_20_2429 vccd vssd sg13cmos5l_decap_8
XFILLER_18_812 vccd vssd sg13cmos5l_decap_8
XFILLER_4_1925 vccd vssd sg13cmos5l_decap_8
XFILLER_36_119 vccd vssd sg13cmos5l_decap_8
XFILLER_20_1717 vccd vssd sg13cmos5l_decap_8
XFILLER_17_322 vccd vssd sg13cmos5l_decap_8
XFILLER_29_182 vccd vssd sg13cmos5l_decap_8
XFILLER_2_2394 vccd vssd sg13cmos5l_decap_8
XFILLER_45_686 vccd vssd sg13cmos5l_decap_8
XFILLER_33_815 vccd vssd sg13cmos5l_decap_8
XFILLER_18_2303 vccd vssd sg13cmos5l_decap_8
XFILLER_18_889 vccd vssd sg13cmos5l_decap_8
XFILLER_44_185 vccd vssd sg13cmos5l_decap_8
XFILLER_32_336 vccd vssd sg13cmos5l_decap_8
XFILLER_18_1624 vccd vssd sg13cmos5l_decap_8
XFILLER_17_399 vccd vssd sg13cmos5l_decap_8
XFILLER_35_2672 vccd vssd sg13cmos5l_decap_8
X_0970_ _1042_/B _0970_/A _0970_/B _0971_/C vccd vssd sg13cmos5l_nor3_1
XFILLER_9_532 vccd vssd sg13cmos5l_decap_8
XFILLER_35_1993 vccd vssd sg13cmos5l_decap_8
XFILLER_12_1267 vccd vssd sg13cmos5l_decap_8
XFILLER_29_2454 vccd vssd sg13cmos5l_decap_8
X_1522_ _1740_/D _1590_/A1 _1528_/B hold270/X vccd vssd sg13cmos5l_o21ai_1
X_1453_ _1462_/S _1520_/A _1453_/B vccd vssd sg13cmos5l_nand2_1
XFILLER_25_2307 vccd vssd sg13cmos5l_decap_8
XFILLER_9_2537 vccd vssd sg13cmos5l_decap_4
XFILLER_9_2559 vccd vssd sg13cmos5l_decap_8
XFILLER_45_1043 vccd vssd sg13cmos5l_decap_8
XFILLER_42_2643 vccd vssd sg13cmos5l_decap_8
X_1384_ _1384_/Y reset _1598_/B _1210_/B vccd vssd sg13cmos5l_a21oi_1
XFILLER_23_2031 vccd vssd sg13cmos5l_decap_4
XFILLER_3_2114 vccd vssd sg13cmos5l_decap_8
XFILLER_7_2261 vccd vssd sg13cmos5l_decap_8
XFILLER_9_1869 vccd vssd sg13cmos5l_decap_8
XFILLER_42_1964 vccd vssd sg13cmos5l_decap_8
XFILLER_7_1582 vccd vssd sg13cmos5l_decap_8
XFILLER_27_119 vccd vssd sg13cmos5l_decap_8
XFILLER_3_1435 vccd vssd sg13cmos5l_decap_8
XFILLER_36_642 vccd vssd sg13cmos5l_decap_8
Xoutbuffers\[15\] control[15] _1683_/Q vccd vssd sg13cmos5l_buf_8
XFILLER_24_826 vccd vssd sg13cmos5l_decap_8
XFILLER_35_196 vccd vssd sg13cmos5l_decap_8
XFILLER_23_336 vccd vssd sg13cmos5l_decap_8
XFILLER_17_1134 vccd vssd sg13cmos5l_decap_8
XFILLER_14_2778 vccd vssd sg13cmos5l_decap_8
XFILLER_30_1367 vccd vssd sg13cmos5l_decap_4
XFILLER_12_2491 vccd vssd sg13cmos5l_decap_8
XFILLER_8_1302 vccd vssd sg13cmos5l_decap_8
XFILLER_8_2058 vccd vssd sg13cmos5l_decap_8
XFILLER_28_1274 vccd vssd sg13cmos5l_decap_8
XFILLER_41_2153 vccd vssd sg13cmos5l_decap_8
XFILLER_24_1149 vccd vssd sg13cmos5l_decap_8
XFILLER_21_2727 vccd vssd sg13cmos5l_decap_8
XFILLER_19_609 vccd vssd sg13cmos5l_decap_8
XFILLER_8_1379 vccd vssd sg13cmos5l_decap_8
XFILLER_39_480 vccd vssd sg13cmos5l_decap_8
XFILLER_18_119 vccd vssd sg13cmos5l_decap_8
XFILLER_41_1496 vccd vssd sg13cmos5l_decap_8
XFILLER_19_2601 vccd vssd sg13cmos5l_decap_8
XFILLER_3_2681 vccd vssd sg13cmos5l_decap_8
XFILLER_6_1092 vccd vssd sg13cmos5l_decap_8
XFILLER_15_826 vccd vssd sg13cmos5l_decap_8
XFILLER_26_196 vccd vssd sg13cmos5l_decap_8
XFILLER_25_42 vccd vssd sg13cmos5l_decap_8
XFILLER_14_336 vccd vssd sg13cmos5l_decap_8
XFILLER_42_667 vccd vssd sg13cmos5l_decap_8
XFILLER_41_133 vccd vssd sg13cmos5l_decap_8
XFILLER_39_1381 vccd vssd sg13cmos5l_decap_8
XFILLER_19_2678 vccd vssd sg13cmos5l_decap_8
XFILLER_10_553 vccd vssd sg13cmos5l_decap_8
XFILLER_13_2255 vccd vssd sg13cmos5l_decap_8
XFILLER_41_63 vccd vssd sg13cmos5l_decap_8
XFILLER_13_1554 vccd vssd sg13cmos5l_decap_8
Xrebuffer161 _0982_/C _0988_/B vccd vssd sg13cmos5l_buf_8
XFILLER_6_546 vccd vssd sg13cmos5l_decap_8
XFILLER_30_1890 vccd vssd sg13cmos5l_decap_8
Xtiedowns\[51\] status[51] vccd vssd sg13cmos5l_antennanp
XFILLER_26_2649 vccd vssd sg13cmos5l_decap_8
XFILLER_26_1904 vccd vssd sg13cmos5l_decap_8
XFILLER_2_763 vccd vssd sg13cmos5l_decap_8
XFILLER_2_35 vccd vssd sg13cmos5l_decap_8
XFILLER_1_273 vccd vssd sg13cmos5l_decap_8
XFILLER_4_2401 vccd vssd sg13cmos5l_decap_8
XFILLER_42_1249 vccd vssd sg13cmos5l_decap_8
XFILLER_38_918 vccd vssd sg13cmos5l_decap_8
XFILLER_37_406 vccd vssd sg13cmos5l_decap_8
XFILLER_20_1514 vccd vssd sg13cmos5l_decap_8
XFILLER_4_1722 vccd vssd sg13cmos5l_decap_8
XFILLER_4_2478 vccd vssd sg13cmos5l_decap_8
XFILLER_24_1694 vccd vssd sg13cmos5l_decap_8
XFILLER_37_2723 vccd vssd sg13cmos5l_decap_8
XFILLER_33_612 vccd vssd sg13cmos5l_decap_8
XFILLER_18_686 vccd vssd sg13cmos5l_decap_8
XFILLER_2_2191 vccd vssd sg13cmos5l_decap_8
XFILLER_4_1799 vccd vssd sg13cmos5l_decap_8
XFILLER_45_483 vccd vssd sg13cmos5l_decap_8
XFILLER_36_1009 vccd vssd sg13cmos5l_decap_8
XFILLER_18_2144 vccd vssd sg13cmos5l_decap_8
XFILLER_17_196 vccd vssd sg13cmos5l_decap_8
XFILLER_32_133 vccd vssd sg13cmos5l_decap_8
XFILLER_18_1421 vccd vssd sg13cmos5l_decap_8
Xoutbuffers\[105\] control[105] _1773_/Q vccd vssd sg13cmos5l_buf_8
XFILLER_33_1908 vccd vssd sg13cmos5l_decap_4
X_0953_ _0985_/A _1797_/Q SDI _0957_/S vccd vssd sg13cmos5l_mux2_1
XFILLER_18_1498 vccd vssd sg13cmos5l_decap_8
X_0884_ _0884_/Y _1488_/A1 _0883_/B hold178/X vccd vssd sg13cmos5l_o21ai_1
XFILLER_31_1654 vccd vssd sg13cmos5l_decap_8
XFILLER_12_1064 vccd vssd sg13cmos5l_decap_8
XFILLER_44_2716 vccd vssd sg13cmos5l_decap_8
XFILLER_29_2240 vccd vssd sg13cmos5l_decap_8
X_1505_ _1505_/Y hold267/X _1508_/S _1504_/Y vccd vssd sg13cmos5l_a21oi_1
XFILLER_9_2345 vccd vssd sg13cmos5l_decap_8
XFILLER_42_2440 vccd vssd sg13cmos5l_decap_8
X_1436_ _1436_/X _1506_/A hold375/X _1437_/S vccd vssd sg13cmos5l_mux2_1
XFILLER_25_1425 vccd vssd sg13cmos5l_decap_8
XFILLER_9_1666 vccd vssd sg13cmos5l_decap_8
X_1367_ _1369_/C _1772_/Q _1568_/B _1556_/B vccd vssd sg13cmos5l_a21oi_1
XFILLER_29_918 vccd vssd sg13cmos5l_decap_8
XFILLER_28_406 vccd vssd sg13cmos5l_decap_8
XFILLER_5_1519 vccd vssd sg13cmos5l_decap_8
X_1298_ _1298_/Y _1295_/Y _1296_/Y _1297_/Y vccd vssd sg13cmos5l_a21oi_1
XFILLER_23_1193 vccd vssd sg13cmos5l_decap_8
XFILLER_3_1232 vccd vssd sg13cmos5l_decap_8
XFILLER_24_623 vccd vssd sg13cmos5l_decap_8
XFILLER_19_1218 vccd vssd sg13cmos5l_decap_8
XFILLER_23_133 vccd vssd sg13cmos5l_decap_8
XFILLER_36_1598 vccd vssd sg13cmos5l_decap_8
XFILLER_36_1576 vccd vssd sg13cmos5l_decap_8
XFILLER_20_840 vccd vssd sg13cmos5l_decap_8
XFILLER_14_1841 vccd vssd sg13cmos5l_decap_8
XFILLER_30_1131 vccd vssd sg13cmos5l_decap_8
XFILLER_11_77 vccd vssd sg13cmos5l_decap_8
XFILLER_43_2204 vccd vssd sg13cmos5l_decap_8
XFILLER_5_2710 vccd vssd sg13cmos5l_decap_8
XFILLER_25_2693 vccd vssd sg13cmos5l_decap_8
XFILLER_21_2524 vccd vssd sg13cmos5l_decap_8
XFILLER_5_2754 vccd vssd sg13cmos5l_decap_8
XFILLER_8_1176 vccd vssd sg13cmos5l_decap_8
XFILLER_19_406 vccd vssd sg13cmos5l_decap_8
XFILLER_1_2618 vccd vssd sg13cmos5l_decap_8
XFILLER_4_1029 vccd vssd sg13cmos5l_decap_8
XFILLER_36_63 vccd vssd sg13cmos5l_decap_8
XFILLER_1_1939 vccd vssd sg13cmos5l_decap_8
XFILLER_27_483 vccd vssd sg13cmos5l_decap_8
XFILLER_19_2420 vccd vssd sg13cmos5l_decap_8
XFILLER_15_623 vccd vssd sg13cmos5l_decap_8
XFILLER_37_1318 vccd vssd sg13cmos5l_decap_8
XFILLER_14_133 vccd vssd sg13cmos5l_decap_8
XFILLER_42_497 vccd vssd sg13cmos5l_decap_8
XFILLER_30_615 vccd vssd sg13cmos5l_decap_8
XFILLER_19_2497 vccd vssd sg13cmos5l_decap_8
Xtiedowns\[99\] status[99] vccd vssd sg13cmos5l_antennanp
XFILLER_19_1785 vccd vssd sg13cmos5l_decap_4
XFILLER_15_1638 vccd vssd sg13cmos5l_decap_8
XFILLER_11_840 vccd vssd sg13cmos5l_decap_8
XFILLER_13_2030 vccd vssd sg13cmos5l_decap_8
XFILLER_35_1075 vccd vssd sg13cmos5l_decap_8
XFILLER_32_2686 vccd vssd sg13cmos5l_decap_8
XFILLER_7_833 vccd vssd sg13cmos5l_decap_8
XFILLER_10_350 vccd vssd sg13cmos5l_decap_8
XFILLER_6_343 vccd vssd sg13cmos5l_decap_8
XFILLER_13_1351 vccd vssd sg13cmos5l_decap_8
XFILLER_42_7 vccd vssd sg13cmos5l_decap_8
XFILLER_2_560 vccd vssd sg13cmos5l_decap_8
XFILLER_26_2457 vccd vssd sg13cmos5l_decap_4
XFILLER_6_1806 vccd vssd sg13cmos5l_decap_8
X_1221_ _1223_/B status[99] _1357_/A2 _1309_/B1 status[107] vccd vssd sg13cmos5l_a22oi_1
XFILLER_20_2001 vccd vssd sg13cmos5l_decap_8
XFILLER_42_1068 vccd vssd sg13cmos5l_decap_8
XFILLER_37_203 vccd vssd sg13cmos5l_decap_8
XFILLER_26_1789 vccd vssd sg13cmos5l_decap_8
X_1152_ _1153_/D _1769_/Q _1152_/B vccd vssd sg13cmos5l_nand2_1
XFILLER_0_2128 vccd vssd sg13cmos5l_decap_8
XFILLER_4_2275 vccd vssd sg13cmos5l_decap_8
XFILLER_20_2089 vccd vssd sg13cmos5l_decap_4
XFILLER_20_1344 vccd vssd sg13cmos5l_decap_8
XFILLER_19_973 vccd vssd sg13cmos5l_decap_8
XFILLER_4_1596 vccd vssd sg13cmos5l_decap_8
X_1083_ _1083_/Y _0827_/A _0888_/C _1390_/A vccd vssd sg13cmos5l_a21oi_1
XFILLER_45_280 vccd vssd sg13cmos5l_decap_8
XFILLER_37_2520 vccd vssd sg13cmos5l_decap_8
XFILLER_33_420 vccd vssd sg13cmos5l_decap_8
XFILLER_18_483 vccd vssd sg13cmos5l_decap_8
XFILLER_0_1449 vccd vssd sg13cmos5l_decap_8
XFILLER_34_976 vccd vssd sg13cmos5l_decap_8
XFILLER_37_2597 vccd vssd sg13cmos5l_decap_8
XFILLER_37_1841 vccd vssd sg13cmos5l_decap_8
XFILLER_33_497 vccd vssd sg13cmos5l_decap_8
XFILLER_21_637 vccd vssd sg13cmos5l_decap_8
XFILLER_33_1705 vccd vssd sg13cmos5l_decap_8
XFILLER_20_147 vccd vssd sg13cmos5l_decap_8
X_0936_ _0936_/Y _0940_/A _0936_/B vccd vssd sg13cmos5l_nand2_1
XFILLER_18_1295 vccd vssd sg13cmos5l_decap_8
XFILLER_11_2704 vccd vssd sg13cmos5l_decap_8
XFILLER_14_1148 vccd vssd sg13cmos5l_decap_8
XFILLER_31_2174 vccd vssd sg13cmos5l_decap_8
XFILLER_11_2748 vccd vssd sg13cmos5l_decap_8
Xoutbuffers\[82\] control[82] _1750_/Q vccd vssd sg13cmos5l_buf_8
X_0867_ _0867_/Y _0867_/A vccd vssd sg13cmos5l_inv_1
XFILLER_31_1473 vccd vssd sg13cmos5l_decap_8
XFILLER_44_2513 vccd vssd sg13cmos5l_decap_8
XFILLER_29_2070 vccd vssd sg13cmos5l_decap_8
XFILLER_9_2142 vccd vssd sg13cmos5l_decap_8
XFILLER_44_1856 vccd vssd sg13cmos5l_decap_8
X_1419_ _1426_/S _1520_/A _1419_/B vccd vssd sg13cmos5l_nand2_1
XFILLER_9_1463 vccd vssd sg13cmos5l_decap_8
XFILLER_28_203 vccd vssd sg13cmos5l_decap_8
XFILLER_5_1316 vccd vssd sg13cmos5l_decap_8
XFILLER_29_748 vccd vssd sg13cmos5l_decap_8
XFILLER_20_2590 vccd vssd sg13cmos5l_decap_8
XFILLER_36_280 vccd vssd sg13cmos5l_decap_8
XFILLER_24_420 vccd vssd sg13cmos5l_decap_8
XFILLER_0_2695 vccd vssd sg13cmos5l_decap_8
Xwire73 wire73/X wire73/A vccd vssd sg13cmos5l_buf_4
XFILLER_25_976 vccd vssd sg13cmos5l_decap_8
XFILLER_19_1015 vccd vssd sg13cmos5l_decap_8
XFILLER_16_2604 vccd vssd sg13cmos5l_decap_8
XFILLER_36_2052 vccd vssd sg13cmos5l_decap_8
XFILLER_24_497 vccd vssd sg13cmos5l_decap_8
XFILLER_16_2626 vccd vssd sg13cmos5l_decap_4
XFILLER_12_637 vccd vssd sg13cmos5l_decap_8
XFILLER_40_968 vccd vssd sg13cmos5l_decap_8
XFILLER_36_1373 vccd vssd sg13cmos5l_decap_4
XFILLER_11_147 vccd vssd sg13cmos5l_decap_8
XFILLER_36_1384 vccd vssd sg13cmos5l_decap_8
XFILLER_22_21 vccd vssd sg13cmos5l_decap_8
XFILLER_16_1958 vccd vssd sg13cmos5l_decap_8
XFILLER_14_2372 vccd vssd sg13cmos5l_decap_8
XFILLER_10_2247 vccd vssd sg13cmos5l_decap_8
XFILLER_22_98 vccd vssd sg13cmos5l_decap_8
XFILLER_27_2700 vccd vssd sg13cmos5l_decap_8
XFILLER_4_847 vccd vssd sg13cmos5l_decap_8
XFILLER_10_1568 vccd vssd sg13cmos5l_decap_8
XFILLER_3_357 vccd vssd sg13cmos5l_decap_8
XFILLER_27_2777 vccd vssd sg13cmos5l_decap_8
XFILLER_43_1344 vccd vssd sg13cmos5l_decap_8
XFILLER_21_2321 vccd vssd sg13cmos5l_decap_8
XFILLER_19_203 vccd vssd sg13cmos5l_decap_8
XFILLER_5_2562 vccd vssd sg13cmos5l_decap_8
XFILLER_21_1620 vccd vssd sg13cmos5l_decap_8
XFILLER_1_2415 vccd vssd sg13cmos5l_decap_8
XFILLER_5_2595 vccd vssd sg13cmos5l_decap_8
Xtiedowns\[14\] status[14] vccd vssd sg13cmos5l_antennanp
XFILLER_21_2398 vccd vssd sg13cmos5l_decap_8
XFILLER_16_910 vccd vssd sg13cmos5l_decap_8
XFILLER_1_1736 vccd vssd sg13cmos5l_decap_8
XFILLER_5_1883 vccd vssd sg13cmos5l_decap_8
XFILLER_34_217 vccd vssd sg13cmos5l_decap_8
XFILLER_27_280 vccd vssd sg13cmos5l_decap_8
XFILLER_21_1697 vccd vssd sg13cmos5l_decap_8
XFILLER_15_420 vccd vssd sg13cmos5l_decap_8
XFILLER_16_987 vccd vssd sg13cmos5l_decap_8
XFILLER_19_2261 vccd vssd sg13cmos5l_decap_8
XFILLER_15_2114 vccd vssd sg13cmos5l_decap_8
XFILLER_31_957 vccd vssd sg13cmos5l_decap_8
XFILLER_30_434 vccd vssd sg13cmos5l_decap_8
XFILLER_19_1582 vccd vssd sg13cmos5l_decap_8
XFILLER_15_497 vccd vssd sg13cmos5l_decap_8
X_1770_ _1770_/Q clkload6/A _1770_/D fanout118/X vccd vssd sg13cmos5l_dfrbpq_1
XFILLER_15_1435 vccd vssd sg13cmos5l_decap_8
XFILLER_8_56 vccd vssd sg13cmos5l_decap_8
XFILLER_32_2472 vccd vssd sg13cmos5l_decap_8
Xclkbuf_5_11_0_SCK clkload8/A clkbuf_5_9_0_SCK/A vccd vssd sg13cmos5l_buf_8
XFILLER_7_630 vccd vssd sg13cmos5l_decap_8
XFILLER_6_140 vccd vssd sg13cmos5l_decap_8
XFILLER_44_1119 vccd vssd sg13cmos5l_decap_8
Xclkbuf_5_26_0_SCK _1707_/CLK clkbuf_3_6_0_SCK/X vccd vssd sg13cmos5l_buf_8
XFILLER_41_2719 vccd vssd sg13cmos5l_decap_8
XFILLER_26_1520 vccd vssd sg13cmos5l_decap_8
XFILLER_6_1603 vccd vssd sg13cmos5l_decap_8
XFILLER_6_2359 vccd vssd sg13cmos5l_decap_8
XFILLER_38_523 vccd vssd sg13cmos5l_decap_8
X_1204_ _1206_/A _1704_/Q _1463_/B vccd vssd sg13cmos5l_nand2_1
XFILLER_4_2072 vccd vssd sg13cmos5l_decap_8
X_1135_ _1135_/Y status[93] _1135_/B vccd vssd sg13cmos5l_nand2b_1
XFILLER_39_2626 vccd vssd sg13cmos5l_decap_8
XFILLER_38_589 vccd vssd sg13cmos5l_decap_8
XFILLER_19_770 vccd vssd sg13cmos5l_decap_8
XFILLER_25_217 vccd vssd sg13cmos5l_decap_8
XFILLER_20_1141 vccd vssd sg13cmos5l_decap_8
XFILLER_4_1393 vccd vssd sg13cmos5l_decap_8
XFILLER_18_280 vccd vssd sg13cmos5l_decap_8
XFILLER_0_1246 vccd vssd sg13cmos5l_decap_8
X_1066_ _1066_/X _1067_/A _1074_/C vccd vssd sg13cmos5l_and2_1
XFILLER_37_2383 vccd vssd sg13cmos5l_decap_8
XFILLER_22_924 vccd vssd sg13cmos5l_decap_8
XFILLER_33_294 vccd vssd sg13cmos5l_decap_8
XFILLER_21_434 vccd vssd sg13cmos5l_decap_8
XFILLER_18_1092 vccd vssd sg13cmos5l_decap_8
X_0919_ _0920_/A _0922_/A2 _0909_/C _0936_/B vccd vssd sg13cmos5l_o21ai_1
XFILLER_11_1855 vccd vssd sg13cmos5l_decap_8
XFILLER_44_2387 vccd vssd sg13cmos5l_decap_8
XFILLER_40_2229 vccd vssd sg13cmos5l_decap_8
XFILLER_29_501 vccd vssd sg13cmos5l_decap_8
XFILLER_22_2641 vccd vssd sg13cmos5l_decap_8
XFILLER_2_2702 vccd vssd sg13cmos5l_decap_8
XFILLER_5_1113 vccd vssd sg13cmos5l_decap_8
XFILLER_9_1260 vccd vssd sg13cmos5l_decap_8
XFILLER_44_1686 vccd vssd sg13cmos5l_decap_8
XFILLER_25_1085 vccd vssd sg13cmos5l_decap_8
XFILLER_17_707 vccd vssd sg13cmos5l_decap_8
XFILLER_17_21 vccd vssd sg13cmos5l_decap_8
XFILLER_2_2779 vccd vssd sg13cmos5l_decap_8
XFILLER_16_217 vccd vssd sg13cmos5l_decap_8
XFILLER_38_2158 vccd vssd sg13cmos5l_decap_8
XFILLER_17_98 vccd vssd sg13cmos5l_decap_8
XFILLER_0_2492 vccd vssd sg13cmos5l_decap_8
XFILLER_25_773 vccd vssd sg13cmos5l_decap_8
XFILLER_16_2423 vccd vssd sg13cmos5l_decap_8
XFILLER_13_924 vccd vssd sg13cmos5l_decap_8
XFILLER_40_732 vccd vssd sg13cmos5l_decap_8
XFILLER_33_42 vccd vssd sg13cmos5l_decap_8
XFILLER_24_294 vccd vssd sg13cmos5l_decap_8
XFILLER_16_1722 vccd vssd sg13cmos5l_decap_8
XFILLER_9_917 vccd vssd sg13cmos5l_decap_8
XFILLER_12_434 vccd vssd sg13cmos5l_decap_8
XFILLER_8_427 vccd vssd sg13cmos5l_decap_8
XFILLER_32_1023 vccd vssd sg13cmos5l_decap_8
XFILLER_14_2180 vccd vssd sg13cmos5l_decap_8
XFILLER_16_1799 vccd vssd sg13cmos5l_decap_8
XFILLER_10_2044 vccd vssd sg13cmos5l_decap_8
XFILLER_4_644 vccd vssd sg13cmos5l_decap_8
XFILLER_45_2107 vccd vssd sg13cmos5l_decap_8
XFILLER_3_154 vccd vssd sg13cmos5l_decap_8
XFILLER_10_1365 vccd vssd sg13cmos5l_decap_8
XFILLER_27_2530 vccd vssd sg13cmos5l_decap_8
XFILLER_7_2602 vccd vssd sg13cmos5l_decap_8
XFILLER_45_1428 vccd vssd sg13cmos5l_decap_8
XFILLER_43_1130 vccd vssd sg13cmos5l_decap_8
XFILLER_27_1862 vccd vssd sg13cmos5l_decap_8
XFILLER_23_2438 vccd vssd sg13cmos5l_decap_8
XFILLER_0_861 vccd vssd sg13cmos5l_decap_8
XFILLER_23_1748 vccd vssd sg13cmos5l_decap_8
XFILLER_21_2140 vccd vssd sg13cmos5l_decap_8
XFILLER_1_2212 vccd vssd sg13cmos5l_decap_8
XFILLER_7_1967 vccd vssd sg13cmos5l_decap_8
XFILLER_40_2785 vccd vssd sg13cmos5l_decap_4
XFILLER_1_2289 vccd vssd sg13cmos5l_decap_8
XFILLER_1_1533 vccd vssd sg13cmos5l_decap_8
XFILLER_5_1680 vccd vssd sg13cmos5l_decap_8
XFILLER_21_1494 vccd vssd sg13cmos5l_decap_8
XFILLER_16_784 vccd vssd sg13cmos5l_decap_8
XFILLER_31_732 vccd vssd sg13cmos5l_decap_8
XFILLER_30_231 vccd vssd sg13cmos5l_decap_8
XFILLER_17_1519 vccd vssd sg13cmos5l_decap_8
XFILLER_15_294 vccd vssd sg13cmos5l_decap_8
XFILLER_34_2567 vccd vssd sg13cmos5l_decap_8
XFILLER_15_1232 vccd vssd sg13cmos5l_decap_8
X_1753_ _1753_/Q _1763_/CLK _1753_/D fanout119/X vccd vssd sg13cmos5l_dfrbpq_1
XFILLER_32_2291 vccd vssd sg13cmos5l_decap_8
X_1684_ _1684_/Q _1685_/CLK _1684_/D fanout137/X vccd vssd sg13cmos5l_dfrbpq_1
Xhold416 _1739_/D _1519_/X vccd vssd sg13cmos5l_dlygate4sd3_1
Xhold405 hold405/X _1689_/Q vccd vssd sg13cmos5l_dlygate4sd3_1
Xhold427 hold427/X _1738_/Q vccd vssd sg13cmos5l_dlygate4sd3_1
XFILLER_8_994 vccd vssd sg13cmos5l_decap_8
Xhold438 _1760_/D _1551_/X vccd vssd sg13cmos5l_dlygate4sd3_1
Xhold449 hold449/X _0937_/Y vccd vssd sg13cmos5l_dlygate4sd3_1
XFILLER_28_1637 vccd vssd sg13cmos5l_decap_8
XFILLER_45_2674 vccd vssd sg13cmos5l_decap_8
XFILLER_41_2516 vccd vssd sg13cmos5l_decap_8
XFILLER_31_0 vccd vssd sg13cmos5l_decap_8
XFILLER_26_2073 vccd vssd sg13cmos5l_decap_8
XFILLER_6_1400 vccd vssd sg13cmos5l_decap_8
XFILLER_6_2156 vccd vssd sg13cmos5l_decap_8
XFILLER_45_1995 vccd vssd sg13cmos5l_decap_8
Xoutbuffers\[45\] control[45] _1713_/Q vccd vssd sg13cmos5l_buf_8
XFILLER_2_2009 vccd vssd sg13cmos5l_decap_8
XFILLER_41_1859 vccd vssd sg13cmos5l_decap_8
XFILLER_38_364 vccd vssd sg13cmos5l_decap_8
XFILLER_26_504 vccd vssd sg13cmos5l_decap_8
XFILLER_6_1477 vccd vssd sg13cmos5l_decap_8
XFILLER_39_2434 vccd vssd sg13cmos5l_decap_4
XFILLER_39_1700 vccd vssd sg13cmos5l_decap_8
X_1118_ _1118_/Y _1115_/Y _1116_/X _1117_/Y vccd vssd sg13cmos5l_o21ai_1
XFILLER_0_1043 vccd vssd sg13cmos5l_decap_8
XFILLER_4_1190 vccd vssd sg13cmos5l_decap_8
X_1049_ _1049_/Y _0875_/Y _1162_/B _1044_/Y _1047_/Y _1164_/B vccd vssd sg13cmos5l_a221oi_1
XFILLER_39_1777 vccd vssd sg13cmos5l_decap_8
XFILLER_37_2180 vccd vssd sg13cmos5l_decap_8
XFILLER_34_592 vccd vssd sg13cmos5l_decap_8
XFILLER_22_721 vccd vssd sg13cmos5l_decap_8
XFILLER_33_2044 vccd vssd sg13cmos5l_decap_8
XFILLER_21_231 vccd vssd sg13cmos5l_decap_8
XFILLER_17_2776 vccd vssd sg13cmos5l_decap_8
XFILLER_16_1029 vccd vssd sg13cmos5l_decap_8
XFILLER_22_798 vccd vssd sg13cmos5l_decap_8
XFILLER_10_938 vccd vssd sg13cmos5l_decap_8
XFILLER_13_1939 vccd vssd sg13cmos5l_decap_8
XFILLER_33_1398 vccd vssd sg13cmos5l_decap_8
XFILLER_11_1652 vccd vssd sg13cmos5l_decap_8
XFILLER_11_2375 vccd vssd sg13cmos5l_decap_8
XFILLER_1_658 vccd vssd sg13cmos5l_decap_8
XFILLER_44_2173 vccd vssd sg13cmos5l_decap_8
XFILLER_40_2004 vccd vssd sg13cmos5l_decap_8
XFILLER_24_2769 vccd vssd sg13cmos5l_decap_8
XFILLER_0_168 vccd vssd sg13cmos5l_decap_8
XFILLER_44_1483 vccd vssd sg13cmos5l_decap_8
XFILLER_40_1325 vccd vssd sg13cmos5l_decap_8
XFILLER_29_364 vccd vssd sg13cmos5l_decap_8
XFILLER_28_42 vccd vssd sg13cmos5l_decap_8
XFILLER_17_504 vccd vssd sg13cmos5l_decap_8
XFILLER_44_301 vccd vssd sg13cmos5l_decap_8
XFILLER_22_1781 vccd vssd sg13cmos5l_decap_8
XFILLER_2_2576 vccd vssd sg13cmos5l_decap_8
XFILLER_2_1820 vccd vssd sg13cmos5l_decap_8
XFILLER_45_868 vccd vssd sg13cmos5l_decap_8
XFILLER_18_2518 vccd vssd sg13cmos5l_decap_8
XFILLER_44_378 vccd vssd sg13cmos5l_decap_8
XFILLER_38_1232 vccd vssd sg13cmos5l_decap_8
XFILLER_32_518 vccd vssd sg13cmos5l_decap_8
XFILLER_18_1806 vccd vssd sg13cmos5l_decap_8
XFILLER_2_1897 vccd vssd sg13cmos5l_decap_8
XFILLER_44_63 vccd vssd sg13cmos5l_decap_8
XFILLER_13_721 vccd vssd sg13cmos5l_decap_8
XFILLER_9_714 vccd vssd sg13cmos5l_decap_8
XFILLER_12_231 vccd vssd sg13cmos5l_decap_8
XFILLER_8_224 vccd vssd sg13cmos5l_decap_8
XFILLER_12_2128 vccd vssd sg13cmos5l_decap_8
XFILLER_13_798 vccd vssd sg13cmos5l_decap_8
Xtiedowns\[81\] status[81] vccd vssd sg13cmos5l_antennanp
XFILLER_16_1596 vccd vssd sg13cmos5l_decap_8
XFILLER_5_931 vccd vssd sg13cmos5l_decap_8
XFILLER_12_1449 vccd vssd sg13cmos5l_decap_8
XFILLER_29_2636 vccd vssd sg13cmos5l_decap_8
XFILLER_4_441 vccd vssd sg13cmos5l_decap_8
XFILLER_5_35 vccd vssd sg13cmos5l_decap_8
XFILLER_9_2708 vccd vssd sg13cmos5l_decap_8
XFILLER_10_1162 vccd vssd sg13cmos5l_decap_8
XFILLER_45_1225 vccd vssd sg13cmos5l_decap_8
XFILLER_7_2443 vccd vssd sg13cmos5l_decap_8
XFILLER_23_2246 vccd vssd sg13cmos5l_decap_8
XFILLER_7_1764 vccd vssd sg13cmos5l_decap_8
XFILLER_40_2582 vccd vssd sg13cmos5l_decap_8
XFILLER_36_813 vccd vssd sg13cmos5l_decap_8
XFILLER_3_1617 vccd vssd sg13cmos5l_decap_8
XFILLER_35_301 vccd vssd sg13cmos5l_decap_8
XFILLER_1_2086 vccd vssd sg13cmos5l_decap_8
XFILLER_1_1330 vccd vssd sg13cmos5l_decap_8
XFILLER_35_378 vccd vssd sg13cmos5l_decap_8
XFILLER_23_518 vccd vssd sg13cmos5l_decap_8
XFILLER_17_2039 vccd vssd sg13cmos5l_decap_8
XFILLER_17_1316 vccd vssd sg13cmos5l_decap_8
XFILLER_16_581 vccd vssd sg13cmos5l_decap_8
XFILLER_30_2239 vccd vssd sg13cmos5l_decap_8
X_1805_ _1805_/Q _1807_/CLK _1805_/D _1640_/Y vccd vssd sg13cmos5l_dfrbpq_1
Xhold202 hold202/X _1420_/Y vccd vssd sg13cmos5l_dlygate4sd3_1
XFILLER_30_1538 vccd vssd sg13cmos5l_decap_8
X_1736_ _1736_/Q _1736_/CLK _1736_/D fanout125/X vccd vssd sg13cmos5l_dfrbpq_1
XFILLER_8_791 vccd vssd sg13cmos5l_decap_8
XFILLER_12_2673 vccd vssd sg13cmos5l_decap_8
Xhold224 _0876_/A _1755_/Q vccd vssd sg13cmos5l_dlygate4sd3_1
Xhold235 _1545_/A _1756_/Q vccd vssd sg13cmos5l_dlygate4sd3_1
Xhold213 _1808_/D _0889_/Y vccd vssd sg13cmos5l_dlygate4sd3_1
Xhold246 hold246/X _0863_/Y vccd vssd sg13cmos5l_dlygate4sd3_1
Xhold257 _1708_/D _1476_/Y vccd vssd sg13cmos5l_dlygate4sd3_1
Xhold268 _1728_/D _1505_/Y vccd vssd sg13cmos5l_dlygate4sd3_1
X_1667_ sdo_ena _1667_/CLK _1667_/D _0943_/Y vccd vssd sg13cmos5l_dfrbpq_1
Xhold279 _1762_/D _1554_/Y vccd vssd sg13cmos5l_dlygate4sd3_1
XFILLER_28_1423 vccd vssd sg13cmos5l_decap_8
X_1598_ _1599_/B _1655_/Q _1598_/B vccd vssd sg13cmos5l_nand2_1
XFILLER_45_2471 vccd vssd sg13cmos5l_decap_8
XFILLER_24_1309 vccd vssd sg13cmos5l_decap_8
XFILLER_45_1792 vccd vssd sg13cmos5l_decap_8
XFILLER_41_2335 vccd vssd sg13cmos5l_decap_8
XFILLER_41_1623 vccd vssd sg13cmos5l_decap_8
XFILLER_41_1656 vccd vssd sg13cmos5l_decap_8
XFILLER_22_1022 vccd vssd sg13cmos5l_decap_8
XFILLER_6_1274 vccd vssd sg13cmos5l_decap_8
XFILLER_39_673 vccd vssd sg13cmos5l_decap_8
XFILLER_38_161 vccd vssd sg13cmos5l_decap_8
XFILLER_26_301 vccd vssd sg13cmos5l_decap_8
XFILLER_2_1127 vccd vssd sg13cmos5l_decap_8
XFILLER_22_1099 vccd vssd sg13cmos5l_decap_8
XFILLER_26_378 vccd vssd sg13cmos5l_decap_8
XFILLER_14_518 vccd vssd sg13cmos5l_decap_8
XFILLER_42_849 vccd vssd sg13cmos5l_decap_8
XFILLER_41_326 vccd vssd sg13cmos5l_decap_8
XFILLER_39_2286 vccd vssd sg13cmos5l_decap_8
XFILLER_39_1563 vccd vssd sg13cmos5l_decap_8
XFILLER_17_2540 vccd vssd sg13cmos5l_decap_8
XFILLER_22_595 vccd vssd sg13cmos5l_decap_8
XFILLER_17_2595 vccd vssd sg13cmos5l_decap_8
XFILLER_10_735 vccd vssd sg13cmos5l_decap_8
XFILLER_14_77 vccd vssd sg13cmos5l_decap_8
XFILLER_13_2426 vccd vssd sg13cmos5l_decap_8
XFILLER_33_1151 vccd vssd sg13cmos5l_decap_8
XFILLER_13_1736 vccd vssd sg13cmos5l_decap_8
XFILLER_33_1184 vccd vssd sg13cmos5l_decap_4
XFILLER_30_21 vccd vssd sg13cmos5l_decap_8
XFILLER_6_728 vccd vssd sg13cmos5l_decap_8
XFILLER_5_238 vccd vssd sg13cmos5l_decap_8
XFILLER_11_2172 vccd vssd sg13cmos5l_decap_8
XFILLER_30_98 vccd vssd sg13cmos5l_decap_8
XFILLER_2_945 vccd vssd sg13cmos5l_decap_8
XFILLER_1_455 vccd vssd sg13cmos5l_decap_8
XFILLER_39_63 vccd vssd sg13cmos5l_decap_8
XFILLER_24_2566 vccd vssd sg13cmos5l_decap_8
XFILLER_20_2408 vccd vssd sg13cmos5l_decap_8
XFILLER_4_1904 vccd vssd sg13cmos5l_decap_8
XFILLER_44_1280 vccd vssd sg13cmos5l_decap_8
XFILLER_24_1854 vccd vssd sg13cmos5l_decap_8
XFILLER_29_161 vccd vssd sg13cmos5l_decap_8
XFILLER_17_301 vccd vssd sg13cmos5l_decap_8
XFILLER_40_1188 vccd vssd sg13cmos5l_decap_8
XFILLER_18_868 vccd vssd sg13cmos5l_decap_8
XFILLER_2_2373 vccd vssd sg13cmos5l_decap_8
XFILLER_45_665 vccd vssd sg13cmos5l_decap_8
XFILLER_17_378 vccd vssd sg13cmos5l_decap_8
XFILLER_2_1694 vccd vssd sg13cmos5l_decap_8
XFILLER_32_315 vccd vssd sg13cmos5l_decap_8
XFILLER_18_1603 vccd vssd sg13cmos5l_decap_8
XFILLER_35_2651 vccd vssd sg13cmos5l_decap_8
XFILLER_9_511 vccd vssd sg13cmos5l_decap_8
XFILLER_13_595 vccd vssd sg13cmos5l_decap_8
XFILLER_40_392 vccd vssd sg13cmos5l_decap_8
XFILLER_35_1972 vccd vssd sg13cmos5l_decap_8
XFILLER_31_1825 vccd vssd sg13cmos5l_decap_8
XFILLER_31_1869 vccd vssd sg13cmos5l_decap_8
XFILLER_31_1847 vccd vssd sg13cmos5l_decap_8
XFILLER_16_1393 vccd vssd sg13cmos5l_decap_8
XFILLER_9_588 vccd vssd sg13cmos5l_decap_8
XFILLER_12_1246 vccd vssd sg13cmos5l_decap_8
X_1521_ _1521_/Y _1521_/A _1528_/B vccd vssd sg13cmos5l_nand2_1
XFILLER_9_2516 vccd vssd sg13cmos5l_decap_8
X_1452_ _1452_/Y hold233/X _1451_/B _1451_/Y vccd vssd sg13cmos5l_a21oi_1
XFILLER_45_1022 vccd vssd sg13cmos5l_decap_8
XFILLER_42_2622 vccd vssd sg13cmos5l_decap_8
XFILLER_29_1787 vccd vssd sg13cmos5l_decap_8
XFILLER_29_1754 vccd vssd sg13cmos5l_decap_8
XFILLER_23_2010 vccd vssd sg13cmos5l_decap_8
XFILLER_7_2240 vccd vssd sg13cmos5l_decap_8
XFILLER_9_1848 vccd vssd sg13cmos5l_decap_8
X_1383_ _1383_/Y _1668_/Q _1382_/A _1382_/Y vccd vssd sg13cmos5l_o21ai_1
XFILLER_45_1099 vccd vssd sg13cmos5l_decap_8
Xtiedowns\[125\] status[125] vccd vssd sg13cmos5l_antennanp
XFILLER_42_2699 vccd vssd sg13cmos5l_decap_8
XFILLER_7_1561 vccd vssd sg13cmos5l_decap_8
XFILLER_42_1987 vccd vssd sg13cmos5l_decap_8
XFILLER_36_621 vccd vssd sg13cmos5l_decap_8
XFILLER_3_1414 vccd vssd sg13cmos5l_decap_8
XFILLER_24_805 vccd vssd sg13cmos5l_decap_8
XFILLER_36_1703 vccd vssd sg13cmos5l_decap_8
XFILLER_35_175 vccd vssd sg13cmos5l_decap_8
XFILLER_23_315 vccd vssd sg13cmos5l_decap_8
XFILLER_32_860 vccd vssd sg13cmos5l_decap_8
XFILLER_17_1113 vccd vssd sg13cmos5l_decap_8
XFILLER_14_2713 vccd vssd sg13cmos5l_decap_8
XFILLER_31_392 vccd vssd sg13cmos5l_decap_8
XFILLER_14_2757 vccd vssd sg13cmos5l_decap_8
XFILLER_30_2069 vccd vssd sg13cmos5l_decap_8
XFILLER_30_1346 vccd vssd sg13cmos5l_decap_8
X_1719_ _1719_/Q clkload5/A _1719_/D fanout128/X vccd vssd sg13cmos5l_dfrbpq_1
XFILLER_28_1253 vccd vssd sg13cmos5l_decap_8
XFILLER_8_2037 vccd vssd sg13cmos5l_decap_8
XFILLER_41_2132 vccd vssd sg13cmos5l_decap_8
XFILLER_21_2706 vccd vssd sg13cmos5l_decap_8
XFILLER_8_1358 vccd vssd sg13cmos5l_decap_8
XFILLER_3_2660 vccd vssd sg13cmos5l_decap_8
XFILLER_6_1071 vccd vssd sg13cmos5l_decap_8
XFILLER_41_1475 vccd vssd sg13cmos5l_decap_8
XFILLER_39_2050 vccd vssd sg13cmos5l_decap_8
XFILLER_27_665 vccd vssd sg13cmos5l_decap_8
XFILLER_25_21 vccd vssd sg13cmos5l_decap_8
XFILLER_15_805 vccd vssd sg13cmos5l_decap_8
XFILLER_3_1981 vccd vssd sg13cmos5l_decap_8
XFILLER_41_112 vccd vssd sg13cmos5l_decap_8
XFILLER_39_2083 vccd vssd sg13cmos5l_decap_8
XFILLER_26_175 vccd vssd sg13cmos5l_decap_8
XFILLER_19_2657 vccd vssd sg13cmos5l_decap_8
XFILLER_19_1923 vccd vssd sg13cmos5l_decap_4
XFILLER_14_315 vccd vssd sg13cmos5l_decap_8
XFILLER_30_819 vccd vssd sg13cmos5l_decap_8
XFILLER_41_189 vccd vssd sg13cmos5l_decap_8
XFILLER_25_98 vccd vssd sg13cmos5l_decap_8
XFILLER_23_882 vccd vssd sg13cmos5l_decap_8
XFILLER_13_2223 vccd vssd sg13cmos5l_decap_8
XFILLER_22_392 vccd vssd sg13cmos5l_decap_8
XFILLER_17_2392 vccd vssd sg13cmos5l_decap_8
XFILLER_17_1680 vccd vssd sg13cmos5l_decap_8
XFILLER_10_532 vccd vssd sg13cmos5l_decap_8
XFILLER_41_42 vccd vssd sg13cmos5l_decap_8
XFILLER_6_525 vccd vssd sg13cmos5l_decap_8
XFILLER_13_1533 vccd vssd sg13cmos5l_decap_8
Xrebuffer162 _0981_/C _0988_/B vccd vssd sg13cmos5l_buf_2
XFILLER_26_2628 vccd vssd sg13cmos5l_decap_8
XFILLER_2_742 vccd vssd sg13cmos5l_decap_8
XFILLER_9_0 vccd vssd sg13cmos5l_decap_8
Xtiedowns\[44\] status[44] vccd vssd sg13cmos5l_antennanp
XFILLER_1_252 vccd vssd sg13cmos5l_decap_8
XFILLER_24_2330 vccd vssd sg13cmos5l_decap_8
XFILLER_2_14 vccd vssd sg13cmos5l_decap_8
XFILLER_42_1228 vccd vssd sg13cmos5l_decap_8
XFILLER_4_1701 vccd vssd sg13cmos5l_decap_8
XFILLER_4_2457 vccd vssd sg13cmos5l_decap_8
XFILLER_24_1673 vccd vssd sg13cmos5l_decap_8
XFILLER_2_2170 vccd vssd sg13cmos5l_decap_8
XFILLER_4_1778 vccd vssd sg13cmos5l_decap_8
XFILLER_45_462 vccd vssd sg13cmos5l_decap_8
XFILLER_37_2702 vccd vssd sg13cmos5l_decap_8
XFILLER_18_665 vccd vssd sg13cmos5l_decap_8
XFILLER_32_112 vccd vssd sg13cmos5l_decap_8
XFILLER_18_2123 vccd vssd sg13cmos5l_decap_8
XFILLER_17_175 vccd vssd sg13cmos5l_decap_8
XFILLER_2_1491 vccd vssd sg13cmos5l_decap_8
XFILLER_37_2779 vccd vssd sg13cmos5l_decap_8
XFILLER_21_819 vccd vssd sg13cmos5l_decap_8
XFILLER_18_1400 vccd vssd sg13cmos5l_decap_8
XFILLER_14_2009 vccd vssd sg13cmos5l_decap_8
XFILLER_32_189 vccd vssd sg13cmos5l_decap_8
X_0952_ _0952_/Y _0970_/B _0952_/B _1042_/A vccd vssd sg13cmos5l_nand3_1
XFILLER_20_329 vccd vssd sg13cmos5l_decap_8
XFILLER_14_882 vccd vssd sg13cmos5l_decap_8
XFILLER_35_2492 vccd vssd sg13cmos5l_decap_8
XFILLER_31_2334 vccd vssd sg13cmos5l_decap_8
XFILLER_18_1477 vccd vssd sg13cmos5l_decap_8
XFILLER_13_392 vccd vssd sg13cmos5l_decap_8
XFILLER_31_1633 vccd vssd sg13cmos5l_decap_8
X_0883_ _0883_/Y _0883_/A _0883_/B vccd vssd sg13cmos5l_nand2_1
XFILLER_16_1190 vccd vssd sg13cmos5l_decap_8
XFILLER_9_385 vccd vssd sg13cmos5l_decap_8
XFILLER_31_2389 vccd vssd sg13cmos5l_decap_8
XFILLER_12_1043 vccd vssd sg13cmos5l_decap_8
XFILLER_31_1699 vccd vssd sg13cmos5l_decap_8
X_1504_ _1504_/Y _1504_/A _1508_/S vccd vssd sg13cmos5l_nor2_1
XFILLER_9_2324 vccd vssd sg13cmos5l_decap_8
XFILLER_29_2296 vccd vssd sg13cmos5l_decap_8
X_1435_ _1435_/X _1504_/A hold377/X _1437_/S vccd vssd sg13cmos5l_mux2_1
XFILLER_25_1404 vccd vssd sg13cmos5l_decap_8
XFILLER_9_1645 vccd vssd sg13cmos5l_decap_8
X_1366_ _1369_/B status[8] _1324_/B _1366_/B1 status[0] vccd vssd sg13cmos5l_a22oi_1
XFILLER_42_2463 vccd vssd sg13cmos5l_decap_8
XFILLER_25_1459 vccd vssd sg13cmos5l_decap_8
XFILLER_3_1211 vccd vssd sg13cmos5l_decap_8
XFILLER_42_1795 vccd vssd sg13cmos5l_decap_8
X_1297_ _1297_/Y _1670_/Q _1382_/A _1060_/Y vccd vssd sg13cmos5l_o21ai_1
XFILLER_20_2772 vccd vssd sg13cmos5l_decap_8
XFILLER_24_602 vccd vssd sg13cmos5l_decap_8
XFILLER_3_1288 vccd vssd sg13cmos5l_decap_8
XFILLER_23_112 vccd vssd sg13cmos5l_decap_8
XFILLER_24_679 vccd vssd sg13cmos5l_decap_8
XFILLER_12_819 vccd vssd sg13cmos5l_decap_8
XFILLER_36_1555 vccd vssd sg13cmos5l_decap_8
XFILLER_23_189 vccd vssd sg13cmos5l_decap_8
XFILLER_11_329 vccd vssd sg13cmos5l_decap_8
XFILLER_32_1419 vccd vssd sg13cmos5l_decap_8
XFILLER_30_1110 vccd vssd sg13cmos5l_decap_8
XFILLER_10_2429 vccd vssd sg13cmos5l_decap_4
XFILLER_14_1820 vccd vssd sg13cmos5l_decap_8
XFILLER_20_896 vccd vssd sg13cmos5l_decap_8
XFILLER_11_56 vccd vssd sg13cmos5l_decap_8
XFILLER_14_1897 vccd vssd sg13cmos5l_decap_8
XFILLER_3_539 vccd vssd sg13cmos5l_decap_8
XFILLER_2_7 vccd vssd sg13cmos5l_decap_8
XFILLER_25_2672 vccd vssd sg13cmos5l_decap_8
XFILLER_21_2503 vccd vssd sg13cmos5l_decap_8
XFILLER_8_1155 vccd vssd sg13cmos5l_decap_8
XFILLER_4_1008 vccd vssd sg13cmos5l_decap_8
XFILLER_1_1918 vccd vssd sg13cmos5l_decap_8
XFILLER_41_1283 vccd vssd sg13cmos5l_decap_8
XFILLER_36_42 vccd vssd sg13cmos5l_decap_8
XFILLER_27_462 vccd vssd sg13cmos5l_decap_8
XFILLER_15_602 vccd vssd sg13cmos5l_decap_8
XFILLER_14_112 vccd vssd sg13cmos5l_decap_8
XFILLER_19_2476 vccd vssd sg13cmos5l_decap_8
XFILLER_15_679 vccd vssd sg13cmos5l_decap_8
XFILLER_19_1764 vccd vssd sg13cmos5l_decap_8
XFILLER_14_189 vccd vssd sg13cmos5l_decap_8
XFILLER_35_1054 vccd vssd sg13cmos5l_decap_8
XFILLER_15_1617 vccd vssd sg13cmos5l_decap_8
XFILLER_32_2665 vccd vssd sg13cmos5l_decap_8
XFILLER_32_1920 vccd vssd sg13cmos5l_decap_8
XFILLER_7_812 vccd vssd sg13cmos5l_decap_8
XFILLER_32_1975 vccd vssd sg13cmos5l_decap_8
XFILLER_6_322 vccd vssd sg13cmos5l_decap_8
XFILLER_11_896 vccd vssd sg13cmos5l_decap_8
XFILLER_13_1330 vccd vssd sg13cmos5l_decap_8
XFILLER_13_2086 vccd vssd sg13cmos5l_decap_8
XFILLER_7_889 vccd vssd sg13cmos5l_decap_8
XFILLER_6_399 vccd vssd sg13cmos5l_decap_8
XFILLER_26_2436 vccd vssd sg13cmos5l_decap_8
XFILLER_35_7 vccd vssd sg13cmos5l_decap_8
XFILLER_26_1713 vccd vssd sg13cmos5l_decap_8
X_1220_ _1223_/C status[123] wire74/X _1261_/B vccd vssd sg13cmos5l_a21oi_2
XFILLER_38_705 vccd vssd sg13cmos5l_decap_4
XFILLER_42_1047 vccd vssd sg13cmos5l_decap_8
X_1151_ _1153_/C _1777_/Q _1151_/B vccd vssd sg13cmos5l_nand2_1
XFILLER_4_2254 vccd vssd sg13cmos5l_decap_8
XFILLER_20_1323 vccd vssd sg13cmos5l_decap_8
XFILLER_19_952 vccd vssd sg13cmos5l_decap_8
XFILLER_0_2107 vccd vssd sg13cmos5l_decap_8
XFILLER_37_259 vccd vssd sg13cmos5l_decap_8
XFILLER_34_911 vccd vssd sg13cmos5l_decap_8
XFILLER_18_462 vccd vssd sg13cmos5l_decap_8
XFILLER_0_1428 vccd vssd sg13cmos5l_decap_8
XFILLER_4_1575 vccd vssd sg13cmos5l_decap_8
X_1082_ _1082_/Y _1071_/X _1069_/Y _1081_/Y vccd vssd sg13cmos5l_o21ai_1
XFILLER_37_2576 vccd vssd sg13cmos5l_decap_8
XFILLER_33_2418 vccd vssd sg13cmos5l_decap_8
XFILLER_21_616 vccd vssd sg13cmos5l_decap_8
XFILLER_37_1897 vccd vssd sg13cmos5l_decap_8
XFILLER_20_126 vccd vssd sg13cmos5l_decap_8
XFILLER_18_1274 vccd vssd sg13cmos5l_decap_8
X_0935_ _1799_/D _0935_/A vccd vssd sg13cmos5l_inv_1
XFILLER_11_2727 vccd vssd sg13cmos5l_decap_8
XFILLER_14_1127 vccd vssd sg13cmos5l_decap_8
X_0866_ _0866_/Y mask_rev_in[30] vccd vssd sg13cmos5l_inv_1
XFILLER_9_182 vccd vssd sg13cmos5l_decap_8
Xoutbuffers\[75\] control[75] _1743_/Q vccd vssd sg13cmos5l_buf_8
XFILLER_9_2121 vccd vssd sg13cmos5l_decap_8
XFILLER_44_2569 vccd vssd sg13cmos5l_decap_8
X_1418_ _1418_/Y _1394_/C _1403_/B _1417_/Y vccd vssd sg13cmos5l_o21ai_1
XFILLER_9_1442 vccd vssd sg13cmos5l_decap_8
XFILLER_9_2198 vccd vssd sg13cmos5l_decap_8
XFILLER_42_2282 vccd vssd sg13cmos5l_decap_8
XFILLER_25_1245 vccd vssd sg13cmos5l_decap_8
X_1349_ _1349_/Y _1350_/B _1349_/B _1349_/C vccd vssd sg13cmos5l_nor3_1
XFILLER_44_719 vccd vssd sg13cmos5l_decap_8
XFILLER_28_259 vccd vssd sg13cmos5l_decap_8
XFILLER_37_782 vccd vssd sg13cmos5l_decap_8
XFILLER_3_1085 vccd vssd sg13cmos5l_decap_8
XFILLER_0_2674 vccd vssd sg13cmos5l_decap_8
Xwire74 wire74/X wire74/A vccd vssd sg13cmos5l_buf_4
XFILLER_25_955 vccd vssd sg13cmos5l_decap_8
XFILLER_24_476 vccd vssd sg13cmos5l_decap_8
XFILLER_0_1995 vccd vssd sg13cmos5l_decap_8
XFILLER_12_616 vccd vssd sg13cmos5l_decap_8
XFILLER_40_947 vccd vssd sg13cmos5l_decap_8
XFILLER_36_1352 vccd vssd sg13cmos5l_decap_8
XFILLER_16_1937 vccd vssd sg13cmos5l_decap_8
XFILLER_8_609 vccd vssd sg13cmos5l_decap_8
XFILLER_11_126 vccd vssd sg13cmos5l_decap_8
XFILLER_32_1227 vccd vssd sg13cmos5l_decap_8
XFILLER_7_119 vccd vssd sg13cmos5l_decap_8
XFILLER_14_2351 vccd vssd sg13cmos5l_decap_8
XFILLER_20_693 vccd vssd sg13cmos5l_decap_8
XFILLER_10_2226 vccd vssd sg13cmos5l_decap_8
XFILLER_22_77 vccd vssd sg13cmos5l_decap_8
XFILLER_4_826 vccd vssd sg13cmos5l_decap_8
XFILLER_14_1694 vccd vssd sg13cmos5l_decap_8
XFILLER_3_336 vccd vssd sg13cmos5l_decap_8
XFILLER_10_1547 vccd vssd sg13cmos5l_decap_8
XFILLER_43_2035 vccd vssd sg13cmos5l_decap_8
XFILLER_27_2756 vccd vssd sg13cmos5l_decap_8
XFILLER_5_2541 vccd vssd sg13cmos5l_decap_8
XFILLER_43_1378 vccd vssd sg13cmos5l_decap_8
XFILLER_25_1790 vccd vssd sg13cmos5l_decap_8
XFILLER_5_1862 vccd vssd sg13cmos5l_decap_8
XFILLER_5_2574 vccd vssd sg13cmos5l_decap_8
XFILLER_21_2377 vccd vssd sg13cmos5l_decap_8
XFILLER_19_259 vccd vssd sg13cmos5l_decap_8
XFILLER_1_1715 vccd vssd sg13cmos5l_decap_8
XFILLER_21_1676 vccd vssd sg13cmos5l_decap_8
XFILLER_37_1105 vccd vssd sg13cmos5l_decap_4
XFILLER_19_2240 vccd vssd sg13cmos5l_decap_8
XFILLER_16_966 vccd vssd sg13cmos5l_decap_8
XFILLER_37_1149 vccd vssd sg13cmos5l_decap_8
XFILLER_31_936 vccd vssd sg13cmos5l_decap_8
XFILLER_30_413 vccd vssd sg13cmos5l_decap_8
XFILLER_15_476 vccd vssd sg13cmos5l_decap_8
XFILLER_34_2749 vccd vssd sg13cmos5l_decap_8
XFILLER_19_1561 vccd vssd sg13cmos5l_decap_8
XFILLER_15_2137 vccd vssd sg13cmos5l_decap_8
XFILLER_15_1414 vccd vssd sg13cmos5l_decap_8
XFILLER_32_2451 vccd vssd sg13cmos5l_decap_8
XFILLER_8_35 vccd vssd sg13cmos5l_decap_8
XFILLER_11_693 vccd vssd sg13cmos5l_decap_8
XFILLER_32_1783 vccd vssd sg13cmos5l_decap_8
XFILLER_7_686 vccd vssd sg13cmos5l_decap_8
XFILLER_28_1819 vccd vssd sg13cmos5l_decap_8
XFILLER_6_196 vccd vssd sg13cmos5l_decap_8
XFILLER_6_2338 vccd vssd sg13cmos5l_decap_8
XFILLER_38_502 vccd vssd sg13cmos5l_decap_8
X_1203_ _1206_/B _1201_/X _1200_/Y _1202_/Y vccd vssd sg13cmos5l_o21ai_1
XFILLER_4_2051 vccd vssd sg13cmos5l_decap_8
XFILLER_6_1659 vccd vssd sg13cmos5l_decap_8
X_1134_ _1134_/Y _1132_/X _1131_/Y _1133_/Y vccd vssd sg13cmos5l_o21ai_1
XFILLER_39_2605 vccd vssd sg13cmos5l_decap_8
XFILLER_20_1120 vccd vssd sg13cmos5l_decap_8
X_1626__157 _1662_/CLK _1631__159/A vccd vssd sg13cmos5l_inv_1
XFILLER_0_1225 vccd vssd sg13cmos5l_decap_8
XFILLER_4_1372 vccd vssd sg13cmos5l_decap_8
X_1065_ _1065_/Y mask_rev_in[7] _1210_/B _1306_/B vccd vssd sg13cmos5l_a21oi_1
XFILLER_22_903 vccd vssd sg13cmos5l_decap_8
XFILLER_20_1197 vccd vssd sg13cmos5l_decap_8
XFILLER_33_2204 vccd vssd sg13cmos5l_decap_8
XFILLER_21_413 vccd vssd sg13cmos5l_decap_8
XFILLER_33_273 vccd vssd sg13cmos5l_decap_8
XFILLER_33_1525 vccd vssd sg13cmos5l_decap_8
XFILLER_18_1071 vccd vssd sg13cmos5l_decap_8
XFILLER_33_1569 vccd vssd sg13cmos5l_decap_8
X_0918_ _0918_/Y _0918_/A vccd vssd sg13cmos5l_inv_1
XFILLER_15_1981 vccd vssd sg13cmos5l_decap_8
XFILLER_11_1834 vccd vssd sg13cmos5l_decap_8
X_0849_ _0849_/Y status[66] vccd vssd sg13cmos5l_inv_1
XFILLER_27_1329 vccd vssd sg13cmos5l_decap_8
XFILLER_44_2366 vccd vssd sg13cmos5l_decap_8
XFILLER_40_2208 vccd vssd sg13cmos5l_decap_8
XFILLER_44_1665 vccd vssd sg13cmos5l_decap_8
XFILLER_22_2620 vccd vssd sg13cmos5l_decap_8
XFILLER_40_1529 vccd vssd sg13cmos5l_decap_8
XFILLER_25_1064 vccd vssd sg13cmos5l_decap_8
XFILLER_22_1930 vccd vssd sg13cmos5l_decap_8
XFILLER_29_579 vccd vssd sg13cmos5l_decap_8
XFILLER_22_2697 vccd vssd sg13cmos5l_decap_8
XFILLER_2_2758 vccd vssd sg13cmos5l_decap_8
XFILLER_5_1169 vccd vssd sg13cmos5l_decap_8
XFILLER_22_1996 vccd vssd sg13cmos5l_decap_8
XFILLER_25_752 vccd vssd sg13cmos5l_decap_8
XFILLER_17_77 vccd vssd sg13cmos5l_decap_8
XFILLER_0_2471 vccd vssd sg13cmos5l_decap_8
XFILLER_40_711 vccd vssd sg13cmos5l_decap_8
XFILLER_16_2402 vccd vssd sg13cmos5l_decap_8
XFILLER_0_1792 vccd vssd sg13cmos5l_decap_8
XFILLER_13_903 vccd vssd sg13cmos5l_decap_8
XFILLER_33_21 vccd vssd sg13cmos5l_decap_8
XFILLER_24_273 vccd vssd sg13cmos5l_decap_8
XFILLER_16_1701 vccd vssd sg13cmos5l_decap_8
XFILLER_12_413 vccd vssd sg13cmos5l_decap_8
XFILLER_36_1160 vccd vssd sg13cmos5l_decap_4
XFILLER_32_1002 vccd vssd sg13cmos5l_decap_8
XFILLER_16_2479 vccd vssd sg13cmos5l_decap_8
XFILLER_8_406 vccd vssd sg13cmos5l_decap_8
XFILLER_36_1193 vccd vssd sg13cmos5l_decap_8
XFILLER_33_98 vccd vssd sg13cmos5l_decap_8
XFILLER_21_980 vccd vssd sg13cmos5l_decap_8
XFILLER_16_1778 vccd vssd sg13cmos5l_decap_8
XFILLER_20_490 vccd vssd sg13cmos5l_decap_8
XFILLER_10_2023 vccd vssd sg13cmos5l_decap_8
XFILLER_4_623 vccd vssd sg13cmos5l_decap_8
XFILLER_10_1344 vccd vssd sg13cmos5l_decap_8
XFILLER_14_1491 vccd vssd sg13cmos5l_decap_8
XFILLER_3_133 vccd vssd sg13cmos5l_decap_8
XFILLER_45_1407 vccd vssd sg13cmos5l_decap_8
XFILLER_27_2586 vccd vssd sg13cmos5l_decap_4
XFILLER_23_2417 vccd vssd sg13cmos5l_decap_8
XFILLER_0_840 vccd vssd sg13cmos5l_decap_8
XFILLER_7_2647 vccd vssd sg13cmos5l_decap_8
XFILLER_7_1946 vccd vssd sg13cmos5l_decap_8
XFILLER_40_2764 vccd vssd sg13cmos5l_decap_8
XFILLER_23_1727 vccd vssd sg13cmos5l_decap_8
XFILLER_21_1473 vccd vssd sg13cmos5l_decap_8
XFILLER_1_2268 vccd vssd sg13cmos5l_decap_8
XFILLER_1_1512 vccd vssd sg13cmos5l_decap_8
XFILLER_35_549 vccd vssd sg13cmos5l_decap_8
XFILLER_43_571 vccd vssd sg13cmos5l_decap_8
XFILLER_31_711 vccd vssd sg13cmos5l_decap_8
XFILLER_16_763 vccd vssd sg13cmos5l_decap_8
XFILLER_1_1589 vccd vssd sg13cmos5l_decap_8
XFILLER_38_2693 vccd vssd sg13cmos5l_decap_8
XFILLER_34_2546 vccd vssd sg13cmos5l_decap_8
XFILLER_30_210 vccd vssd sg13cmos5l_decap_8
XFILLER_15_273 vccd vssd sg13cmos5l_decap_8
XFILLER_15_1211 vccd vssd sg13cmos5l_decap_8
XFILLER_34_1878 vccd vssd sg13cmos5l_decap_8
XFILLER_30_287 vccd vssd sg13cmos5l_decap_8
XFILLER_12_980 vccd vssd sg13cmos5l_decap_8
X_1752_ _1752_/Q clkload6/A _1752_/D fanout119/X vccd vssd sg13cmos5l_dfrbpq_1
XFILLER_15_1288 vccd vssd sg13cmos5l_decap_8
XFILLER_8_973 vccd vssd sg13cmos5l_decap_8
XFILLER_11_490 vccd vssd sg13cmos5l_decap_8
X_1683_ _1683_/Q _1685_/CLK _1683_/D fanout139/X vccd vssd sg13cmos5l_dfrbpq_1
Xhold417 hold417/X _1782_/Q vccd vssd sg13cmos5l_dlygate4sd3_1
Xhold406 _1689_/D _1448_/X vccd vssd sg13cmos5l_dlygate4sd3_1
XFILLER_7_483 vccd vssd sg13cmos5l_decap_8
Xhold439 hold439/X _1698_/Q vccd vssd sg13cmos5l_dlygate4sd3_1
Xhold428 _1738_/D _1518_/X vccd vssd sg13cmos5l_dlygate4sd3_1
XFILLER_28_1616 vccd vssd sg13cmos5l_decap_8
XFILLER_45_2653 vccd vssd sg13cmos5l_decap_8
XFILLER_26_2052 vccd vssd sg13cmos5l_decap_8
XFILLER_45_1974 vccd vssd sg13cmos5l_decap_8
XFILLER_24_0 vccd vssd sg13cmos5l_decap_8
XFILLER_6_2135 vccd vssd sg13cmos5l_decap_8
XFILLER_41_1838 vccd vssd sg13cmos5l_decap_8
XFILLER_26_1384 vccd vssd sg13cmos5l_decap_8
XFILLER_22_1204 vccd vssd sg13cmos5l_decap_8
XFILLER_6_1456 vccd vssd sg13cmos5l_decap_8
XFILLER_38_343 vccd vssd sg13cmos5l_decap_8
Xoutbuffers\[38\] control[38] _1706_/Q vccd vssd sg13cmos5l_buf_8
XFILLER_22_1259 vccd vssd sg13cmos5l_decap_8
XFILLER_2_1309 vccd vssd sg13cmos5l_decap_8
XFILLER_39_2413 vccd vssd sg13cmos5l_decap_8
X_1117_ _1117_/Y _1698_/Q _1164_/B vccd vssd sg13cmos5l_nand2b_1
XFILLER_0_1022 vccd vssd sg13cmos5l_decap_8
XFILLER_41_519 vccd vssd sg13cmos5l_decap_4
XFILLER_39_2479 vccd vssd sg13cmos5l_decap_8
XFILLER_39_1756 vccd vssd sg13cmos5l_decap_8
X_1048_ _1048_/X _1048_/A _1074_/C vccd vssd sg13cmos5l_and2_1
XFILLER_22_700 vccd vssd sg13cmos5l_decap_8
XFILLER_0_91 vccd vssd sg13cmos5l_decap_8
XFILLER_35_1609 vccd vssd sg13cmos5l_decap_8
XFILLER_33_2023 vccd vssd sg13cmos5l_decap_8
XFILLER_21_210 vccd vssd sg13cmos5l_decap_8
XFILLER_17_2755 vccd vssd sg13cmos5l_decap_8
XFILLER_16_1008 vccd vssd sg13cmos5l_decap_8
XFILLER_0_1099 vccd vssd sg13cmos5l_decap_8
XFILLER_33_1311 vccd vssd sg13cmos5l_decap_8
XFILLER_22_777 vccd vssd sg13cmos5l_decap_8
XFILLER_10_917 vccd vssd sg13cmos5l_decap_8
XFILLER_13_2619 vccd vssd sg13cmos5l_decap_8
XFILLER_21_287 vccd vssd sg13cmos5l_decap_8
XFILLER_13_1918 vccd vssd sg13cmos5l_decap_8
XFILLER_33_1377 vccd vssd sg13cmos5l_decap_8
XFILLER_11_2354 vccd vssd sg13cmos5l_decap_8
XFILLER_11_1631 vccd vssd sg13cmos5l_decap_8
XFILLER_44_2152 vccd vssd sg13cmos5l_decap_8
XFILLER_1_637 vccd vssd sg13cmos5l_decap_8
XFILLER_27_1159 vccd vssd sg13cmos5l_decap_8
XFILLER_24_2748 vccd vssd sg13cmos5l_decap_8
XFILLER_0_147 vccd vssd sg13cmos5l_decap_8
XFILLER_44_1462 vccd vssd sg13cmos5l_decap_8
XFILLER_28_21 vccd vssd sg13cmos5l_decap_8
XFILLER_29_343 vccd vssd sg13cmos5l_decap_8
XFILLER_45_847 vccd vssd sg13cmos5l_decap_8
Xclkbuf_5_10_0_SCK clkload7/A clkbuf_5_9_0_SCK/A vccd vssd sg13cmos5l_buf_8
XFILLER_28_98 vccd vssd sg13cmos5l_decap_8
XFILLER_22_2494 vccd vssd sg13cmos5l_decap_8
XFILLER_22_1760 vccd vssd sg13cmos5l_decap_8
XFILLER_2_2555 vccd vssd sg13cmos5l_decap_8
XFILLER_44_357 vccd vssd sg13cmos5l_decap_8
XFILLER_44_346 vccd vssd sg13cmos5l_decap_8
XFILLER_2_1876 vccd vssd sg13cmos5l_decap_8
XFILLER_44_42 vccd vssd sg13cmos5l_decap_8
XFILLER_25_560 vccd vssd sg13cmos5l_decap_8
XFILLER_13_700 vccd vssd sg13cmos5l_decap_8
Xclkbuf_5_25_0_SCK _1697_/CLK clkbuf_3_6_0_SCK/X vccd vssd sg13cmos5l_buf_8
XFILLER_12_210 vccd vssd sg13cmos5l_decap_8
XFILLER_38_1299 vccd vssd sg13cmos5l_decap_8
XFILLER_8_203 vccd vssd sg13cmos5l_decap_8
XFILLER_13_777 vccd vssd sg13cmos5l_decap_8
XFILLER_16_2287 vccd vssd sg13cmos5l_decap_4
XFILLER_12_287 vccd vssd sg13cmos5l_decap_8
XFILLER_12_2107 vccd vssd sg13cmos5l_decap_8
XFILLER_16_1575 vccd vssd sg13cmos5l_decap_8
XFILLER_12_1428 vccd vssd sg13cmos5l_decap_8
Xtiedowns\[74\] status[74] vccd vssd sg13cmos5l_antennanp
XFILLER_5_910 vccd vssd sg13cmos5l_decap_8
XFILLER_29_2615 vccd vssd sg13cmos5l_decap_8
XFILLER_4_420 vccd vssd sg13cmos5l_decap_8
XFILLER_5_14 vccd vssd sg13cmos5l_decap_8
XFILLER_10_1141 vccd vssd sg13cmos5l_decap_8
XFILLER_29_1903 vccd vssd sg13cmos5l_decap_8
XFILLER_5_987 vccd vssd sg13cmos5l_decap_8
XFILLER_45_1204 vccd vssd sg13cmos5l_decap_8
XFILLER_4_497 vccd vssd sg13cmos5l_decap_8
XFILLER_7_2422 vccd vssd sg13cmos5l_decap_8
XFILLER_27_2394 vccd vssd sg13cmos5l_decap_8
XFILLER_23_2225 vccd vssd sg13cmos5l_decap_8
XFILLER_27_1671 vccd vssd sg13cmos5l_decap_8
XFILLER_7_1743 vccd vssd sg13cmos5l_decap_8
XFILLER_7_2499 vccd vssd sg13cmos5l_decap_8
XFILLER_40_2561 vccd vssd sg13cmos5l_decap_8
XFILLER_36_869 vccd vssd sg13cmos5l_decap_8
XFILLER_21_1281 vccd vssd sg13cmos5l_decap_8
XFILLER_1_2065 vccd vssd sg13cmos5l_decap_8
XFILLER_35_357 vccd vssd sg13cmos5l_decap_8
XFILLER_16_560 vccd vssd sg13cmos5l_decap_8
XFILLER_1_1386 vccd vssd sg13cmos5l_decap_8
XFILLER_38_2490 vccd vssd sg13cmos5l_decap_8
XFILLER_36_1918 vccd vssd sg13cmos5l_decap_8
XFILLER_31_585 vccd vssd sg13cmos5l_decap_8
XFILLER_30_1517 vccd vssd sg13cmos5l_decap_8
X_1804_ _1804_/Q _1804_/CLK _1804_/D _1639_/Y vccd vssd sg13cmos5l_dfrbpq_1
XFILLER_12_2652 vccd vssd sg13cmos5l_decap_8
XFILLER_34_1697 vccd vssd sg13cmos5l_decap_8
X_1735_ _1735_/Q clkload4/A _1735_/D fanout125/X vccd vssd sg13cmos5l_dfrbpq_1
XFILLER_15_1085 vccd vssd sg13cmos5l_decap_8
XFILLER_8_770 vccd vssd sg13cmos5l_decap_8
Xhold225 hold225/X _0876_/Y vccd vssd sg13cmos5l_dlygate4sd3_1
Xhold214 _1440_/A _1684_/Q vccd vssd sg13cmos5l_dlygate4sd3_1
XFILLER_7_280 vccd vssd sg13cmos5l_decap_8
Xhold203 _0826_/A SDO vccd vssd sg13cmos5l_dlygate4sd3_1
Xhold247 _1729_/D _1507_/Y vccd vssd sg13cmos5l_dlygate4sd3_1
Xhold258 _0842_/A _1710_/Q vccd vssd sg13cmos5l_dlygate4sd3_1
XFILLER_28_2136 vccd vssd sg13cmos5l_decap_4
Xhold236 hold236/X _1545_/Y vccd vssd sg13cmos5l_dlygate4sd3_1
Xhold269 _1521_/A _1740_/Q vccd vssd sg13cmos5l_dlygate4sd3_1
X_1666_ _1666_/Q _1798_/CLK _1666_/D _1630_/Y vccd vssd sg13cmos5l_dfrbpq_1
XFILLER_8_2219 vccd vssd sg13cmos5l_decap_8
XFILLER_12_1995 vccd vssd sg13cmos5l_decap_8
XFILLER_45_2450 vccd vssd sg13cmos5l_decap_8
X_1597_ _1597_/X _1542_/A hold488/X _1597_/S vccd vssd sg13cmos5l_mux2_1
XFILLER_28_2158 vccd vssd sg13cmos5l_decap_8
XFILLER_41_2314 vccd vssd sg13cmos5l_decap_8
XFILLER_45_1771 vccd vssd sg13cmos5l_decap_8
XFILLER_41_1602 vccd vssd sg13cmos5l_decap_8
XFILLER_39_652 vccd vssd sg13cmos5l_decap_8
XFILLER_26_1181 vccd vssd sg13cmos5l_decap_8
XFILLER_23_2781 vccd vssd sg13cmos5l_decap_8
XFILLER_22_1001 vccd vssd sg13cmos5l_decap_8
XFILLER_6_1253 vccd vssd sg13cmos5l_decap_8
XFILLER_38_140 vccd vssd sg13cmos5l_decap_8
XFILLER_2_1106 vccd vssd sg13cmos5l_decap_8
XFILLER_27_869 vccd vssd sg13cmos5l_decap_8
XFILLER_22_1078 vccd vssd sg13cmos5l_decap_8
XFILLER_42_828 vccd vssd sg13cmos5l_decap_8
XFILLER_41_305 vccd vssd sg13cmos5l_decap_8
XFILLER_39_2265 vccd vssd sg13cmos5l_decap_8
XFILLER_26_357 vccd vssd sg13cmos5l_decap_8
XFILLER_39_1542 vccd vssd sg13cmos5l_decap_8
XFILLER_35_891 vccd vssd sg13cmos5l_decap_8
XFILLER_35_1417 vccd vssd sg13cmos5l_decap_8
XFILLER_13_2405 vccd vssd sg13cmos5l_decap_8
XFILLER_22_574 vccd vssd sg13cmos5l_decap_8
XFILLER_10_714 vccd vssd sg13cmos5l_decap_8
XFILLER_14_56 vccd vssd sg13cmos5l_decap_8
XFILLER_6_707 vccd vssd sg13cmos5l_decap_8
XFILLER_13_1715 vccd vssd sg13cmos5l_decap_8
XFILLER_30_2785 vccd vssd sg13cmos5l_decap_4
XFILLER_5_217 vccd vssd sg13cmos5l_decap_8
XFILLER_30_77 vccd vssd sg13cmos5l_decap_8
XFILLER_2_924 vccd vssd sg13cmos5l_decap_8
XFILLER_1_434 vccd vssd sg13cmos5l_decap_8
XFILLER_39_42 vccd vssd sg13cmos5l_decap_8
XFILLER_28_1980 vccd vssd sg13cmos5l_decap_8
XFILLER_24_2545 vccd vssd sg13cmos5l_decap_8
XFILLER_4_2639 vccd vssd sg13cmos5l_decap_8
XFILLER_8_2786 vccd vssd sg13cmos5l_decap_4
XFILLER_40_1101 vccd vssd sg13cmos5l_decap_8
XFILLER_24_1833 vccd vssd sg13cmos5l_decap_8
XFILLER_29_140 vccd vssd sg13cmos5l_decap_8
XFILLER_24_1899 vccd vssd sg13cmos5l_decap_8
XFILLER_2_2352 vccd vssd sg13cmos5l_decap_8
XFILLER_45_644 vccd vssd sg13cmos5l_decap_8
XFILLER_40_1167 vccd vssd sg13cmos5l_decap_8
XFILLER_18_847 vccd vssd sg13cmos5l_decap_8
XFILLER_44_154 vccd vssd sg13cmos5l_decap_8
XFILLER_17_357 vccd vssd sg13cmos5l_decap_8
XFILLER_2_1673 vccd vssd sg13cmos5l_decap_8
XFILLER_35_2630 vccd vssd sg13cmos5l_decap_8
XFILLER_18_2338 vccd vssd sg13cmos5l_decap_8
XFILLER_41_894 vccd vssd sg13cmos5l_decap_8
XFILLER_18_1659 vccd vssd sg13cmos5l_decap_8
XFILLER_13_574 vccd vssd sg13cmos5l_decap_8
XFILLER_31_2549 vccd vssd sg13cmos5l_decap_8
XFILLER_31_1804 vccd vssd sg13cmos5l_decap_8
XFILLER_16_2084 vccd vssd sg13cmos5l_decap_8
XFILLER_16_1372 vccd vssd sg13cmos5l_decap_8
XFILLER_9_567 vccd vssd sg13cmos5l_decap_8
XFILLER_12_1225 vccd vssd sg13cmos5l_decap_8
XFILLER_29_2412 vccd vssd sg13cmos5l_decap_8
X_1520_ _1530_/S _1520_/A _1520_/B vccd vssd sg13cmos5l_nand2_1
XFILLER_5_784 vccd vssd sg13cmos5l_decap_8
XFILLER_9_2506 vccd vssd sg13cmos5l_decap_8
XFILLER_45_1001 vccd vssd sg13cmos5l_decap_8
X_1451_ _1451_/Y _1472_/A _1451_/B vccd vssd sg13cmos5l_nor2_1
XFILLER_29_2489 vccd vssd sg13cmos5l_decap_8
XFILLER_29_1733 vccd vssd sg13cmos5l_decap_8
XFILLER_4_294 vccd vssd sg13cmos5l_decap_8
X_1382_ _1382_/Y _1382_/A _1382_/B _1382_/C vccd vssd sg13cmos5l_nand3_1
XFILLER_9_1827 vccd vssd sg13cmos5l_decap_8
XFILLER_45_1078 vccd vssd sg13cmos5l_decap_8
XFILLER_42_2678 vccd vssd sg13cmos5l_decap_8
XFILLER_27_1490 vccd vssd sg13cmos5l_decap_8
XFILLER_23_1321 vccd vssd sg13cmos5l_decap_8
XFILLER_3_2149 vccd vssd sg13cmos5l_decap_8
XFILLER_7_1540 vccd vssd sg13cmos5l_decap_8
XFILLER_7_2296 vccd vssd sg13cmos5l_decap_8
Xtiedowns\[118\] status[118] vccd vssd sg13cmos5l_antennanp
XFILLER_40_2380 vccd vssd sg13cmos5l_decap_8
XFILLER_36_600 vccd vssd sg13cmos5l_decap_8
XFILLER_23_2099 vccd vssd sg13cmos5l_decap_8
XFILLER_40_1690 vccd vssd sg13cmos5l_decap_8
XFILLER_36_2405 vccd vssd sg13cmos5l_decap_8
XFILLER_36_677 vccd vssd sg13cmos5l_decap_4
XFILLER_35_154 vccd vssd sg13cmos5l_decap_8
XFILLER_36_2449 vccd vssd sg13cmos5l_decap_8
XFILLER_1_1183 vccd vssd sg13cmos5l_decap_8
XFILLER_31_371 vccd vssd sg13cmos5l_decap_8
Xoutbuffers\[1\] control[1] _1669_/Q vccd vssd sg13cmos5l_buf_8
XFILLER_34_2184 vccd vssd sg13cmos5l_decap_8
XFILLER_30_2015 vccd vssd sg13cmos5l_decap_4
XFILLER_17_1169 vccd vssd sg13cmos5l_decap_8
XFILLER_30_1325 vccd vssd sg13cmos5l_decap_8
X_1718_ _1718_/Q clkload0/A _1718_/D fanout127/X vccd vssd sg13cmos5l_dfrbpq_1
XFILLER_12_1792 vccd vssd sg13cmos5l_decap_8
X_1649_ _1649_/Q _1675_/CLK _1649_/D _1614_/Y vccd vssd sg13cmos5l_dfrbpq_1
XFILLER_8_2016 vccd vssd sg13cmos5l_decap_8
XFILLER_28_1232 vccd vssd sg13cmos5l_decap_8
XFILLER_41_2111 vccd vssd sg13cmos5l_decap_8
XFILLER_8_1337 vccd vssd sg13cmos5l_decap_8
XFILLER_41_2188 vccd vssd sg13cmos5l_decap_8
XFILLER_6_1050 vccd vssd sg13cmos5l_decap_8
XFILLER_3_1960 vccd vssd sg13cmos5l_decap_8
XFILLER_26_154 vccd vssd sg13cmos5l_decap_8
XFILLER_42_625 vccd vssd sg13cmos5l_decap_8
XFILLER_19_2636 vccd vssd sg13cmos5l_decap_8
XFILLER_19_1902 vccd vssd sg13cmos5l_decap_8
XFILLER_25_77 vccd vssd sg13cmos5l_decap_8
XFILLER_23_861 vccd vssd sg13cmos5l_decap_8
XFILLER_41_168 vccd vssd sg13cmos5l_decap_8
XFILLER_35_1225 vccd vssd sg13cmos5l_decap_8
XFILLER_22_371 vccd vssd sg13cmos5l_decap_8
XFILLER_19_1979 vccd vssd sg13cmos5l_decap_8
XFILLER_17_2371 vccd vssd sg13cmos5l_decap_8
XFILLER_10_511 vccd vssd sg13cmos5l_decap_8
XFILLER_13_2202 vccd vssd sg13cmos5l_decap_8
XFILLER_41_21 vccd vssd sg13cmos5l_decap_8
XFILLER_35_1269 vccd vssd sg13cmos5l_decap_4
XFILLER_6_504 vccd vssd sg13cmos5l_decap_8
XFILLER_13_1512 vccd vssd sg13cmos5l_decap_8
XFILLER_41_98 vccd vssd sg13cmos5l_decap_8
XFILLER_30_2582 vccd vssd sg13cmos5l_decap_8
Xrebuffer163 _0970_/B _0971_/A vccd vssd sg13cmos5l_buf_1
XFILLER_10_588 vccd vssd sg13cmos5l_decap_8
XFILLER_13_1589 vccd vssd sg13cmos5l_decap_8
XFILLER_29_1007 vccd vssd sg13cmos5l_decap_8
XFILLER_26_2607 vccd vssd sg13cmos5l_decap_8
XFILLER_2_721 vccd vssd sg13cmos5l_decap_8
XFILLER_1_231 vccd vssd sg13cmos5l_decap_8
XFILLER_42_1207 vccd vssd sg13cmos5l_decap_8
XFILLER_2_798 vccd vssd sg13cmos5l_decap_8
XFILLER_8_2583 vccd vssd sg13cmos5l_decap_8
Xtiedowns\[37\] status[37] vccd vssd sg13cmos5l_antennanp
XFILLER_4_2436 vccd vssd sg13cmos5l_decap_8
XFILLER_24_1652 vccd vssd sg13cmos5l_decap_8
XFILLER_18_644 vccd vssd sg13cmos5l_decap_8
XFILLER_4_1757 vccd vssd sg13cmos5l_decap_8
XFILLER_45_441 vccd vssd sg13cmos5l_decap_8
XFILLER_20_1549 vccd vssd sg13cmos5l_decap_8
XFILLER_17_154 vccd vssd sg13cmos5l_decap_8
XFILLER_18_2102 vccd vssd sg13cmos5l_decap_8
XFILLER_2_1470 vccd vssd sg13cmos5l_decap_8
XFILLER_37_2758 vccd vssd sg13cmos5l_decap_8
XFILLER_33_669 vccd vssd sg13cmos5l_decap_8
XFILLER_35_2471 vccd vssd sg13cmos5l_decap_8
XFILLER_32_168 vccd vssd sg13cmos5l_decap_8
X_0951_ _1008_/A _0970_/B _0952_/B _1042_/A vccd vssd sg13cmos5l_and3_1
XFILLER_20_308 vccd vssd sg13cmos5l_decap_8
XFILLER_18_2179 vccd vssd sg13cmos5l_decap_8
XFILLER_18_1456 vccd vssd sg13cmos5l_decap_8
XFILLER_14_861 vccd vssd sg13cmos5l_decap_8
XFILLER_41_691 vccd vssd sg13cmos5l_decap_8
XFILLER_31_2313 vccd vssd sg13cmos5l_decap_8
XFILLER_13_371 vccd vssd sg13cmos5l_decap_8
XFILLER_14_1309 vccd vssd sg13cmos5l_decap_8
XFILLER_31_2368 vccd vssd sg13cmos5l_decap_8
XFILLER_31_1612 vccd vssd sg13cmos5l_decap_8
X_0882_ _0883_/B _0898_/C _1406_/A vccd vssd sg13cmos5l_nand2_1
XFILLER_9_364 vccd vssd sg13cmos5l_decap_8
XFILLER_12_1022 vccd vssd sg13cmos5l_decap_8
X_1503_ _1503_/X _1445_/A hold322/X _1508_/S vccd vssd sg13cmos5l_mux2_1
XFILLER_5_581 vccd vssd sg13cmos5l_decap_8
XFILLER_9_2303 vccd vssd sg13cmos5l_decap_8
XFILLER_12_1099 vccd vssd sg13cmos5l_decap_8
XFILLER_9_1624 vccd vssd sg13cmos5l_decap_8
X_1434_ _1434_/X _1445_/A hold318/X _1437_/S vccd vssd sg13cmos5l_mux2_1
X_1365_ _1369_/A status[16] _1011_/X _1364_/Y vccd vssd sg13cmos5l_o21ai_1
XFILLER_29_1596 vccd vssd sg13cmos5l_decap_8
XFILLER_42_1741 vccd vssd sg13cmos5l_decap_8
XFILLER_7_2093 vccd vssd sg13cmos5l_decap_8
X_1296_ _1296_/Y _1678_/Q _1052_/Y _1055_/Y vccd vssd sg13cmos5l_a21oi_1
XFILLER_23_1162 vccd vssd sg13cmos5l_decap_8
XFILLER_20_2751 vccd vssd sg13cmos5l_decap_8
Xoutbuffers\[20\] control[20] _1688_/Q vccd vssd sg13cmos5l_buf_8
XFILLER_37_964 vccd vssd sg13cmos5l_decap_8
XFILLER_36_441 vccd vssd sg13cmos5l_decap_8
XFILLER_3_1267 vccd vssd sg13cmos5l_decap_8
XFILLER_37_997 vccd vssd sg13cmos5l_decap_8
XFILLER_36_2202 vccd vssd sg13cmos5l_decap_8
XFILLER_36_2235 vccd vssd sg13cmos5l_decap_8
XFILLER_24_658 vccd vssd sg13cmos5l_decap_8
XFILLER_36_1534 vccd vssd sg13cmos5l_decap_8
XFILLER_23_168 vccd vssd sg13cmos5l_decap_8
XFILLER_18_2680 vccd vssd sg13cmos5l_decap_8
XFILLER_11_308 vccd vssd sg13cmos5l_decap_8
XFILLER_14_2533 vccd vssd sg13cmos5l_decap_8
XFILLER_20_875 vccd vssd sg13cmos5l_decap_8
XFILLER_10_2408 vccd vssd sg13cmos5l_decap_8
XFILLER_14_2588 vccd vssd sg13cmos5l_decap_8
XFILLER_14_1876 vccd vssd sg13cmos5l_decap_8
XFILLER_3_518 vccd vssd sg13cmos5l_decap_8
XFILLER_10_1729 vccd vssd sg13cmos5l_decap_8
XFILLER_11_35 vccd vssd sg13cmos5l_decap_8
XFILLER_25_2651 vccd vssd sg13cmos5l_decap_8
XFILLER_8_1134 vccd vssd sg13cmos5l_decap_8
XFILLER_25_1961 vccd vssd sg13cmos5l_decap_8
XFILLER_21_1803 vccd vssd sg13cmos5l_decap_8
XFILLER_41_1262 vccd vssd sg13cmos5l_decap_8
XFILLER_36_21 vccd vssd sg13cmos5l_decap_8
XFILLER_28_942 vccd vssd sg13cmos5l_decap_8
XFILLER_21_2559 vccd vssd sg13cmos5l_decap_8
XFILLER_27_441 vccd vssd sg13cmos5l_decap_8
XFILLER_21_1869 vccd vssd sg13cmos5l_decap_8
XFILLER_42_411 vccd vssd sg13cmos5l_decap_8
XFILLER_42_444 vccd vssd sg13cmos5l_decap_8
XFILLER_36_98 vccd vssd sg13cmos5l_decap_8
XFILLER_19_2455 vccd vssd sg13cmos5l_decap_8
XFILLER_15_658 vccd vssd sg13cmos5l_decap_8
XFILLER_39_1180 vccd vssd sg13cmos5l_decap_8
XFILLER_19_1743 vccd vssd sg13cmos5l_decap_8
XFILLER_14_168 vccd vssd sg13cmos5l_decap_8
XFILLER_35_1033 vccd vssd sg13cmos5l_decap_8
XFILLER_32_2644 vccd vssd sg13cmos5l_decap_8
XFILLER_17_2190 vccd vssd sg13cmos5l_decap_8
XFILLER_6_301 vccd vssd sg13cmos5l_decap_8
XFILLER_11_875 vccd vssd sg13cmos5l_decap_8
XFILLER_13_2065 vccd vssd sg13cmos5l_decap_8
XFILLER_32_1954 vccd vssd sg13cmos5l_decap_8
XFILLER_7_868 vccd vssd sg13cmos5l_decap_8
XFILLER_10_385 vccd vssd sg13cmos5l_decap_8
XFILLER_30_2390 vccd vssd sg13cmos5l_decap_8
XFILLER_6_378 vccd vssd sg13cmos5l_decap_8
XFILLER_13_1386 vccd vssd sg13cmos5l_decap_8
XFILLER_26_2415 vccd vssd sg13cmos5l_decap_8
XFILLER_42_1026 vccd vssd sg13cmos5l_decap_8
XFILLER_28_7 vccd vssd sg13cmos5l_decap_8
XFILLER_2_595 vccd vssd sg13cmos5l_decap_8
XFILLER_8_2380 vccd vssd sg13cmos5l_decap_8
XFILLER_43_2784 vccd vssd sg13cmos5l_decap_8
X_1150_ _1153_/A _1785_/Q _1279_/B vccd vssd sg13cmos5l_nand2_1
XFILLER_24_2183 vccd vssd sg13cmos5l_decap_4
XFILLER_4_2233 vccd vssd sg13cmos5l_decap_8
XFILLER_38_739 vccd vssd sg13cmos5l_decap_8
XFILLER_37_238 vccd vssd sg13cmos5l_decap_8
XFILLER_20_1302 vccd vssd sg13cmos5l_decap_8
XFILLER_19_931 vccd vssd sg13cmos5l_decap_8
XFILLER_4_1554 vccd vssd sg13cmos5l_decap_8
XFILLER_20_2069 vccd vssd sg13cmos5l_decap_8
XFILLER_18_441 vccd vssd sg13cmos5l_decap_8
XFILLER_0_1407 vccd vssd sg13cmos5l_decap_8
X_1081_ _1081_/Y _1390_/B _1258_/B _1081_/C vccd vssd sg13cmos5l_nor3_1
XFILLER_20_1379 vccd vssd sg13cmos5l_decap_8
XFILLER_37_2555 vccd vssd sg13cmos5l_decap_8
Xoutbuffers\[110\] control[110] _1778_/Q vccd vssd sg13cmos5l_buf_8
XFILLER_20_105 vccd vssd sg13cmos5l_decap_8
XFILLER_37_1876 vccd vssd sg13cmos5l_decap_8
XFILLER_31_2121 vccd vssd sg13cmos5l_decap_8
XFILLER_18_1253 vccd vssd sg13cmos5l_decap_8
XFILLER_14_1106 vccd vssd sg13cmos5l_decap_8
X_0934_ _0934_/Y _0928_/A _0926_/B hold383/X _0936_/B vccd vssd sg13cmos5l_a22oi_1
XFILLER_9_161 vccd vssd sg13cmos5l_decap_8
X_0865_ _0865_/Y status[109] vccd vssd sg13cmos5l_inv_1
XFILLER_31_1442 vccd vssd sg13cmos5l_decap_8
XFILLER_9_2100 vccd vssd sg13cmos5l_decap_8
XFILLER_44_2548 vccd vssd sg13cmos5l_decap_8
XFILLER_44_1814 vccd vssd sg13cmos5l_decap_8
Xoutbuffers\[68\] control[68] _1736_/Q vccd vssd sg13cmos5l_buf_8
XFILLER_9_1421 vccd vssd sg13cmos5l_decap_8
XFILLER_9_2177 vccd vssd sg13cmos5l_decap_8
XFILLER_25_1224 vccd vssd sg13cmos5l_decap_8
X_1417_ _1417_/Y _1403_/B _0902_/A _1394_/B vccd vssd sg13cmos5l_o21ai_1
XFILLER_3_91 vccd vssd sg13cmos5l_decap_8
XFILLER_9_1498 vccd vssd sg13cmos5l_decap_8
XFILLER_28_238 vccd vssd sg13cmos5l_decap_8
X_1348_ _1349_/C mask_rev_in[17] _1348_/B vccd vssd sg13cmos5l_nor2_1
XFILLER_42_1582 vccd vssd sg13cmos5l_decap_8
XFILLER_37_761 vccd vssd sg13cmos5l_decap_8
X_1279_ _1279_/Y _1782_/Q _1279_/B vccd vssd sg13cmos5l_nand2b_1
XFILLER_25_934 vccd vssd sg13cmos5l_decap_8
XFILLER_3_1064 vccd vssd sg13cmos5l_decap_8
XFILLER_0_2653 vccd vssd sg13cmos5l_decap_8
XFILLER_38_1629 vccd vssd sg13cmos5l_decap_8
XFILLER_0_1974 vccd vssd sg13cmos5l_decap_8
XFILLER_40_926 vccd vssd sg13cmos5l_decap_8
XFILLER_24_455 vccd vssd sg13cmos5l_decap_8
XFILLER_11_105 vccd vssd sg13cmos5l_decap_8
XFILLER_36_2098 vccd vssd sg13cmos5l_decap_8
XFILLER_36_2087 vccd vssd sg13cmos5l_decap_8
XFILLER_36_1331 vccd vssd sg13cmos5l_decap_8
XFILLER_16_1916 vccd vssd sg13cmos5l_decap_8
XFILLER_32_1206 vccd vssd sg13cmos5l_decap_8
XFILLER_22_56 vccd vssd sg13cmos5l_decap_8
XFILLER_20_672 vccd vssd sg13cmos5l_decap_8
XFILLER_10_2205 vccd vssd sg13cmos5l_decap_8
XFILLER_4_805 vccd vssd sg13cmos5l_decap_8
XFILLER_10_1526 vccd vssd sg13cmos5l_decap_8
XFILLER_14_1673 vccd vssd sg13cmos5l_decap_8
Xclkbuf_3_7_0_SCK clkbuf_3_7_0_SCK/X clkbuf_0_SCK/X vccd vssd sg13cmos5l_buf_8
XFILLER_3_315 vccd vssd sg13cmos5l_decap_8
XFILLER_27_2735 vccd vssd sg13cmos5l_decap_8
XFILLER_43_2069 vccd vssd sg13cmos5l_decap_8
XFILLER_5_2520 vccd vssd sg13cmos5l_decap_8
Xfanout140 fanout140/X fanout143/X vccd vssd sg13cmos5l_buf_1
XFILLER_21_2356 vccd vssd sg13cmos5l_decap_8
XFILLER_19_238 vccd vssd sg13cmos5l_decap_8
XFILLER_5_1841 vccd vssd sg13cmos5l_decap_8
XFILLER_35_709 vccd vssd sg13cmos5l_decap_8
XFILLER_21_1655 vccd vssd sg13cmos5l_decap_8
XFILLER_41_1092 vccd vssd sg13cmos5l_decap_8
XFILLER_16_945 vccd vssd sg13cmos5l_decap_8
XFILLER_37_1128 vccd vssd sg13cmos5l_decap_8
XFILLER_34_2728 vccd vssd sg13cmos5l_decap_8
XFILLER_31_915 vccd vssd sg13cmos5l_decap_8
XFILLER_19_1540 vccd vssd sg13cmos5l_decap_8
XFILLER_15_455 vccd vssd sg13cmos5l_decap_8
XFILLER_43_797 vccd vssd sg13cmos5l_decap_4
XFILLER_8_14 vccd vssd sg13cmos5l_decap_8
XFILLER_32_2430 vccd vssd sg13cmos5l_decap_8
XFILLER_11_672 vccd vssd sg13cmos5l_decap_8
XFILLER_32_1762 vccd vssd sg13cmos5l_decap_8
XFILLER_7_665 vccd vssd sg13cmos5l_decap_8
XFILLER_10_182 vccd vssd sg13cmos5l_decap_8
XFILLER_6_175 vccd vssd sg13cmos5l_decap_8
XFILLER_13_1183 vccd vssd sg13cmos5l_decap_8
XFILLER_26_2234 vccd vssd sg13cmos5l_decap_8
XFILLER_3_882 vccd vssd sg13cmos5l_decap_8
XFILLER_2_392 vccd vssd sg13cmos5l_decap_8
XFILLER_6_2317 vccd vssd sg13cmos5l_decap_8
X_1202_ _1202_/Y _0857_/Y _1114_/B _1162_/B vccd vssd sg13cmos5l_a21oi_1
XFILLER_22_1408 vccd vssd sg13cmos5l_decap_8
XFILLER_4_2030 vccd vssd sg13cmos5l_decap_8
XFILLER_6_1638 vccd vssd sg13cmos5l_decap_8
XFILLER_26_1599 vccd vssd sg13cmos5l_decap_8
X_1133_ _1133_/Y status[101] _1357_/A2 _1357_/C1 vccd vssd sg13cmos5l_a21oi_1
XFILLER_38_558 vccd vssd sg13cmos5l_decap_4
XFILLER_4_1351 vccd vssd sg13cmos5l_decap_8
Xtiedowns\[100\] status[100] vccd vssd sg13cmos5l_antennanp
XFILLER_0_1204 vccd vssd sg13cmos5l_decap_8
X_1064_ _1064_/Y _1064_/A _1074_/C vccd vssd sg13cmos5l_nand2_1
XFILLER_20_1176 vccd vssd sg13cmos5l_decap_8
XFILLER_33_252 vccd vssd sg13cmos5l_decap_8
XFILLER_22_959 vccd vssd sg13cmos5l_decap_8
XFILLER_33_1504 vccd vssd sg13cmos5l_decap_8
XFILLER_21_469 vccd vssd sg13cmos5l_decap_8
XFILLER_18_1050 vccd vssd sg13cmos5l_decap_8
X_0917_ _0917_/Y _0970_/A _0914_/A _0916_/Y _0936_/B vccd vssd sg13cmos5l_a22oi_1
XFILLER_15_2683 vccd vssd sg13cmos5l_decap_8
XFILLER_15_1960 vccd vssd sg13cmos5l_decap_8
XFILLER_31_1250 vccd vssd sg13cmos5l_decap_8
XFILLER_11_1813 vccd vssd sg13cmos5l_decap_8
X_0848_ _0848_/Y status[50] vccd vssd sg13cmos5l_inv_1
XFILLER_27_2009 vccd vssd sg13cmos5l_decap_8
XFILLER_44_2334 vccd vssd sg13cmos5l_decap_8
XFILLER_27_1308 vccd vssd sg13cmos5l_decap_8
XFILLER_1_819 vccd vssd sg13cmos5l_decap_8
XFILLER_44_2345 vccd vssd sg13cmos5l_decap_8
XFILLER_0_329 vccd vssd sg13cmos5l_decap_8
XFILLER_44_1644 vccd vssd sg13cmos5l_decap_8
XFILLER_42_2091 vccd vssd sg13cmos5l_decap_8
XFILLER_40_1508 vccd vssd sg13cmos5l_decap_8
XFILLER_2_2737 vccd vssd sg13cmos5l_decap_8
XFILLER_5_1148 vccd vssd sg13cmos5l_decap_8
XFILLER_9_1295 vccd vssd sg13cmos5l_decap_8
XFILLER_29_558 vccd vssd sg13cmos5l_decap_8
XFILLER_22_2676 vccd vssd sg13cmos5l_decap_8
XFILLER_17_56 vccd vssd sg13cmos5l_decap_8
XFILLER_0_2450 vccd vssd sg13cmos5l_decap_8
XFILLER_25_731 vccd vssd sg13cmos5l_decap_8
XFILLER_38_1448 vccd vssd sg13cmos5l_decap_8
XFILLER_24_252 vccd vssd sg13cmos5l_decap_8
XFILLER_0_1771 vccd vssd sg13cmos5l_decap_8
XFILLER_13_959 vccd vssd sg13cmos5l_decap_8
XFILLER_36_1172 vccd vssd sg13cmos5l_decap_8
XFILLER_33_77 vccd vssd sg13cmos5l_decap_8
XFILLER_16_2458 vccd vssd sg13cmos5l_decap_8
XFILLER_12_469 vccd vssd sg13cmos5l_decap_8
XFILLER_33_2783 vccd vssd sg13cmos5l_decap_8
XFILLER_16_1757 vccd vssd sg13cmos5l_decap_8
XFILLER_10_2002 vccd vssd sg13cmos5l_decap_8
XFILLER_14_1470 vccd vssd sg13cmos5l_decap_8
XFILLER_4_602 vccd vssd sg13cmos5l_decap_8
XFILLER_10_1323 vccd vssd sg13cmos5l_decap_8
XFILLER_10_2079 vccd vssd sg13cmos5l_decap_8
XFILLER_3_112 vccd vssd sg13cmos5l_decap_8
XFILLER_4_679 vccd vssd sg13cmos5l_decap_8
XFILLER_27_2565 vccd vssd sg13cmos5l_decap_8
XFILLER_3_189 vccd vssd sg13cmos5l_decap_8
XFILLER_23_1706 vccd vssd sg13cmos5l_decap_8
XFILLER_7_1925 vccd vssd sg13cmos5l_decap_8
XFILLER_40_2743 vccd vssd sg13cmos5l_decap_8
XFILLER_27_1897 vccd vssd sg13cmos5l_decap_8
XFILLER_0_896 vccd vssd sg13cmos5l_decap_8
XFILLER_5_2394 vccd vssd sg13cmos5l_decap_8
XFILLER_35_528 vccd vssd sg13cmos5l_decap_8
XFILLER_21_2197 vccd vssd sg13cmos5l_decap_8
XFILLER_21_1452 vccd vssd sg13cmos5l_decap_8
XFILLER_1_2247 vccd vssd sg13cmos5l_decap_8
XFILLER_28_591 vccd vssd sg13cmos5l_decap_8
XFILLER_16_742 vccd vssd sg13cmos5l_decap_8
XFILLER_1_1568 vccd vssd sg13cmos5l_decap_8
XFILLER_38_2672 vccd vssd sg13cmos5l_decap_8
XFILLER_15_252 vccd vssd sg13cmos5l_decap_8
XFILLER_19_2093 vccd vssd sg13cmos5l_decap_4
XFILLER_38_1993 vccd vssd sg13cmos5l_decap_8
XFILLER_34_1813 vccd vssd sg13cmos5l_decap_8
XFILLER_31_767 vccd vssd sg13cmos5l_decap_8
XFILLER_34_1857 vccd vssd sg13cmos5l_decap_8
XFILLER_30_266 vccd vssd sg13cmos5l_decap_8
X_1751_ _1751_/Q clkload4/A _1751_/D fanout121/X vccd vssd sg13cmos5l_dfrbpq_1
XFILLER_32_2282 vccd vssd sg13cmos5l_decap_4
XFILLER_15_1267 vccd vssd sg13cmos5l_decap_8
XFILLER_8_952 vccd vssd sg13cmos5l_decap_8
X_1682_ _1682_/Q _1682_/CLK _1682_/D fanout137/X vccd vssd sg13cmos5l_dfrbpq_1
Xhold418 _1782_/D _1582_/X vccd vssd sg13cmos5l_dlygate4sd3_1
Xhold407 hold407/X _1771_/Q vccd vssd sg13cmos5l_dlygate4sd3_1
XFILLER_7_462 vccd vssd sg13cmos5l_decap_8
XFILLER_28_2329 vccd vssd sg13cmos5l_decap_8
Xhold429 hold429/X _1713_/Q vccd vssd sg13cmos5l_dlygate4sd3_1
XFILLER_45_2632 vccd vssd sg13cmos5l_decap_8
XFILLER_10_1890 vccd vssd sg13cmos5l_decap_8
XFILLER_26_2031 vccd vssd sg13cmos5l_decap_8
XFILLER_6_2114 vccd vssd sg13cmos5l_decap_8
XFILLER_45_1953 vccd vssd sg13cmos5l_decap_8
XFILLER_39_812 vccd vssd sg13cmos5l_decap_8
XFILLER_41_1817 vccd vssd sg13cmos5l_decap_8
XFILLER_38_322 vccd vssd sg13cmos5l_decap_8
XFILLER_26_1363 vccd vssd sg13cmos5l_decap_8
XFILLER_6_1435 vccd vssd sg13cmos5l_decap_8
XFILLER_17_0 vccd vssd sg13cmos5l_decap_8
X_1116_ _1116_/X _1706_/Q _1463_/B _1164_/B vccd vssd sg13cmos5l_a21o_1
XFILLER_0_1001 vccd vssd sg13cmos5l_decap_8
XFILLER_39_2458 vccd vssd sg13cmos5l_decap_8
XFILLER_38_399 vccd vssd sg13cmos5l_decap_8
XFILLER_26_539 vccd vssd sg13cmos5l_decap_8
XFILLER_0_70 vccd vssd sg13cmos5l_decap_8
X_1047_ _1047_/Y _1723_/Q _1337_/B _1474_/B _1715_/Q _1162_/B vccd vssd sg13cmos5l_a221oi_1
XFILLER_0_1078 vccd vssd sg13cmos5l_decap_8
XFILLER_33_2002 vccd vssd sg13cmos5l_decap_8
XFILLER_17_2734 vccd vssd sg13cmos5l_decap_8
XFILLER_22_756 vccd vssd sg13cmos5l_decap_8
Xtiedowns\[3\] status[3] vccd vssd sg13cmos5l_antennanp
XFILLER_37_1492 vccd vssd sg13cmos5l_decap_8
XFILLER_33_2079 vccd vssd sg13cmos5l_decap_8
XFILLER_21_266 vccd vssd sg13cmos5l_decap_8
XFILLER_33_1356 vccd vssd sg13cmos5l_decap_8
XFILLER_11_2333 vccd vssd sg13cmos5l_decap_8
XFILLER_11_1610 vccd vssd sg13cmos5l_decap_8
XFILLER_1_616 vccd vssd sg13cmos5l_decap_8
XFILLER_11_1687 vccd vssd sg13cmos5l_decap_8
XFILLER_44_2131 vccd vssd sg13cmos5l_decap_8
XFILLER_0_126 vccd vssd sg13cmos5l_decap_8
XFILLER_44_1441 vccd vssd sg13cmos5l_decap_8
XFILLER_27_1138 vccd vssd sg13cmos5l_decap_8
XFILLER_24_2727 vccd vssd sg13cmos5l_decap_8
XFILLER_40_2039 vccd vssd sg13cmos5l_decap_8
XFILLER_40_1305 vccd vssd sg13cmos5l_decap_8
XFILLER_9_1092 vccd vssd sg13cmos5l_decap_8
XFILLER_29_322 vccd vssd sg13cmos5l_decap_8
XFILLER_22_2473 vccd vssd sg13cmos5l_decap_8
XFILLER_2_2534 vccd vssd sg13cmos5l_decap_8
XFILLER_6_2692 vccd vssd sg13cmos5l_decap_8
XFILLER_45_826 vccd vssd sg13cmos5l_decap_8
XFILLER_28_77 vccd vssd sg13cmos5l_decap_8
XFILLER_44_336 vccd vssd sg13cmos5l_decap_8
XFILLER_29_399 vccd vssd sg13cmos5l_decap_8
XFILLER_17_539 vccd vssd sg13cmos5l_decap_8
XFILLER_2_1855 vccd vssd sg13cmos5l_decap_8
XFILLER_44_21 vccd vssd sg13cmos5l_decap_8
XFILLER_38_1212 vccd vssd sg13cmos5l_decap_8
XFILLER_44_98 vccd vssd sg13cmos5l_decap_8
XFILLER_40_553 vccd vssd sg13cmos5l_decap_8
XFILLER_38_1278 vccd vssd sg13cmos5l_decap_8
XFILLER_16_2266 vccd vssd sg13cmos5l_decap_8
XFILLER_13_756 vccd vssd sg13cmos5l_decap_8
XFILLER_16_1554 vccd vssd sg13cmos5l_decap_8
XFILLER_9_749 vccd vssd sg13cmos5l_decap_8
XFILLER_12_266 vccd vssd sg13cmos5l_decap_8
XFILLER_33_2580 vccd vssd sg13cmos5l_decap_8
XFILLER_8_259 vccd vssd sg13cmos5l_decap_8
XFILLER_12_1407 vccd vssd sg13cmos5l_decap_8
Xtiedowns\[67\] status[67] vccd vssd sg13cmos5l_antennanp
XFILLER_5_966 vccd vssd sg13cmos5l_decap_8
XFILLER_10_1120 vccd vssd sg13cmos5l_decap_8
XFILLER_4_476 vccd vssd sg13cmos5l_decap_8
XFILLER_7_2401 vccd vssd sg13cmos5l_decap_8
XFILLER_10_1197 vccd vssd sg13cmos5l_decap_8
XFILLER_27_1650 vccd vssd sg13cmos5l_decap_8
XFILLER_7_1722 vccd vssd sg13cmos5l_decap_8
XFILLER_39_119 vccd vssd sg13cmos5l_decap_8
XFILLER_7_2478 vccd vssd sg13cmos5l_decap_8
XFILLER_40_2540 vccd vssd sg13cmos5l_decap_8
XFILLER_23_1525 vccd vssd sg13cmos5l_decap_8
XFILLER_0_693 vccd vssd sg13cmos5l_decap_8
XFILLER_10_7 vccd vssd sg13cmos5l_decap_8
XFILLER_23_1569 vccd vssd sg13cmos5l_decap_8
XFILLER_1_2044 vccd vssd sg13cmos5l_decap_8
XFILLER_5_2191 vccd vssd sg13cmos5l_decap_8
XFILLER_7_1799 vccd vssd sg13cmos5l_decap_8
XFILLER_40_1883 vccd vssd sg13cmos5l_decap_8
XFILLER_39_1009 vccd vssd sg13cmos5l_decap_4
XFILLER_36_848 vccd vssd sg13cmos5l_decap_8
XFILLER_35_336 vccd vssd sg13cmos5l_decap_8
XFILLER_21_1260 vccd vssd sg13cmos5l_decap_8
XFILLER_44_870 vccd vssd sg13cmos5l_decap_8
XFILLER_36_2609 vccd vssd sg13cmos5l_decap_8
XFILLER_1_1365 vccd vssd sg13cmos5l_decap_8
XFILLER_34_2322 vccd vssd sg13cmos5l_decap_8
XFILLER_31_564 vccd vssd sg13cmos5l_decap_8
XFILLER_34_2399 vccd vssd sg13cmos5l_decap_8
XFILLER_34_1676 vccd vssd sg13cmos5l_decap_8
X_1803_ _1803_/Q _1804_/CLK _1803_/D _1638_/Y vccd vssd sg13cmos5l_dfrbpq_1
XFILLER_15_1064 vccd vssd sg13cmos5l_decap_8
XFILLER_12_2631 vccd vssd sg13cmos5l_decap_8
XFILLER_32_2090 vccd vssd sg13cmos5l_decap_8
X_1734_ _1734_/Q _1757_/CLK _1734_/D fanout122/X vccd vssd sg13cmos5l_dfrbpq_1
Xhold226 _0852_/A _1719_/Q vccd vssd sg13cmos5l_dlygate4sd3_1
Xhold215 hold215/X _1440_/Y vccd vssd sg13cmos5l_dlygate4sd3_1
XFILLER_12_1974 vccd vssd sg13cmos5l_decap_8
Xhold204 hold204/X _0826_/Y vccd vssd sg13cmos5l_dlygate4sd3_1
Xhold248 _1579_/A _1780_/Q vccd vssd sg13cmos5l_dlygate4sd3_1
Xhold259 hold259/X _0842_/Y vccd vssd sg13cmos5l_dlygate4sd3_1
Xhold237 _1454_/A _1692_/Q vccd vssd sg13cmos5l_dlygate4sd3_1
X_1665_ _1665_/Q _1804_/CLK _1665_/D _1629_/Y vccd vssd sg13cmos5l_dfrbpq_1
X_1596_ _1596_/X _1528_/A hold508/X _1597_/S vccd vssd sg13cmos5l_mux2_1
XFILLER_28_1414 vccd vssd sg13cmos5l_decap_4
XFILLER_8_1519 vccd vssd sg13cmos5l_decap_8
XFILLER_45_1750 vccd vssd sg13cmos5l_decap_8
Xoutbuffers\[50\] control[50] _1718_/Q vccd vssd sg13cmos5l_buf_8
XFILLER_41_2359 vccd vssd sg13cmos5l_decap_8
XFILLER_39_620 vccd vssd sg13cmos5l_decap_4
XFILLER_26_1160 vccd vssd sg13cmos5l_decap_8
XFILLER_39_631 vccd vssd sg13cmos5l_decap_8
XFILLER_23_2760 vccd vssd sg13cmos5l_decap_8
XFILLER_6_1232 vccd vssd sg13cmos5l_decap_8
XFILLER_22_1057 vccd vssd sg13cmos5l_decap_8
XFILLER_38_196 vccd vssd sg13cmos5l_decap_8
XFILLER_27_848 vccd vssd sg13cmos5l_decap_8
XFILLER_26_336 vccd vssd sg13cmos5l_decap_8
XFILLER_42_807 vccd vssd sg13cmos5l_decap_8
XFILLER_39_1521 vccd vssd sg13cmos5l_decap_4
XFILLER_35_2119 vccd vssd sg13cmos5l_decap_8
XFILLER_39_1598 vccd vssd sg13cmos5l_decap_8
XFILLER_34_391 vccd vssd sg13cmos5l_decap_8
XFILLER_22_553 vccd vssd sg13cmos5l_decap_8
XFILLER_14_35 vccd vssd sg13cmos5l_decap_8
XFILLER_17_1874 vccd vssd sg13cmos5l_decap_8
XFILLER_30_2764 vccd vssd sg13cmos5l_decap_8
XFILLER_30_56 vccd vssd sg13cmos5l_decap_8
XFILLER_11_2163 vccd vssd sg13cmos5l_decap_4
XFILLER_2_903 vccd vssd sg13cmos5l_decap_8
XFILLER_11_1484 vccd vssd sg13cmos5l_decap_8
XFILLER_1_413 vccd vssd sg13cmos5l_decap_8
XFILLER_39_21 vccd vssd sg13cmos5l_decap_8
XFILLER_28_2693 vccd vssd sg13cmos5l_decap_8
XFILLER_24_2524 vccd vssd sg13cmos5l_decap_8
XFILLER_8_2765 vccd vssd sg13cmos5l_decap_8
XFILLER_24_1812 vccd vssd sg13cmos5l_decap_8
XFILLER_4_2618 vccd vssd sg13cmos5l_decap_8
XFILLER_7_1029 vccd vssd sg13cmos5l_decap_8
XFILLER_39_98 vccd vssd sg13cmos5l_decap_8
XFILLER_40_1146 vccd vssd sg13cmos5l_decap_8
XFILLER_24_1878 vccd vssd sg13cmos5l_decap_8
XFILLER_22_2270 vccd vssd sg13cmos5l_decap_8
XFILLER_18_826 vccd vssd sg13cmos5l_decap_8
XFILLER_2_2331 vccd vssd sg13cmos5l_decap_8
XFILLER_4_1939 vccd vssd sg13cmos5l_decap_8
XFILLER_45_623 vccd vssd sg13cmos5l_decap_8
XFILLER_29_196 vccd vssd sg13cmos5l_decap_8
XFILLER_17_336 vccd vssd sg13cmos5l_decap_8
XFILLER_2_1652 vccd vssd sg13cmos5l_decap_8
XFILLER_44_133 vccd vssd sg13cmos5l_decap_8
XFILLER_33_829 vccd vssd sg13cmos5l_decap_8
XFILLER_18_2317 vccd vssd sg13cmos5l_decap_8
XFILLER_44_199 vccd vssd sg13cmos5l_decap_8
XFILLER_18_1638 vccd vssd sg13cmos5l_decap_8
XFILLER_13_553 vccd vssd sg13cmos5l_decap_8
XFILLER_41_873 vccd vssd sg13cmos5l_decap_8
XFILLER_40_350 vccd vssd sg13cmos5l_decap_8
XFILLER_38_1086 vccd vssd sg13cmos5l_decap_8
XFILLER_35_2686 vccd vssd sg13cmos5l_decap_8
XFILLER_16_2063 vccd vssd sg13cmos5l_decap_8
XFILLER_16_1351 vccd vssd sg13cmos5l_decap_8
XFILLER_9_546 vccd vssd sg13cmos5l_decap_8
XFILLER_12_1204 vccd vssd sg13cmos5l_decap_8
XFILLER_5_763 vccd vssd sg13cmos5l_decap_8
X_1450_ _1450_/Y hold243/X _1449_/B _1449_/Y vccd vssd sg13cmos5l_a21oi_1
XFILLER_29_2468 vccd vssd sg13cmos5l_decap_8
XFILLER_29_1712 vccd vssd sg13cmos5l_decap_8
XFILLER_4_273 vccd vssd sg13cmos5l_decap_8
XFILLER_9_1806 vccd vssd sg13cmos5l_decap_8
XFILLER_42_2602 vccd vssd sg13cmos5l_decap_8
X_1381_ _1382_/C _1684_/Q _1342_/B _1429_/B _1676_/Q vccd vssd sg13cmos5l_a22oi_1
XFILLER_45_1057 vccd vssd sg13cmos5l_decap_8
XFILLER_42_2657 vccd vssd sg13cmos5l_decap_8
XFILLER_1_980 vccd vssd sg13cmos5l_decap_8
XFILLER_7_2275 vccd vssd sg13cmos5l_decap_8
XFILLER_23_1300 vccd vssd sg13cmos5l_decap_8
XFILLER_3_2128 vccd vssd sg13cmos5l_decap_8
XFILLER_0_490 vccd vssd sg13cmos5l_decap_8
XFILLER_23_2078 vccd vssd sg13cmos5l_decap_8
XFILLER_7_1596 vccd vssd sg13cmos5l_decap_8
XFILLER_23_1399 vccd vssd sg13cmos5l_decap_8
XFILLER_3_1449 vccd vssd sg13cmos5l_decap_8
XFILLER_36_656 vccd vssd sg13cmos5l_decap_8
XFILLER_35_133 vccd vssd sg13cmos5l_decap_8
XFILLER_1_1162 vccd vssd sg13cmos5l_decap_8
XFILLER_36_1727 vccd vssd sg13cmos5l_decap_8
XFILLER_34_2163 vccd vssd sg13cmos5l_decap_8
XFILLER_32_895 vccd vssd sg13cmos5l_decap_8
XFILLER_31_350 vccd vssd sg13cmos5l_decap_8
XFILLER_17_1148 vccd vssd sg13cmos5l_decap_8
XFILLER_34_1462 vccd vssd sg13cmos5l_decap_8
XFILLER_30_1304 vccd vssd sg13cmos5l_decap_8
XFILLER_12_2450 vccd vssd sg13cmos5l_decap_8
Xoutbuffers\[98\] control[98] _1766_/Q vccd vssd sg13cmos5l_buf_8
X_1717_ _1717_/Q clkload5/A _1717_/D fanout127/X vccd vssd sg13cmos5l_dfrbpq_1
XFILLER_12_1771 vccd vssd sg13cmos5l_decap_8
X_1648_ _1648_/Q _1809_/CLK _1648_/D _1613_/Y vccd vssd sg13cmos5l_dfrbpq_1
XFILLER_6_91 vccd vssd sg13cmos5l_decap_8
XFILLER_8_1316 vccd vssd sg13cmos5l_decap_8
X_1579_ _1579_/Y _1579_/A _1587_/S vccd vssd sg13cmos5l_nand2_1
Xclkbuf_5_24_0_SCK _1711_/CLK clkbuf_3_6_0_SCK/X vccd vssd sg13cmos5l_buf_8
XFILLER_41_2167 vccd vssd sg13cmos5l_decap_8
XFILLER_28_1288 vccd vssd sg13cmos5l_decap_8
XFILLER_41_1433 vccd vssd sg13cmos5l_decap_8
XFILLER_39_494 vccd vssd sg13cmos5l_decap_8
XFILLER_3_2695 vccd vssd sg13cmos5l_decap_8
XFILLER_42_604 vccd vssd sg13cmos5l_decap_8
XFILLER_26_133 vccd vssd sg13cmos5l_decap_8
XFILLER_19_2615 vccd vssd sg13cmos5l_decap_8
XFILLER_41_147 vccd vssd sg13cmos5l_decap_8
XFILLER_35_1204 vccd vssd sg13cmos5l_decap_8
XFILLER_25_56 vccd vssd sg13cmos5l_decap_8
XFILLER_23_840 vccd vssd sg13cmos5l_decap_8
XFILLER_39_1395 vccd vssd sg13cmos5l_decap_8
XFILLER_22_350 vccd vssd sg13cmos5l_decap_8
XFILLER_17_2350 vccd vssd sg13cmos5l_decap_8
XFILLER_10_567 vccd vssd sg13cmos5l_decap_8
XFILLER_13_2269 vccd vssd sg13cmos5l_decap_8
XFILLER_41_77 vccd vssd sg13cmos5l_decap_8
XFILLER_30_2561 vccd vssd sg13cmos5l_decap_8
Xrebuffer164 _0948_/A fanout93/X vccd vssd sg13cmos5l_buf_1
XFILLER_13_1568 vccd vssd sg13cmos5l_decap_8
XFILLER_30_1860 vccd vssd sg13cmos5l_decap_4
XFILLER_2_700 vccd vssd sg13cmos5l_decap_8
XFILLER_1_210 vccd vssd sg13cmos5l_decap_8
XFILLER_11_1281 vccd vssd sg13cmos5l_decap_8
XFILLER_26_1918 vccd vssd sg13cmos5l_decap_8
XFILLER_2_777 vccd vssd sg13cmos5l_decap_8
XFILLER_8_2562 vccd vssd sg13cmos5l_decap_8
XFILLER_2_49 vccd vssd sg13cmos5l_decap_8
XFILLER_1_287 vccd vssd sg13cmos5l_decap_8
XFILLER_4_2415 vccd vssd sg13cmos5l_decap_8
XFILLER_24_2398 vccd vssd sg13cmos5l_decap_8
XFILLER_4_1736 vccd vssd sg13cmos5l_decap_8
XFILLER_8_1883 vccd vssd sg13cmos5l_decap_8
XFILLER_45_420 vccd vssd sg13cmos5l_decap_8
XFILLER_20_1528 vccd vssd sg13cmos5l_decap_8
XFILLER_18_623 vccd vssd sg13cmos5l_decap_8
XFILLER_17_133 vccd vssd sg13cmos5l_decap_8
XFILLER_45_497 vccd vssd sg13cmos5l_decap_8
XFILLER_37_2737 vccd vssd sg13cmos5l_decap_8
XFILLER_33_626 vccd vssd sg13cmos5l_decap_8
XFILLER_32_147 vccd vssd sg13cmos5l_decap_8
XFILLER_18_2158 vccd vssd sg13cmos5l_decap_8
XFILLER_14_840 vccd vssd sg13cmos5l_decap_8
XFILLER_41_670 vccd vssd sg13cmos5l_decap_8
XFILLER_35_2450 vccd vssd sg13cmos5l_decap_8
X_0950_ _1042_/A _0924_/A _0947_/S _0915_/A vccd vssd sg13cmos5l_a21oi_1
XFILLER_18_1435 vccd vssd sg13cmos5l_decap_8
XFILLER_13_350 vccd vssd sg13cmos5l_decap_8
XFILLER_9_343 vccd vssd sg13cmos5l_decap_8
XFILLER_35_1793 vccd vssd sg13cmos5l_decap_8
X_0881_ _1406_/A _0898_/A _0898_/B _1394_/A vccd vssd sg13cmos5l_nor3_1
XFILLER_12_1001 vccd vssd sg13cmos5l_decap_8
XFILLER_31_1679 vccd vssd sg13cmos5l_decap_4
XFILLER_12_1078 vccd vssd sg13cmos5l_decap_8
XFILLER_29_2254 vccd vssd sg13cmos5l_decap_8
X_1502_ _1502_/X _1560_/A hold441/X _1508_/S vccd vssd sg13cmos5l_mux2_1
XFILLER_5_560 vccd vssd sg13cmos5l_decap_8
X_1433_ _1433_/X _1478_/A hold308/X _1437_/S vccd vssd sg13cmos5l_mux2_1
XFILLER_9_1603 vccd vssd sg13cmos5l_decap_8
XFILLER_9_2359 vccd vssd sg13cmos5l_decap_8
X_1364_ _1364_/Y _1364_/A _1364_/B _1364_/C _1364_/D vccd vssd sg13cmos5l_nand4_1
XFILLER_42_1720 vccd vssd sg13cmos5l_decap_8
XFILLER_7_2072 vccd vssd sg13cmos5l_decap_8
X_1295_ _1295_/Y _1291_/Y _1293_/Y _1294_/Y vccd vssd sg13cmos5l_o21ai_1
XFILLER_23_1141 vccd vssd sg13cmos5l_decap_8
XFILLER_20_2730 vccd vssd sg13cmos5l_decap_8
XFILLER_37_943 vccd vssd sg13cmos5l_decap_8
XFILLER_36_420 vccd vssd sg13cmos5l_decap_8
XFILLER_3_1246 vccd vssd sg13cmos5l_decap_8
XFILLER_7_1393 vccd vssd sg13cmos5l_decap_8
XFILLER_24_637 vccd vssd sg13cmos5l_decap_8
Xoutbuffers\[13\] control[13] _1681_/Q vccd vssd sg13cmos5l_buf_8
XFILLER_36_1513 vccd vssd sg13cmos5l_decap_8
XFILLER_23_147 vccd vssd sg13cmos5l_decap_8
XFILLER_14_2512 vccd vssd sg13cmos5l_decap_8
XFILLER_20_854 vccd vssd sg13cmos5l_decap_8
XFILLER_10_1708 vccd vssd sg13cmos5l_decap_8
XFILLER_11_14 vccd vssd sg13cmos5l_decap_8
XFILLER_14_1855 vccd vssd sg13cmos5l_decap_8
XFILLER_30_1145 vccd vssd sg13cmos5l_decap_8
XFILLER_25_2630 vccd vssd sg13cmos5l_decap_8
XFILLER_8_1113 vccd vssd sg13cmos5l_decap_8
XFILLER_5_2724 vccd vssd sg13cmos5l_decap_8
XFILLER_21_2538 vccd vssd sg13cmos5l_decap_8
XFILLER_5_2768 vccd vssd sg13cmos5l_decap_8
XFILLER_41_1241 vccd vssd sg13cmos5l_decap_8
XFILLER_39_280 vccd vssd sg13cmos5l_decap_8
XFILLER_28_921 vccd vssd sg13cmos5l_decap_8
XFILLER_27_420 vccd vssd sg13cmos5l_decap_8
XFILLER_21_1848 vccd vssd sg13cmos5l_decap_8
XFILLER_3_2492 vccd vssd sg13cmos5l_decap_8
XFILLER_36_77 vccd vssd sg13cmos5l_decap_8
XFILLER_28_987 vccd vssd sg13cmos5l_decap_8
XFILLER_19_2434 vccd vssd sg13cmos5l_decap_8
XFILLER_27_497 vccd vssd sg13cmos5l_decap_8
XFILLER_19_1722 vccd vssd sg13cmos5l_decap_8
XFILLER_15_637 vccd vssd sg13cmos5l_decap_8
XFILLER_36_2770 vccd vssd sg13cmos5l_decap_8
XFILLER_14_147 vccd vssd sg13cmos5l_decap_8
XFILLER_32_2623 vccd vssd sg13cmos5l_decap_8
XFILLER_11_854 vccd vssd sg13cmos5l_decap_8
XFILLER_13_2044 vccd vssd sg13cmos5l_decap_8
XFILLER_7_847 vccd vssd sg13cmos5l_decap_8
XFILLER_10_364 vccd vssd sg13cmos5l_decap_8
XFILLER_6_357 vccd vssd sg13cmos5l_decap_8
XFILLER_13_1365 vccd vssd sg13cmos5l_decap_8
XFILLER_2_574 vccd vssd sg13cmos5l_decap_8
XFILLER_43_2763 vccd vssd sg13cmos5l_decap_8
XFILLER_42_1005 vccd vssd sg13cmos5l_decap_8
XFILLER_4_2212 vccd vssd sg13cmos5l_decap_8
XFILLER_38_718 vccd vssd sg13cmos5l_decap_8
XFILLER_24_2162 vccd vssd sg13cmos5l_decap_8
XFILLER_8_1680 vccd vssd sg13cmos5l_decap_8
XFILLER_37_217 vccd vssd sg13cmos5l_decap_8
XFILLER_19_910 vccd vssd sg13cmos5l_decap_8
XFILLER_4_1533 vccd vssd sg13cmos5l_decap_8
XFILLER_4_2289 vccd vssd sg13cmos5l_decap_8
XFILLER_18_420 vccd vssd sg13cmos5l_decap_8
X_1080_ _1081_/C mask_rev_in[31] _1389_/A2 vccd vssd sg13cmos5l_nor2b_1
XFILLER_20_1358 vccd vssd sg13cmos5l_decap_8
XFILLER_19_987 vccd vssd sg13cmos5l_decap_8
XFILLER_45_294 vccd vssd sg13cmos5l_decap_8
XFILLER_37_2534 vccd vssd sg13cmos5l_decap_8
XFILLER_33_434 vccd vssd sg13cmos5l_decap_8
XFILLER_18_497 vccd vssd sg13cmos5l_decap_8
XFILLER_37_1855 vccd vssd sg13cmos5l_decap_8
XFILLER_18_1232 vccd vssd sg13cmos5l_decap_8
Xoutbuffers\[103\] control[103] _1771_/Q vccd vssd sg13cmos5l_buf_8
XFILLER_33_1719 vccd vssd sg13cmos5l_decap_8
XFILLER_31_2100 vccd vssd sg13cmos5l_decap_8
X_0933_ _0933_/Y _0928_/A _0906_/Y hold382/X vccd vssd sg13cmos5l_o21ai_1
XFILLER_9_140 vccd vssd sg13cmos5l_decap_8
X_0864_ _0864_/Y status[53] vccd vssd sg13cmos5l_inv_1
XFILLER_31_2188 vccd vssd sg13cmos5l_decap_8
XFILLER_31_2155 vccd vssd sg13cmos5l_decap_8
XFILLER_31_1421 vccd vssd sg13cmos5l_decap_8
XFILLER_31_1487 vccd vssd sg13cmos5l_decap_8
XFILLER_44_2527 vccd vssd sg13cmos5l_decap_8
XFILLER_29_2084 vccd vssd sg13cmos5l_decap_8
XFILLER_9_1400 vccd vssd sg13cmos5l_decap_8
XFILLER_9_2156 vccd vssd sg13cmos5l_decap_8
XFILLER_42_2240 vccd vssd sg13cmos5l_decap_8
XFILLER_25_1203 vccd vssd sg13cmos5l_decap_8
X_1416_ _1416_/Y _1394_/C _0903_/B _0903_/Y vccd vssd sg13cmos5l_a21oi_1
XFILLER_5_2009 vccd vssd sg13cmos5l_decap_8
XFILLER_3_70 vccd vssd sg13cmos5l_decap_8
XFILLER_9_1477 vccd vssd sg13cmos5l_decap_8
X_1347_ _1349_/B _1346_/Y _1306_/Y _1347_/B1 vccd vssd sg13cmos5l_a21oi_1
XFILLER_42_1561 vccd vssd sg13cmos5l_decap_8
XFILLER_28_217 vccd vssd sg13cmos5l_decap_8
XFILLER_37_740 vccd vssd sg13cmos5l_decap_8
X_1278_ _1278_/X _1790_/Q _1588_/B _1279_/B vccd vssd sg13cmos5l_a21o_1
XFILLER_3_1043 vccd vssd sg13cmos5l_decap_8
XFILLER_0_2632 vccd vssd sg13cmos5l_decap_8
XFILLER_7_1190 vccd vssd sg13cmos5l_decap_8
XFILLER_25_913 vccd vssd sg13cmos5l_decap_8
XFILLER_36_294 vccd vssd sg13cmos5l_decap_8
XFILLER_24_434 vccd vssd sg13cmos5l_decap_8
XFILLER_0_1953 vccd vssd sg13cmos5l_decap_8
XFILLER_40_905 vccd vssd sg13cmos5l_decap_8
XFILLER_36_2066 vccd vssd sg13cmos5l_decap_8
XFILLER_19_1029 vccd vssd sg13cmos5l_decap_8
XFILLER_36_1398 vccd vssd sg13cmos5l_decap_8
XFILLER_20_651 vccd vssd sg13cmos5l_decap_8
XFILLER_22_35 vccd vssd sg13cmos5l_decap_8
XFILLER_14_1652 vccd vssd sg13cmos5l_decap_8
XFILLER_14_2386 vccd vssd sg13cmos5l_decap_8
XFILLER_10_1505 vccd vssd sg13cmos5l_decap_8
XFILLER_27_2714 vccd vssd sg13cmos5l_decap_8
Xfanout130 fanout130/X fanout143/X vccd vssd sg13cmos5l_buf_1
XFILLER_43_1358 vccd vssd sg13cmos5l_decap_8
Xfanout141 _1617_/B_N _1603_/B_N vccd vssd sg13cmos5l_buf_1
XFILLER_21_2335 vccd vssd sg13cmos5l_decap_8
XFILLER_19_217 vccd vssd sg13cmos5l_decap_8
XFILLER_1_2429 vccd vssd sg13cmos5l_decap_8
XFILLER_5_1820 vccd vssd sg13cmos5l_decap_8
XFILLER_41_1071 vccd vssd sg13cmos5l_decap_8
XFILLER_21_1634 vccd vssd sg13cmos5l_decap_8
XFILLER_28_762 vccd vssd sg13cmos5l_decap_8
XFILLER_16_924 vccd vssd sg13cmos5l_decap_8
XFILLER_5_1897 vccd vssd sg13cmos5l_decap_8
XFILLER_43_754 vccd vssd sg13cmos5l_decap_8
XFILLER_43_743 vccd vssd sg13cmos5l_decap_4
XFILLER_27_294 vccd vssd sg13cmos5l_decap_8
XFILLER_15_434 vccd vssd sg13cmos5l_decap_8
XFILLER_42_253 vccd vssd sg13cmos5l_decap_8
XFILLER_34_2707 vccd vssd sg13cmos5l_decap_8
XFILLER_19_2275 vccd vssd sg13cmos5l_decap_8
Xtiedowns\[97\] status[97] vccd vssd sg13cmos5l_antennanp
XFILLER_30_448 vccd vssd sg13cmos5l_decap_8
XFILLER_19_1596 vccd vssd sg13cmos5l_decap_8
XFILLER_11_651 vccd vssd sg13cmos5l_decap_8
XFILLER_32_2486 vccd vssd sg13cmos5l_decap_8
XFILLER_32_1741 vccd vssd sg13cmos5l_decap_8
XFILLER_15_1449 vccd vssd sg13cmos5l_decap_8
XFILLER_10_161 vccd vssd sg13cmos5l_decap_8
XFILLER_7_644 vccd vssd sg13cmos5l_decap_8
XFILLER_13_1162 vccd vssd sg13cmos5l_decap_8
XFILLER_6_154 vccd vssd sg13cmos5l_decap_8
XFILLER_10_2773 vccd vssd sg13cmos5l_decap_8
XFILLER_40_7 vccd vssd sg13cmos5l_decap_8
XFILLER_26_2213 vccd vssd sg13cmos5l_decap_8
XFILLER_3_861 vccd vssd sg13cmos5l_decap_8
XFILLER_26_1534 vccd vssd sg13cmos5l_decap_8
XFILLER_2_371 vccd vssd sg13cmos5l_decap_8
X_1201_ _1201_/X _1720_/Q _1337_/B _1114_/B vccd vssd sg13cmos5l_a21o_1
XFILLER_6_1617 vccd vssd sg13cmos5l_decap_8
XFILLER_38_537 vccd vssd sg13cmos5l_decap_8
XFILLER_43_1892 vccd vssd sg13cmos5l_decap_4
X_1132_ _1132_/X _0865_/Y _1309_/B1 _1357_/A2 vccd vssd sg13cmos5l_a21o_1
XFILLER_4_1330 vccd vssd sg13cmos5l_decap_8
XFILLER_4_2086 vccd vssd sg13cmos5l_decap_8
XFILLER_20_1155 vccd vssd sg13cmos5l_decap_8
XFILLER_19_784 vccd vssd sg13cmos5l_decap_8
X_1063_ _1063_/X _1064_/A _1074_/C vccd vssd sg13cmos5l_and2_1
XFILLER_37_2331 vccd vssd sg13cmos5l_decap_8
XFILLER_18_294 vccd vssd sg13cmos5l_decap_8
XFILLER_34_754 vccd vssd sg13cmos5l_decap_8
XFILLER_33_231 vccd vssd sg13cmos5l_decap_8
XFILLER_37_2397 vccd vssd sg13cmos5l_decap_8
XFILLER_37_1652 vccd vssd sg13cmos5l_decap_8
XFILLER_22_938 vccd vssd sg13cmos5l_decap_8
XFILLER_21_448 vccd vssd sg13cmos5l_decap_8
X_0916_ _0916_/Y _0970_/A _0910_/B _0915_/Y vccd vssd sg13cmos5l_o21ai_1
XFILLER_11_2548 vccd vssd sg13cmos5l_decap_8
X_0847_ _0847_/Y status[34] vccd vssd sg13cmos5l_inv_1
Xoutbuffers\[80\] control[80] _1748_/Q vccd vssd sg13cmos5l_buf_8
X_0880__150 _1655_/CLK _1804_/CLK vccd vssd sg13cmos5l_inv_1
XFILLER_11_1869 vccd vssd sg13cmos5l_decap_8
XFILLER_44_2313 vccd vssd sg13cmos5l_decap_8
XFILLER_0_308 vccd vssd sg13cmos5l_decap_8
XFILLER_44_1623 vccd vssd sg13cmos5l_decap_8
XFILLER_25_1011 vccd vssd sg13cmos5l_decap_4
XFILLER_9_1274 vccd vssd sg13cmos5l_decap_8
XFILLER_29_515 vccd vssd sg13cmos5l_decap_4
XFILLER_22_2655 vccd vssd sg13cmos5l_decap_8
XFILLER_2_2716 vccd vssd sg13cmos5l_decap_8
XFILLER_5_1127 vccd vssd sg13cmos5l_decap_8
XFILLER_25_1099 vccd vssd sg13cmos5l_decap_4
XFILLER_44_529 vccd vssd sg13cmos5l_decap_8
XFILLER_25_710 vccd vssd sg13cmos5l_decap_8
XFILLER_17_35 vccd vssd sg13cmos5l_decap_8
XFILLER_24_231 vccd vssd sg13cmos5l_decap_8
XFILLER_0_1750 vccd vssd sg13cmos5l_decap_8
XFILLER_40_746 vccd vssd sg13cmos5l_decap_8
XFILLER_25_787 vccd vssd sg13cmos5l_decap_8
XFILLER_16_2437 vccd vssd sg13cmos5l_decap_8
XFILLER_13_938 vccd vssd sg13cmos5l_decap_8
XFILLER_33_56 vccd vssd sg13cmos5l_decap_8
XFILLER_16_1736 vccd vssd sg13cmos5l_decap_8
XFILLER_12_448 vccd vssd sg13cmos5l_decap_8
XFILLER_33_2762 vccd vssd sg13cmos5l_decap_8
XFILLER_32_1037 vccd vssd sg13cmos5l_decap_8
XFILLER_14_2194 vccd vssd sg13cmos5l_decap_8
XFILLER_10_1302 vccd vssd sg13cmos5l_decap_8
XFILLER_10_2058 vccd vssd sg13cmos5l_decap_8
XFILLER_4_658 vccd vssd sg13cmos5l_decap_8
XFILLER_27_2544 vccd vssd sg13cmos5l_decap_8
XFILLER_3_168 vccd vssd sg13cmos5l_decap_8
XFILLER_10_1379 vccd vssd sg13cmos5l_decap_8
XFILLER_7_1904 vccd vssd sg13cmos5l_decap_8
XFILLER_40_2722 vccd vssd sg13cmos5l_decap_8
XFILLER_0_875 vccd vssd sg13cmos5l_decap_8
XFILLER_43_1166 vccd vssd sg13cmos5l_decap_8
XFILLER_27_1876 vccd vssd sg13cmos5l_decap_8
XFILLER_21_2154 vccd vssd sg13cmos5l_decap_8
XFILLER_1_2226 vccd vssd sg13cmos5l_decap_8
XFILLER_5_2373 vccd vssd sg13cmos5l_decap_8
Xtiedowns\[12\] status[12] vccd vssd sg13cmos5l_antennanp
XFILLER_35_507 vccd vssd sg13cmos5l_decap_8
XFILLER_21_1431 vccd vssd sg13cmos5l_decap_8
XFILLER_5_1694 vccd vssd sg13cmos5l_decap_8
XFILLER_28_570 vccd vssd sg13cmos5l_decap_8
XFILLER_16_721 vccd vssd sg13cmos5l_decap_8
XFILLER_1_1547 vccd vssd sg13cmos5l_decap_8
XFILLER_38_2651 vccd vssd sg13cmos5l_decap_8
XFILLER_15_231 vccd vssd sg13cmos5l_decap_8
XFILLER_38_1961 vccd vssd sg13cmos5l_decap_8
XFILLER_19_2072 vccd vssd sg13cmos5l_decap_8
XFILLER_16_798 vccd vssd sg13cmos5l_decap_8
XFILLER_34_1836 vccd vssd sg13cmos5l_decap_8
XFILLER_31_746 vccd vssd sg13cmos5l_decap_8
XFILLER_30_245 vccd vssd sg13cmos5l_decap_8
X_1750_ _1750_/Q _1757_/CLK _1750_/D fanout121/X vccd vssd sg13cmos5l_dfrbpq_1
XFILLER_32_2261 vccd vssd sg13cmos5l_decap_8
XFILLER_19_1393 vccd vssd sg13cmos5l_decap_8
XFILLER_15_1246 vccd vssd sg13cmos5l_decap_8
XFILLER_8_931 vccd vssd sg13cmos5l_decap_8
XFILLER_7_441 vccd vssd sg13cmos5l_decap_8
X_1681_ _1681_/Q _1685_/CLK _1681_/D fanout137/X vccd vssd sg13cmos5l_dfrbpq_1
Xhold408 _1771_/D _1567_/X vccd vssd sg13cmos5l_dlygate4sd3_1
Xhold419 hold419/X _1702_/Q vccd vssd sg13cmos5l_dlygate4sd3_1
XFILLER_28_2308 vccd vssd sg13cmos5l_decap_8
XFILLER_45_2611 vccd vssd sg13cmos5l_decap_8
XFILLER_26_2010 vccd vssd sg13cmos5l_decap_8
XFILLER_45_1932 vccd vssd sg13cmos5l_decap_8
XFILLER_45_2688 vccd vssd sg13cmos5l_decap_8
XFILLER_6_1414 vccd vssd sg13cmos5l_decap_8
XFILLER_38_301 vccd vssd sg13cmos5l_decap_8
XFILLER_38_378 vccd vssd sg13cmos5l_decap_8
X_1115_ _1115_/Y _1112_/Y _1113_/X _1114_/Y vccd vssd sg13cmos5l_o21ai_1
Xclkbuf_3_6_0_SCK clkbuf_3_6_0_SCK/X clkbuf_0_SCK/X vccd vssd sg13cmos5l_buf_8
XFILLER_19_581 vccd vssd sg13cmos5l_decap_8
X_1046_ _1046_/Y _1046_/A _1046_/B _1070_/C vccd vssd sg13cmos5l_nor3_1
XFILLER_17_2713 vccd vssd sg13cmos5l_decap_8
XFILLER_0_1057 vccd vssd sg13cmos5l_decap_8
XFILLER_22_735 vccd vssd sg13cmos5l_decap_8
XFILLER_37_2194 vccd vssd sg13cmos5l_decap_8
XFILLER_37_1471 vccd vssd sg13cmos5l_decap_8
XFILLER_21_245 vccd vssd sg13cmos5l_decap_8
XFILLER_33_2058 vccd vssd sg13cmos5l_decap_8
XFILLER_9_91 vccd vssd sg13cmos5l_decap_8
XFILLER_11_2312 vccd vssd sg13cmos5l_decap_8
XFILLER_11_1666 vccd vssd sg13cmos5l_decap_8
XFILLER_11_2389 vccd vssd sg13cmos5l_decap_8
XFILLER_44_2110 vccd vssd sg13cmos5l_decap_8
XFILLER_27_1117 vccd vssd sg13cmos5l_decap_8
XFILLER_24_2706 vccd vssd sg13cmos5l_decap_8
XFILLER_0_105 vccd vssd sg13cmos5l_decap_8
XFILLER_44_1420 vccd vssd sg13cmos5l_decap_8
XFILLER_40_2018 vccd vssd sg13cmos5l_decap_8
XFILLER_29_301 vccd vssd sg13cmos5l_decap_8
XFILLER_6_2671 vccd vssd sg13cmos5l_decap_8
XFILLER_9_1071 vccd vssd sg13cmos5l_decap_8
XFILLER_44_1497 vccd vssd sg13cmos5l_decap_8
XFILLER_28_56 vccd vssd sg13cmos5l_decap_8
XFILLER_22_2452 vccd vssd sg13cmos5l_decap_8
XFILLER_2_2513 vccd vssd sg13cmos5l_decap_8
XFILLER_45_805 vccd vssd sg13cmos5l_decap_8
XFILLER_29_378 vccd vssd sg13cmos5l_decap_8
XFILLER_17_518 vccd vssd sg13cmos5l_decap_8
XFILLER_2_1834 vccd vssd sg13cmos5l_decap_8
XFILLER_6_1981 vccd vssd sg13cmos5l_decap_8
XFILLER_44_315 vccd vssd sg13cmos5l_decap_8
XFILLER_38_890 vccd vssd sg13cmos5l_decap_8
XFILLER_22_1795 vccd vssd sg13cmos5l_decap_8
XFILLER_44_77 vccd vssd sg13cmos5l_decap_8
XFILLER_38_1257 vccd vssd sg13cmos5l_decap_8
XFILLER_25_584 vccd vssd sg13cmos5l_decap_8
XFILLER_16_2223 vccd vssd sg13cmos5l_decap_8
XFILLER_13_735 vccd vssd sg13cmos5l_decap_8
XFILLER_40_532 vccd vssd sg13cmos5l_decap_8
XFILLER_12_245 vccd vssd sg13cmos5l_decap_8
XFILLER_16_1533 vccd vssd sg13cmos5l_decap_8
XFILLER_9_728 vccd vssd sg13cmos5l_decap_8
XFILLER_40_598 vccd vssd sg13cmos5l_decap_8
XFILLER_8_238 vccd vssd sg13cmos5l_decap_8
XFILLER_5_945 vccd vssd sg13cmos5l_decap_8
XFILLER_4_455 vccd vssd sg13cmos5l_decap_8
XFILLER_5_49 vccd vssd sg13cmos5l_decap_8
XFILLER_10_1176 vccd vssd sg13cmos5l_decap_8
XFILLER_45_1239 vccd vssd sg13cmos5l_decap_8
XFILLER_7_1701 vccd vssd sg13cmos5l_decap_8
XFILLER_7_2457 vccd vssd sg13cmos5l_decap_8
XFILLER_0_672 vccd vssd sg13cmos5l_decap_8
XFILLER_5_2170 vccd vssd sg13cmos5l_decap_8
XFILLER_7_1778 vccd vssd sg13cmos5l_decap_8
XFILLER_40_2596 vccd vssd sg13cmos5l_decap_8
XFILLER_40_1862 vccd vssd sg13cmos5l_decap_8
XFILLER_36_827 vccd vssd sg13cmos5l_decap_8
XFILLER_1_2023 vccd vssd sg13cmos5l_decap_8
XFILLER_35_315 vccd vssd sg13cmos5l_decap_8
XFILLER_1_1344 vccd vssd sg13cmos5l_decap_8
XFILLER_5_1491 vccd vssd sg13cmos5l_decap_8
XFILLER_43_370 vccd vssd sg13cmos5l_decap_8
XFILLER_34_1611 vccd vssd sg13cmos5l_decap_8
XFILLER_31_543 vccd vssd sg13cmos5l_decap_8
XFILLER_16_595 vccd vssd sg13cmos5l_decap_8
XFILLER_34_2378 vccd vssd sg13cmos5l_decap_8
XFILLER_19_1190 vccd vssd sg13cmos5l_decap_8
XFILLER_12_2610 vccd vssd sg13cmos5l_decap_8
XFILLER_34_1655 vccd vssd sg13cmos5l_decap_8
X_1802_ _1802_/Q _1802_/CLK _1802_/D _1637_/Y vccd vssd sg13cmos5l_dfrbpq_1
XFILLER_15_1043 vccd vssd sg13cmos5l_decap_8
X_1733_ _1733_/Q clkload3/A _1733_/D fanout125/X vccd vssd sg13cmos5l_dfrbpq_1
Xhold216 _0843_/A _1750_/Q vccd vssd sg13cmos5l_dlygate4sd3_1
Xhold205 _1464_/A _1700_/Q vccd vssd sg13cmos5l_dlygate4sd3_1
XFILLER_12_1953 vccd vssd sg13cmos5l_decap_8
XFILLER_12_2687 vccd vssd sg13cmos5l_decap_8
Xhold227 hold227/X _0852_/Y vccd vssd sg13cmos5l_dlygate4sd3_1
Xhold249 hold249/X _1579_/Y vccd vssd sg13cmos5l_dlygate4sd3_1
Xhold238 hold238/X _1454_/Y vccd vssd sg13cmos5l_dlygate4sd3_1
X_1664_ _1664_/Q _1809_/CLK _1664_/D _1628_/Y vccd vssd sg13cmos5l_dfrbpq_1
X_1595_ _1793_/D _1595_/A0 hold528/X _1595_/S vccd vssd sg13cmos5l_mux2_1
XFILLER_45_2485 vccd vssd sg13cmos5l_decap_8
XFILLER_28_1437 vccd vssd sg13cmos5l_decap_8
XFILLER_41_2349 vccd vssd sg13cmos5l_decap_4
XFILLER_6_1211 vccd vssd sg13cmos5l_decap_8
Xoutbuffers\[43\] control[43] _1711_/Q vccd vssd sg13cmos5l_buf_8
XFILLER_22_1036 vccd vssd sg13cmos5l_decap_8
XFILLER_6_1288 vccd vssd sg13cmos5l_decap_8
XFILLER_39_2223 vccd vssd sg13cmos5l_decap_8
XFILLER_38_175 vccd vssd sg13cmos5l_decap_8
XFILLER_26_315 vccd vssd sg13cmos5l_decap_8
XFILLER_39_1500 vccd vssd sg13cmos5l_decap_8
XFILLER_1_2590 vccd vssd sg13cmos5l_decap_8
XFILLER_35_2109 vccd vssd sg13cmos5l_decap_4
XFILLER_35_871 vccd vssd sg13cmos5l_decap_4
X_1029_ _1029_/Y _1029_/A _1070_/A _1070_/B vccd vssd sg13cmos5l_nor3_1
XFILLER_17_2521 vccd vssd sg13cmos5l_decap_8
XFILLER_39_1577 vccd vssd sg13cmos5l_decap_8
XFILLER_22_532 vccd vssd sg13cmos5l_decap_8
XFILLER_14_14 vccd vssd sg13cmos5l_decap_8
XFILLER_17_1853 vccd vssd sg13cmos5l_decap_8
XFILLER_37_1290 vccd vssd sg13cmos5l_decap_8
XFILLER_33_1132 vccd vssd sg13cmos5l_decap_4
XFILLER_10_749 vccd vssd sg13cmos5l_decap_8
XFILLER_33_1165 vccd vssd sg13cmos5l_decap_8
XFILLER_30_2743 vccd vssd sg13cmos5l_decap_8
XFILLER_11_2142 vccd vssd sg13cmos5l_decap_8
XFILLER_33_1198 vccd vssd sg13cmos5l_decap_8
XFILLER_30_35 vccd vssd sg13cmos5l_decap_8
XFILLER_11_2186 vccd vssd sg13cmos5l_decap_8
XFILLER_11_1463 vccd vssd sg13cmos5l_decap_8
XFILLER_28_2672 vccd vssd sg13cmos5l_decap_8
XFILLER_24_2503 vccd vssd sg13cmos5l_decap_8
XFILLER_2_959 vccd vssd sg13cmos5l_decap_8
XFILLER_7_1008 vccd vssd sg13cmos5l_decap_8
XFILLER_1_469 vccd vssd sg13cmos5l_decap_8
XFILLER_39_77 vccd vssd sg13cmos5l_decap_8
XFILLER_2_2310 vccd vssd sg13cmos5l_decap_8
XFILLER_4_1918 vccd vssd sg13cmos5l_decap_8
XFILLER_45_602 vccd vssd sg13cmos5l_decap_8
XFILLER_44_1294 vccd vssd sg13cmos5l_decap_8
XFILLER_18_805 vccd vssd sg13cmos5l_decap_8
XFILLER_44_112 vccd vssd sg13cmos5l_decap_8
XFILLER_29_175 vccd vssd sg13cmos5l_decap_8
XFILLER_17_315 vccd vssd sg13cmos5l_decap_8
XFILLER_2_2387 vccd vssd sg13cmos5l_decap_8
XFILLER_2_1631 vccd vssd sg13cmos5l_decap_8
XFILLER_45_679 vccd vssd sg13cmos5l_decap_8
XFILLER_33_808 vccd vssd sg13cmos5l_decap_8
XFILLER_22_1592 vccd vssd sg13cmos5l_decap_8
XFILLER_44_178 vccd vssd sg13cmos5l_decap_8
XFILLER_32_329 vccd vssd sg13cmos5l_decap_8
XFILLER_26_882 vccd vssd sg13cmos5l_decap_8
XFILLER_41_852 vccd vssd sg13cmos5l_decap_8
XFILLER_25_392 vccd vssd sg13cmos5l_decap_8
XFILLER_18_1617 vccd vssd sg13cmos5l_decap_8
XFILLER_13_532 vccd vssd sg13cmos5l_decap_8
XFILLER_35_2665 vccd vssd sg13cmos5l_decap_8
XFILLER_16_2042 vccd vssd sg13cmos5l_decap_8
XFILLER_16_1330 vccd vssd sg13cmos5l_decap_8
XFILLER_9_525 vccd vssd sg13cmos5l_decap_8
XFILLER_35_1986 vccd vssd sg13cmos5l_decap_8
XFILLER_5_742 vccd vssd sg13cmos5l_decap_8
XFILLER_4_252 vccd vssd sg13cmos5l_decap_8
X_1380_ _1382_/B _1380_/A _1380_/B vccd vssd sg13cmos5l_nand2_2
XFILLER_45_1036 vccd vssd sg13cmos5l_decap_8
XFILLER_42_2636 vccd vssd sg13cmos5l_decap_8
XFILLER_27_2182 vccd vssd sg13cmos5l_decap_8
XFILLER_23_2024 vccd vssd sg13cmos5l_decap_8
XFILLER_7_2254 vccd vssd sg13cmos5l_decap_8
XFILLER_3_2107 vccd vssd sg13cmos5l_decap_8
XFILLER_42_1957 vccd vssd sg13cmos5l_decap_8
XFILLER_3_1428 vccd vssd sg13cmos5l_decap_8
XFILLER_7_1575 vccd vssd sg13cmos5l_decap_8
XFILLER_36_635 vccd vssd sg13cmos5l_decap_8
XFILLER_35_112 vccd vssd sg13cmos5l_decap_8
XFILLER_24_819 vccd vssd sg13cmos5l_decap_8
XFILLER_1_1141 vccd vssd sg13cmos5l_decap_8
XFILLER_35_189 vccd vssd sg13cmos5l_decap_8
XFILLER_23_329 vccd vssd sg13cmos5l_decap_8
XFILLER_17_882 vccd vssd sg13cmos5l_decap_8
XFILLER_16_392 vccd vssd sg13cmos5l_decap_8
XFILLER_34_2142 vccd vssd sg13cmos5l_decap_8
XFILLER_32_874 vccd vssd sg13cmos5l_decap_8
XFILLER_17_1127 vccd vssd sg13cmos5l_decap_8
XFILLER_34_1441 vccd vssd sg13cmos5l_decap_8
XFILLER_12_1750 vccd vssd sg13cmos5l_decap_8
X_1716_ _1716_/Q clkload0/A _1716_/D fanout127/X vccd vssd sg13cmos5l_dfrbpq_1
XFILLER_6_70 vccd vssd sg13cmos5l_decap_8
X_1647_ _1647_/Q _1807_/CLK _1647_/D _1612_/Y vccd vssd sg13cmos5l_dfrbpq_1
XFILLER_28_1212 vccd vssd sg13cmos5l_decap_8
XFILLER_45_2282 vccd vssd sg13cmos5l_decap_8
X_1578_ _1585_/S _1588_/A _1578_/B vccd vssd sg13cmos5l_nand2_1
XFILLER_28_1267 vccd vssd sg13cmos5l_decap_8
XFILLER_41_2146 vccd vssd sg13cmos5l_decap_8
XFILLER_41_1412 vccd vssd sg13cmos5l_decap_8
XFILLER_41_1489 vccd vssd sg13cmos5l_decap_8
XFILLER_26_112 vccd vssd sg13cmos5l_decap_8
XFILLER_3_2674 vccd vssd sg13cmos5l_decap_8
XFILLER_6_1085 vccd vssd sg13cmos5l_decap_8
XFILLER_23_1890 vccd vssd sg13cmos5l_decap_8
XFILLER_15_819 vccd vssd sg13cmos5l_decap_8
XFILLER_26_189 vccd vssd sg13cmos5l_decap_8
XFILLER_25_35 vccd vssd sg13cmos5l_decap_8
XFILLER_3_1995 vccd vssd sg13cmos5l_decap_8
XFILLER_14_329 vccd vssd sg13cmos5l_decap_8
XFILLER_41_126 vccd vssd sg13cmos5l_decap_8
XFILLER_39_2097 vccd vssd sg13cmos5l_decap_4
XFILLER_39_1374 vccd vssd sg13cmos5l_decap_8
XFILLER_23_896 vccd vssd sg13cmos5l_decap_8
XFILLER_13_2237 vccd vssd sg13cmos5l_decap_4
XFILLER_41_56 vccd vssd sg13cmos5l_decap_8
XFILLER_30_2540 vccd vssd sg13cmos5l_decap_8
XFILLER_17_1694 vccd vssd sg13cmos5l_decap_8
XFILLER_10_546 vccd vssd sg13cmos5l_decap_8
XFILLER_13_2248 vccd vssd sg13cmos5l_decap_8
Xrebuffer165 _0922_/A2 _0947_/S vccd vssd sg13cmos5l_buf_1
XFILLER_6_539 vccd vssd sg13cmos5l_decap_8
XFILLER_13_1547 vccd vssd sg13cmos5l_decap_8
XFILLER_11_1260 vccd vssd sg13cmos5l_decap_8
XFILLER_30_1883 vccd vssd sg13cmos5l_decap_8
XFILLER_2_756 vccd vssd sg13cmos5l_decap_8
XFILLER_1_266 vccd vssd sg13cmos5l_decap_8
XFILLER_8_2541 vccd vssd sg13cmos5l_decap_8
XFILLER_2_28 vccd vssd sg13cmos5l_decap_8
XFILLER_8_1862 vccd vssd sg13cmos5l_decap_8
XFILLER_44_1091 vccd vssd sg13cmos5l_decap_8
XFILLER_18_602 vccd vssd sg13cmos5l_decap_8
XFILLER_4_1715 vccd vssd sg13cmos5l_decap_8
XFILLER_41_2691 vccd vssd sg13cmos5l_decap_8
XFILLER_24_1687 vccd vssd sg13cmos5l_decap_8
XFILLER_20_1507 vccd vssd sg13cmos5l_decap_8
XFILLER_17_112 vccd vssd sg13cmos5l_decap_8
XFILLER_2_2184 vccd vssd sg13cmos5l_decap_8
XFILLER_45_476 vccd vssd sg13cmos5l_decap_8
XFILLER_37_2716 vccd vssd sg13cmos5l_decap_8
XFILLER_33_605 vccd vssd sg13cmos5l_decap_8
XFILLER_18_679 vccd vssd sg13cmos5l_decap_8
XFILLER_32_126 vccd vssd sg13cmos5l_decap_8
XFILLER_18_2137 vccd vssd sg13cmos5l_decap_8
XFILLER_18_1414 vccd vssd sg13cmos5l_decap_8
XFILLER_17_189 vccd vssd sg13cmos5l_decap_8
XFILLER_9_322 vccd vssd sg13cmos5l_decap_8
XFILLER_14_896 vccd vssd sg13cmos5l_decap_8
XFILLER_31_1647 vccd vssd sg13cmos5l_decap_8
XFILLER_9_399 vccd vssd sg13cmos5l_decap_8
XFILLER_12_1057 vccd vssd sg13cmos5l_decap_8
XFILLER_44_2709 vccd vssd sg13cmos5l_decap_8
X_1501_ _1501_/X _1591_/A0 hold371/X _1508_/S vccd vssd sg13cmos5l_mux2_1
XFILLER_29_2233 vccd vssd sg13cmos5l_decap_8
X_1432_ _1432_/X _1401_/A hold409/X _1437_/S vccd vssd sg13cmos5l_mux2_1
XFILLER_29_1543 vccd vssd sg13cmos5l_decap_4
XFILLER_9_2338 vccd vssd sg13cmos5l_decap_8
XFILLER_25_1418 vccd vssd sg13cmos5l_decap_8
X_1363_ _1364_/D status[32] _1363_/A2 _1144_/B status[24] _1010_/Y vccd vssd sg13cmos5l_a221oi_1
XFILLER_42_2433 vccd vssd sg13cmos5l_decap_8
XFILLER_7_2051 vccd vssd sg13cmos5l_decap_8
XFILLER_9_1659 vccd vssd sg13cmos5l_decap_8
Xtiedowns\[123\] status[123] vccd vssd sg13cmos5l_antennanp
X_1294_ _1294_/Y _0841_/Y _1342_/B _1429_/B vccd vssd sg13cmos5l_a21oi_1
XFILLER_7_1372 vccd vssd sg13cmos5l_decap_8
XFILLER_37_922 vccd vssd sg13cmos5l_decap_8
XFILLER_3_1225 vccd vssd sg13cmos5l_decap_8
XFILLER_20_2786 vccd vssd sg13cmos5l_decap_4
XFILLER_24_616 vccd vssd sg13cmos5l_decap_8
XFILLER_23_126 vccd vssd sg13cmos5l_decap_8
XFILLER_36_1569 vccd vssd sg13cmos5l_decap_8
XFILLER_32_693 vccd vssd sg13cmos5l_decap_8
XFILLER_20_833 vccd vssd sg13cmos5l_decap_8
XFILLER_18_1992 vccd vssd sg13cmos5l_decap_8
XFILLER_14_1834 vccd vssd sg13cmos5l_decap_8
XFILLER_34_1282 vccd vssd sg13cmos5l_decap_8
XFILLER_30_1124 vccd vssd sg13cmos5l_decap_8
XFILLER_28_1031 vccd vssd sg13cmos5l_decap_8
XFILLER_5_2703 vccd vssd sg13cmos5l_decap_8
XFILLER_43_1529 vccd vssd sg13cmos5l_decap_8
XFILLER_5_2747 vccd vssd sg13cmos5l_decap_8
XFILLER_25_2686 vccd vssd sg13cmos5l_decap_8
XFILLER_21_2517 vccd vssd sg13cmos5l_decap_8
XFILLER_8_1169 vccd vssd sg13cmos5l_decap_8
XFILLER_41_1297 vccd vssd sg13cmos5l_decap_8
XFILLER_3_2471 vccd vssd sg13cmos5l_decap_8
XFILLER_36_56 vccd vssd sg13cmos5l_decap_8
XFILLER_27_476 vccd vssd sg13cmos5l_decap_8
XFILLER_19_2413 vccd vssd sg13cmos5l_decap_8
XFILLER_15_616 vccd vssd sg13cmos5l_decap_8
XFILLER_3_1792 vccd vssd sg13cmos5l_decap_8
XFILLER_19_1701 vccd vssd sg13cmos5l_decap_8
XFILLER_14_126 vccd vssd sg13cmos5l_decap_8
XFILLER_35_1002 vccd vssd sg13cmos5l_decap_8
XFILLER_32_2602 vccd vssd sg13cmos5l_decap_8
XFILLER_30_608 vccd vssd sg13cmos5l_decap_8
XFILLER_23_693 vccd vssd sg13cmos5l_decap_8
XFILLER_19_1778 vccd vssd sg13cmos5l_decap_8
XFILLER_11_833 vccd vssd sg13cmos5l_decap_8
XFILLER_35_1068 vccd vssd sg13cmos5l_decap_8
XFILLER_10_343 vccd vssd sg13cmos5l_decap_8
XFILLER_13_2023 vccd vssd sg13cmos5l_decap_8
XFILLER_32_2679 vccd vssd sg13cmos5l_decap_8
XFILLER_32_1945 vccd vssd sg13cmos5l_decap_4
XFILLER_17_1491 vccd vssd sg13cmos5l_decap_8
XFILLER_7_826 vccd vssd sg13cmos5l_decap_8
XFILLER_13_1344 vccd vssd sg13cmos5l_decap_8
XFILLER_6_336 vccd vssd sg13cmos5l_decap_8
XFILLER_7_0 vccd vssd sg13cmos5l_decap_8
Xtiedowns\[42\] status[42] vccd vssd sg13cmos5l_antennanp
XFILLER_2_553 vccd vssd sg13cmos5l_decap_8
XFILLER_43_2742 vccd vssd sg13cmos5l_decap_8
XFILLER_24_2141 vccd vssd sg13cmos5l_decap_8
XFILLER_24_1451 vccd vssd sg13cmos5l_decap_8
XFILLER_4_1512 vccd vssd sg13cmos5l_decap_8
XFILLER_4_2268 vccd vssd sg13cmos5l_decap_8
XFILLER_20_1337 vccd vssd sg13cmos5l_decap_8
XFILLER_19_966 vccd vssd sg13cmos5l_decap_8
XFILLER_37_2513 vccd vssd sg13cmos5l_decap_8
XFILLER_34_925 vccd vssd sg13cmos5l_decap_8
XFILLER_18_476 vccd vssd sg13cmos5l_decap_8
XFILLER_4_1589 vccd vssd sg13cmos5l_decap_8
XFILLER_45_273 vccd vssd sg13cmos5l_decap_8
XFILLER_37_1801 vccd vssd sg13cmos5l_decap_8
XFILLER_33_413 vccd vssd sg13cmos5l_decap_8
XFILLER_37_1834 vccd vssd sg13cmos5l_decap_8
XFILLER_18_1211 vccd vssd sg13cmos5l_decap_8
XFILLER_42_980 vccd vssd sg13cmos5l_decap_8
Xclkbuf_5_23_0_SCK _1809_/CLK clkbuf_3_5_0_SCK/X vccd vssd sg13cmos5l_buf_8
XFILLER_14_693 vccd vssd sg13cmos5l_decap_8
XFILLER_35_2292 vccd vssd sg13cmos5l_decap_8
XFILLER_31_1400 vccd vssd sg13cmos5l_decap_8
XFILLER_18_1288 vccd vssd sg13cmos5l_decap_8
X_0932_ _0932_/Y _0938_/A _0957_/S vccd vssd sg13cmos5l_nand2_1
X_0863_ _0863_/Y _0863_/A vccd vssd sg13cmos5l_inv_1
XFILLER_9_196 vccd vssd sg13cmos5l_decap_8
XFILLER_44_2506 vccd vssd sg13cmos5l_decap_8
XFILLER_29_2063 vccd vssd sg13cmos5l_decap_8
XFILLER_9_2135 vccd vssd sg13cmos5l_decap_8
XFILLER_44_1849 vccd vssd sg13cmos5l_decap_8
X_1415_ _1415_/X _1409_/A _1408_/Y _1414_/Y vccd vssd sg13cmos5l_a21o_1
XFILLER_9_1456 vccd vssd sg13cmos5l_decap_8
X_1346_ _1346_/Y _1344_/Y _1343_/Y _1345_/Y vccd vssd sg13cmos5l_o21ai_1
XFILLER_25_1259 vccd vssd sg13cmos5l_decap_8
XFILLER_5_1309 vccd vssd sg13cmos5l_decap_8
XFILLER_42_2296 vccd vssd sg13cmos5l_decap_4
XFILLER_42_1540 vccd vssd sg13cmos5l_decap_8
X_1277_ _1277_/Y _0845_/Y _1148_/B _1276_/Y _1275_/Y _0966_/Y vccd vssd sg13cmos5l_a221oi_1
XFILLER_3_1022 vccd vssd sg13cmos5l_decap_8
XFILLER_0_2611 vccd vssd sg13cmos5l_decap_8
XFILLER_20_2583 vccd vssd sg13cmos5l_decap_8
XFILLER_0_1932 vccd vssd sg13cmos5l_decap_8
XFILLER_37_796 vccd vssd sg13cmos5l_decap_8
XFILLER_36_2001 vccd vssd sg13cmos5l_decap_8
XFILLER_36_273 vccd vssd sg13cmos5l_decap_8
XFILLER_25_969 vccd vssd sg13cmos5l_decap_8
XFILLER_24_413 vccd vssd sg13cmos5l_decap_8
XFILLER_19_1008 vccd vssd sg13cmos5l_decap_8
XFILLER_3_1099 vccd vssd sg13cmos5l_decap_8
XFILLER_0_2688 vccd vssd sg13cmos5l_decap_8
XFILLER_18_2490 vccd vssd sg13cmos5l_decap_8
XFILLER_36_1366 vccd vssd sg13cmos5l_decap_8
XFILLER_22_14 vccd vssd sg13cmos5l_decap_8
XFILLER_20_630 vccd vssd sg13cmos5l_decap_8
XFILLER_14_1631 vccd vssd sg13cmos5l_decap_8
XFILLER_14_2365 vccd vssd sg13cmos5l_decap_8
XFILLER_0_7 vccd vssd sg13cmos5l_decap_8
Xfanout120 fanout120/X RSTB vccd vssd sg13cmos5l_buf_1
Xfanout131 _1635_/B_N fanout143/X vccd vssd sg13cmos5l_buf_1
XFILLER_9_2680 vccd vssd sg13cmos5l_decap_8
XFILLER_5_2555 vccd vssd sg13cmos5l_decap_8
Xfanout142 _1603_/B_N fanout143/X vccd vssd sg13cmos5l_buf_1
XFILLER_21_1613 vccd vssd sg13cmos5l_decap_8
XFILLER_1_2408 vccd vssd sg13cmos5l_decap_8
XFILLER_5_2588 vccd vssd sg13cmos5l_decap_8
XFILLER_41_1050 vccd vssd sg13cmos5l_decap_8
XFILLER_28_730 vccd vssd sg13cmos5l_decap_8
XFILLER_5_1876 vccd vssd sg13cmos5l_decap_8
XFILLER_43_711 vccd vssd sg13cmos5l_decap_4
XFILLER_16_903 vccd vssd sg13cmos5l_decap_8
XFILLER_1_1729 vccd vssd sg13cmos5l_decap_8
XFILLER_27_273 vccd vssd sg13cmos5l_decap_8
XFILLER_15_413 vccd vssd sg13cmos5l_decap_8
XFILLER_42_232 vccd vssd sg13cmos5l_decap_8
XFILLER_19_2254 vccd vssd sg13cmos5l_decap_8
XFILLER_15_2107 vccd vssd sg13cmos5l_decap_8
XFILLER_30_427 vccd vssd sg13cmos5l_decap_8
XFILLER_24_980 vccd vssd sg13cmos5l_decap_8
XFILLER_23_490 vccd vssd sg13cmos5l_decap_8
XFILLER_19_1575 vccd vssd sg13cmos5l_decap_8
XFILLER_15_1428 vccd vssd sg13cmos5l_decap_8
XFILLER_8_49 vccd vssd sg13cmos5l_decap_8
XFILLER_11_630 vccd vssd sg13cmos5l_decap_8
XFILLER_32_2465 vccd vssd sg13cmos5l_decap_8
XFILLER_32_1720 vccd vssd sg13cmos5l_decap_8
XFILLER_7_623 vccd vssd sg13cmos5l_decap_8
XFILLER_10_140 vccd vssd sg13cmos5l_decap_8
XFILLER_6_133 vccd vssd sg13cmos5l_decap_8
XFILLER_13_1141 vccd vssd sg13cmos5l_decap_8
XFILLER_32_1797 vccd vssd sg13cmos5l_decap_8
XFILLER_10_2752 vccd vssd sg13cmos5l_decap_8
XFILLER_3_840 vccd vssd sg13cmos5l_decap_8
XFILLER_12_91 vccd vssd sg13cmos5l_decap_8
XFILLER_2_350 vccd vssd sg13cmos5l_decap_8
XFILLER_33_7 vccd vssd sg13cmos5l_decap_8
XFILLER_26_1513 vccd vssd sg13cmos5l_decap_8
X_1200_ _1200_/Y _0858_/Y _1372_/B1 _1199_/Y _1198_/X _1486_/B vccd vssd sg13cmos5l_a221oi_1
XFILLER_43_1871 vccd vssd sg13cmos5l_decap_8
XFILLER_38_516 vccd vssd sg13cmos5l_decap_8
X_1131_ _1131_/Y status[117] wire81/X wire74/X status[125] _1309_/B1 vccd vssd sg13cmos5l_a221oi_1
XFILLER_4_2065 vccd vssd sg13cmos5l_decap_8
XFILLER_39_2619 vccd vssd sg13cmos5l_decap_8
X_1062_ _1062_/X _1057_/Y _1054_/Y _1061_/Y vccd vssd sg13cmos5l_a21o_2
XFILLER_20_1134 vccd vssd sg13cmos5l_decap_8
XFILLER_19_763 vccd vssd sg13cmos5l_decap_8
XFILLER_4_1386 vccd vssd sg13cmos5l_decap_8
XFILLER_33_210 vccd vssd sg13cmos5l_decap_8
XFILLER_18_273 vccd vssd sg13cmos5l_decap_8
XFILLER_0_1239 vccd vssd sg13cmos5l_decap_8
XFILLER_22_917 vccd vssd sg13cmos5l_decap_8
XFILLER_37_1631 vccd vssd sg13cmos5l_decap_8
XFILLER_33_287 vccd vssd sg13cmos5l_decap_8
XFILLER_21_427 vccd vssd sg13cmos5l_decap_8
XFILLER_15_980 vccd vssd sg13cmos5l_decap_8
XFILLER_15_2641 vccd vssd sg13cmos5l_decap_8
XFILLER_14_490 vccd vssd sg13cmos5l_decap_8
XFILLER_33_1539 vccd vssd sg13cmos5l_decap_4
X_0915_ _0915_/Y _0915_/A _0957_/S vccd vssd sg13cmos5l_nand2_1
XFILLER_18_1085 vccd vssd sg13cmos5l_decap_8
X_0846_ _0846_/Y status[18] vccd vssd sg13cmos5l_inv_1
XFILLER_15_1995 vccd vssd sg13cmos5l_decap_8
XFILLER_11_1848 vccd vssd sg13cmos5l_decap_8
Xoutbuffers\[73\] control[73] _1741_/Q vccd vssd sg13cmos5l_buf_8
XFILLER_44_1602 vccd vssd sg13cmos5l_decap_8
XFILLER_5_1106 vccd vssd sg13cmos5l_decap_8
XFILLER_9_1253 vccd vssd sg13cmos5l_decap_8
XFILLER_44_1679 vccd vssd sg13cmos5l_decap_8
XFILLER_42_2060 vccd vssd sg13cmos5l_decap_8
XFILLER_22_2634 vccd vssd sg13cmos5l_decap_8
X_1329_ _1329_/Y _1765_/Q _1556_/B _1544_/B vccd vssd sg13cmos5l_a21oi_1
XFILLER_25_1078 vccd vssd sg13cmos5l_decap_8
XFILLER_22_1944 vccd vssd sg13cmos5l_decap_8
XFILLER_17_14 vccd vssd sg13cmos5l_decap_8
XFILLER_20_2380 vccd vssd sg13cmos5l_decap_8
XFILLER_37_593 vccd vssd sg13cmos5l_decap_8
XFILLER_24_210 vccd vssd sg13cmos5l_decap_8
XFILLER_0_2485 vccd vssd sg13cmos5l_decap_8
XFILLER_25_766 vccd vssd sg13cmos5l_decap_8
XFILLER_13_917 vccd vssd sg13cmos5l_decap_8
XFILLER_40_725 vccd vssd sg13cmos5l_decap_8
XFILLER_36_1130 vccd vssd sg13cmos5l_decap_8
XFILLER_24_287 vccd vssd sg13cmos5l_decap_8
XFILLER_16_2416 vccd vssd sg13cmos5l_decap_8
XFILLER_12_427 vccd vssd sg13cmos5l_decap_8
XFILLER_33_2741 vccd vssd sg13cmos5l_decap_8
XFILLER_33_35 vccd vssd sg13cmos5l_decap_8
XFILLER_16_1715 vccd vssd sg13cmos5l_decap_8
XFILLER_32_1016 vccd vssd sg13cmos5l_decap_8
XFILLER_21_994 vccd vssd sg13cmos5l_decap_8
XFILLER_10_2037 vccd vssd sg13cmos5l_decap_8
XFILLER_4_637 vccd vssd sg13cmos5l_decap_8
XFILLER_10_1358 vccd vssd sg13cmos5l_decap_8
XFILLER_27_2523 vccd vssd sg13cmos5l_decap_8
XFILLER_3_147 vccd vssd sg13cmos5l_decap_8
XFILLER_43_1123 vccd vssd sg13cmos5l_decap_8
XFILLER_40_2701 vccd vssd sg13cmos5l_decap_8
XFILLER_0_854 vccd vssd sg13cmos5l_decap_8
XFILLER_5_2352 vccd vssd sg13cmos5l_decap_8
XFILLER_40_2778 vccd vssd sg13cmos5l_decap_8
XFILLER_21_2133 vccd vssd sg13cmos5l_decap_8
XFILLER_21_1421 vccd vssd sg13cmos5l_decap_4
XFILLER_1_2205 vccd vssd sg13cmos5l_decap_8
XFILLER_28_560 vccd vssd sg13cmos5l_decap_4
XFILLER_16_700 vccd vssd sg13cmos5l_decap_8
XFILLER_1_1526 vccd vssd sg13cmos5l_decap_8
XFILLER_5_1673 vccd vssd sg13cmos5l_decap_8
XFILLER_38_2630 vccd vssd sg13cmos5l_decap_8
XFILLER_21_1487 vccd vssd sg13cmos5l_decap_8
XFILLER_15_210 vccd vssd sg13cmos5l_decap_8
XFILLER_16_777 vccd vssd sg13cmos5l_decap_8
XFILLER_31_725 vccd vssd sg13cmos5l_decap_8
XFILLER_15_287 vccd vssd sg13cmos5l_decap_8
XFILLER_30_224 vccd vssd sg13cmos5l_decap_8
XFILLER_19_1372 vccd vssd sg13cmos5l_decap_8
XFILLER_15_1225 vccd vssd sg13cmos5l_decap_8
XFILLER_8_910 vccd vssd sg13cmos5l_decap_8
XFILLER_7_420 vccd vssd sg13cmos5l_decap_8
XFILLER_12_994 vccd vssd sg13cmos5l_decap_8
Xhold409 hold409/X _1677_/Q vccd vssd sg13cmos5l_dlygate4sd3_1
X_1680_ _1680_/Q _1682_/CLK _1680_/D fanout137/X vccd vssd sg13cmos5l_dfrbpq_1
XFILLER_8_987 vccd vssd sg13cmos5l_decap_8
XFILLER_7_497 vccd vssd sg13cmos5l_decap_8
XFILLER_10_2593 vccd vssd sg13cmos5l_decap_8
XFILLER_45_2667 vccd vssd sg13cmos5l_decap_8
XFILLER_45_1911 vccd vssd sg13cmos5l_decap_8
XFILLER_41_2509 vccd vssd sg13cmos5l_decap_8
XFILLER_26_2066 vccd vssd sg13cmos5l_decap_8
XFILLER_6_2149 vccd vssd sg13cmos5l_decap_8
XFILLER_45_1988 vccd vssd sg13cmos5l_decap_8
XFILLER_26_1398 vccd vssd sg13cmos5l_decap_8
XFILLER_38_357 vccd vssd sg13cmos5l_decap_8
X_1114_ _1114_/Y _1714_/Q _1114_/B vccd vssd sg13cmos5l_nand2_1
XFILLER_19_560 vccd vssd sg13cmos5l_decap_8
XFILLER_39_2427 vccd vssd sg13cmos5l_decap_8
XFILLER_1_2772 vccd vssd sg13cmos5l_decap_8
XFILLER_0_1036 vccd vssd sg13cmos5l_decap_8
XFILLER_4_1183 vccd vssd sg13cmos5l_decap_8
X_1045_ _1045_/Y _1045_/A _1046_/B _1070_/C vccd vssd sg13cmos5l_nor3_1
XFILLER_37_2173 vccd vssd sg13cmos5l_decap_8
XFILLER_22_714 vccd vssd sg13cmos5l_decap_8
XFILLER_33_2037 vccd vssd sg13cmos5l_decap_8
XFILLER_21_224 vccd vssd sg13cmos5l_decap_8
XFILLER_17_2769 vccd vssd sg13cmos5l_decap_8
XFILLER_9_70 vccd vssd sg13cmos5l_decap_8
XFILLER_15_2493 vccd vssd sg13cmos5l_decap_8
XFILLER_15_1792 vccd vssd sg13cmos5l_decap_8
XFILLER_11_2368 vccd vssd sg13cmos5l_decap_8
XFILLER_31_1082 vccd vssd sg13cmos5l_decap_8
X_0829_ _0829_/Y _0829_/A vccd vssd sg13cmos5l_inv_1
XFILLER_11_1645 vccd vssd sg13cmos5l_decap_8
XFILLER_44_2166 vccd vssd sg13cmos5l_decap_8
XFILLER_22_2431 vccd vssd sg13cmos5l_decap_8
XFILLER_6_2650 vccd vssd sg13cmos5l_decap_8
XFILLER_9_1050 vccd vssd sg13cmos5l_decap_8
XFILLER_44_1476 vccd vssd sg13cmos5l_decap_8
XFILLER_28_35 vccd vssd sg13cmos5l_decap_8
XFILLER_6_1960 vccd vssd sg13cmos5l_decap_8
XFILLER_29_357 vccd vssd sg13cmos5l_decap_8
XFILLER_2_2569 vccd vssd sg13cmos5l_decap_8
XFILLER_2_1813 vccd vssd sg13cmos5l_decap_8
XFILLER_22_1774 vccd vssd sg13cmos5l_decap_8
XFILLER_0_2282 vccd vssd sg13cmos5l_decap_8
XFILLER_44_56 vccd vssd sg13cmos5l_decap_8
XFILLER_40_511 vccd vssd sg13cmos5l_decap_8
XFILLER_16_2202 vccd vssd sg13cmos5l_decap_8
XFILLER_13_714 vccd vssd sg13cmos5l_decap_8
XFILLER_16_1512 vccd vssd sg13cmos5l_decap_8
XFILLER_9_707 vccd vssd sg13cmos5l_decap_8
XFILLER_12_224 vccd vssd sg13cmos5l_decap_8
XFILLER_8_217 vccd vssd sg13cmos5l_decap_8
XFILLER_21_791 vccd vssd sg13cmos5l_decap_8
XFILLER_33_1870 vccd vssd sg13cmos5l_decap_8
XFILLER_16_1589 vccd vssd sg13cmos5l_decap_8
XFILLER_5_924 vccd vssd sg13cmos5l_decap_8
XFILLER_29_2629 vccd vssd sg13cmos5l_decap_8
XFILLER_4_434 vccd vssd sg13cmos5l_decap_8
XFILLER_5_28 vccd vssd sg13cmos5l_decap_8
XFILLER_10_1155 vccd vssd sg13cmos5l_decap_8
XFILLER_45_1218 vccd vssd sg13cmos5l_decap_8
XFILLER_27_2353 vccd vssd sg13cmos5l_decap_8
XFILLER_7_2436 vccd vssd sg13cmos5l_decap_8
XFILLER_23_2239 vccd vssd sg13cmos5l_decap_8
XFILLER_23_1505 vccd vssd sg13cmos5l_decap_8
XFILLER_0_651 vccd vssd sg13cmos5l_decap_8
XFILLER_1_2002 vccd vssd sg13cmos5l_decap_8
XFILLER_7_1757 vccd vssd sg13cmos5l_decap_8
XFILLER_40_2575 vccd vssd sg13cmos5l_decap_8
XFILLER_40_1841 vccd vssd sg13cmos5l_decap_8
XFILLER_5_1470 vccd vssd sg13cmos5l_decap_8
XFILLER_1_2079 vccd vssd sg13cmos5l_decap_8
XFILLER_1_1323 vccd vssd sg13cmos5l_decap_8
XFILLER_21_1295 vccd vssd sg13cmos5l_decap_8
XFILLER_44_894 vccd vssd sg13cmos5l_decap_8
XFILLER_16_574 vccd vssd sg13cmos5l_decap_8
XFILLER_31_522 vccd vssd sg13cmos5l_decap_8
XFILLER_17_1309 vccd vssd sg13cmos5l_decap_8
X_1801_ _1801_/Q _1802_/CLK _1801_/D _1636_/Y vccd vssd sg13cmos5l_dfrbpq_1
XFILLER_15_1022 vccd vssd sg13cmos5l_decap_8
XFILLER_31_599 vccd vssd sg13cmos5l_decap_8
XFILLER_12_791 vccd vssd sg13cmos5l_decap_8
X_1732_ _1732_/Q _1736_/CLK _1732_/D fanout122/X vccd vssd sg13cmos5l_dfrbpq_1
XFILLER_12_1932 vccd vssd sg13cmos5l_decap_8
XFILLER_12_2666 vccd vssd sg13cmos5l_decap_8
Xhold217 hold217/X _0843_/Y vccd vssd sg13cmos5l_dlygate4sd3_1
Xhold206 hold206/X _1464_/Y vccd vssd sg13cmos5l_dlygate4sd3_1
XFILLER_15_1099 vccd vssd sg13cmos5l_decap_8
XFILLER_8_784 vccd vssd sg13cmos5l_decap_8
X_1663_ SDO _1663_/CLK _1663_/D _1601_/Y vccd vssd sg13cmos5l_dfrbpq_1
Xhold228 _0853_/A _1751_/Q vccd vssd sg13cmos5l_dlygate4sd3_1
Xhold239 _0875_/A _1707_/Q vccd vssd sg13cmos5l_dlygate4sd3_1
XFILLER_7_294 vccd vssd sg13cmos5l_decap_8
X_1594_ _1594_/X _1481_/A hold513/X _1597_/S vccd vssd sg13cmos5l_mux2_1
XFILLER_45_2464 vccd vssd sg13cmos5l_decap_8
XFILLER_41_2328 vccd vssd sg13cmos5l_decap_8
XFILLER_22_0 vccd vssd sg13cmos5l_decap_8
XFILLER_45_1785 vccd vssd sg13cmos5l_decap_8
XFILLER_41_1616 vccd vssd sg13cmos5l_decap_8
XFILLER_22_1015 vccd vssd sg13cmos5l_decap_8
XFILLER_41_1649 vccd vssd sg13cmos5l_decap_8
XFILLER_38_154 vccd vssd sg13cmos5l_decap_8
XFILLER_6_1267 vccd vssd sg13cmos5l_decap_8
Xoutbuffers\[36\] control[36] _1704_/Q vccd vssd sg13cmos5l_buf_8
XFILLER_41_319 vccd vssd sg13cmos5l_decap_8
XFILLER_39_2279 vccd vssd sg13cmos5l_decap_8
XFILLER_39_1556 vccd vssd sg13cmos5l_decap_8
X_1028_ _1028_/Y _1779_/Q _1151_/B vccd vssd sg13cmos5l_nand2b_1
XFILLER_1_1890 vccd vssd sg13cmos5l_decap_8
XFILLER_22_511 vccd vssd sg13cmos5l_decap_8
XFILLER_13_2419 vccd vssd sg13cmos5l_decap_8
XFILLER_33_1144 vccd vssd sg13cmos5l_decap_8
XFILLER_30_2722 vccd vssd sg13cmos5l_decap_8
XFILLER_22_588 vccd vssd sg13cmos5l_decap_8
XFILLER_10_728 vccd vssd sg13cmos5l_decap_8
XFILLER_30_14 vccd vssd sg13cmos5l_decap_8
XFILLER_11_2121 vccd vssd sg13cmos5l_decap_8
XFILLER_13_1729 vccd vssd sg13cmos5l_decap_8
XFILLER_11_1442 vccd vssd sg13cmos5l_decap_8
XFILLER_28_2651 vccd vssd sg13cmos5l_decap_8
XFILLER_2_938 vccd vssd sg13cmos5l_decap_8
XFILLER_1_448 vccd vssd sg13cmos5l_decap_8
XFILLER_39_56 vccd vssd sg13cmos5l_decap_8
XFILLER_24_2559 vccd vssd sg13cmos5l_decap_8
XFILLER_44_1273 vccd vssd sg13cmos5l_decap_8
XFILLER_28_1994 vccd vssd sg13cmos5l_decap_8
XFILLER_24_1847 vccd vssd sg13cmos5l_decap_8
XFILLER_29_154 vccd vssd sg13cmos5l_decap_8
XFILLER_22_2294 vccd vssd sg13cmos5l_decap_8
XFILLER_22_1571 vccd vssd sg13cmos5l_decap_8
XFILLER_2_2366 vccd vssd sg13cmos5l_decap_8
XFILLER_2_1610 vccd vssd sg13cmos5l_decap_8
XFILLER_45_658 vccd vssd sg13cmos5l_decap_8
XFILLER_39_2780 vccd vssd sg13cmos5l_decap_8
XFILLER_32_308 vccd vssd sg13cmos5l_decap_8
XFILLER_26_861 vccd vssd sg13cmos5l_decap_8
XFILLER_2_1687 vccd vssd sg13cmos5l_decap_8
XFILLER_41_831 vccd vssd sg13cmos5l_decap_8
XFILLER_35_2644 vccd vssd sg13cmos5l_decap_8
XFILLER_25_371 vccd vssd sg13cmos5l_decap_8
XFILLER_16_2021 vccd vssd sg13cmos5l_decap_8
XFILLER_13_511 vccd vssd sg13cmos5l_decap_8
XFILLER_9_504 vccd vssd sg13cmos5l_decap_8
XFILLER_40_385 vccd vssd sg13cmos5l_decap_8
XFILLER_35_1965 vccd vssd sg13cmos5l_decap_8
XFILLER_16_2098 vccd vssd sg13cmos5l_decap_4
XFILLER_13_588 vccd vssd sg13cmos5l_decap_8
XFILLER_33_2390 vccd vssd sg13cmos5l_decap_8
XFILLER_31_1818 vccd vssd sg13cmos5l_decap_8
XFILLER_16_1386 vccd vssd sg13cmos5l_decap_8
Xtiedowns\[72\] status[72] vccd vssd sg13cmos5l_antennanp
XFILLER_5_721 vccd vssd sg13cmos5l_decap_8
XFILLER_12_1239 vccd vssd sg13cmos5l_decap_8
XFILLER_29_2426 vccd vssd sg13cmos5l_decap_4
XFILLER_4_231 vccd vssd sg13cmos5l_decap_8
Xclkbuf_3_5_0_SCK clkbuf_3_5_0_SCK/X clkbuf_0_SCK/X vccd vssd sg13cmos5l_buf_8
XFILLER_5_798 vccd vssd sg13cmos5l_decap_8
XFILLER_45_1015 vccd vssd sg13cmos5l_decap_8
XFILLER_29_1747 vccd vssd sg13cmos5l_decap_8
XFILLER_27_2161 vccd vssd sg13cmos5l_decap_8
XFILLER_20_91 vccd vssd sg13cmos5l_decap_8
XFILLER_23_2003 vccd vssd sg13cmos5l_decap_8
XFILLER_7_2233 vccd vssd sg13cmos5l_decap_8
XFILLER_7_1554 vccd vssd sg13cmos5l_decap_8
XFILLER_23_1335 vccd vssd sg13cmos5l_decap_8
XFILLER_3_1407 vccd vssd sg13cmos5l_decap_8
XFILLER_40_2394 vccd vssd sg13cmos5l_decap_8
XFILLER_36_614 vccd vssd sg13cmos5l_decap_8
XFILLER_1_1120 vccd vssd sg13cmos5l_decap_8
XFILLER_36_2419 vccd vssd sg13cmos5l_decap_4
XFILLER_35_168 vccd vssd sg13cmos5l_decap_8
Xoutbuffers\[126\] control[126] _1794_/Q vccd vssd sg13cmos5l_buf_8
XFILLER_23_308 vccd vssd sg13cmos5l_decap_8
XFILLER_21_1092 vccd vssd sg13cmos5l_decap_8
XFILLER_17_861 vccd vssd sg13cmos5l_decap_8
XFILLER_44_691 vccd vssd sg13cmos5l_decap_8
XFILLER_17_1106 vccd vssd sg13cmos5l_decap_8
XFILLER_16_371 vccd vssd sg13cmos5l_decap_8
XFILLER_1_1197 vccd vssd sg13cmos5l_decap_8
XFILLER_32_853 vccd vssd sg13cmos5l_decap_8
XFILLER_14_2706 vccd vssd sg13cmos5l_decap_8
XFILLER_34_1420 vccd vssd sg13cmos5l_decap_8
XFILLER_31_385 vccd vssd sg13cmos5l_decap_8
XFILLER_34_2198 vccd vssd sg13cmos5l_decap_8
X_1715_ _1715_/Q clkload3/A _1715_/D fanout127/X vccd vssd sg13cmos5l_dfrbpq_1
XFILLER_30_1339 vccd vssd sg13cmos5l_decap_8
XFILLER_8_581 vccd vssd sg13cmos5l_decap_8
X_1646_ _1646_/Q _1798_/CLK _1646_/D _1611_/Y vccd vssd sg13cmos5l_dfrbpq_1
X_1577_ _1577_/X _1542_/A hold480/X _1577_/S vccd vssd sg13cmos5l_mux2_1
XFILLER_45_2261 vccd vssd sg13cmos5l_decap_8
XFILLER_28_1246 vccd vssd sg13cmos5l_decap_8
XFILLER_45_1582 vccd vssd sg13cmos5l_decap_8
XFILLER_41_2125 vccd vssd sg13cmos5l_decap_8
XFILLER_39_441 vccd vssd sg13cmos5l_decap_8
XFILLER_3_2653 vccd vssd sg13cmos5l_decap_8
XFILLER_6_1064 vccd vssd sg13cmos5l_decap_8
XFILLER_41_1468 vccd vssd sg13cmos5l_decap_8
XFILLER_23_2592 vccd vssd sg13cmos5l_decap_8
XFILLER_27_658 vccd vssd sg13cmos5l_decap_8
XFILLER_3_1974 vccd vssd sg13cmos5l_decap_8
XFILLER_41_105 vccd vssd sg13cmos5l_decap_8
XFILLER_39_2076 vccd vssd sg13cmos5l_decap_8
XFILLER_39_2043 vccd vssd sg13cmos5l_decap_8
XFILLER_39_1320 vccd vssd sg13cmos5l_decap_8
XFILLER_26_168 vccd vssd sg13cmos5l_decap_8
XFILLER_25_14 vccd vssd sg13cmos5l_decap_8
XFILLER_14_308 vccd vssd sg13cmos5l_decap_8
XFILLER_42_639 vccd vssd sg13cmos5l_decap_8
XFILLER_19_1916 vccd vssd sg13cmos5l_decap_8
XFILLER_23_875 vccd vssd sg13cmos5l_decap_8
XFILLER_22_385 vccd vssd sg13cmos5l_decap_8
XFILLER_17_2385 vccd vssd sg13cmos5l_decap_8
XFILLER_10_525 vccd vssd sg13cmos5l_decap_8
XFILLER_13_2216 vccd vssd sg13cmos5l_decap_8
XFILLER_41_35 vccd vssd sg13cmos5l_decap_8
XFILLER_17_1673 vccd vssd sg13cmos5l_decap_8
XFILLER_6_518 vccd vssd sg13cmos5l_decap_8
XFILLER_13_1526 vccd vssd sg13cmos5l_decap_8
XFILLER_30_2596 vccd vssd sg13cmos5l_decap_8
XFILLER_2_735 vccd vssd sg13cmos5l_decap_8
XFILLER_8_2520 vccd vssd sg13cmos5l_decap_8
XFILLER_28_2492 vccd vssd sg13cmos5l_decap_8
XFILLER_24_2323 vccd vssd sg13cmos5l_decap_8
XFILLER_1_245 vccd vssd sg13cmos5l_decap_8
XFILLER_28_1791 vccd vssd sg13cmos5l_decap_8
XFILLER_8_1841 vccd vssd sg13cmos5l_decap_8
XFILLER_8_2597 vccd vssd sg13cmos5l_decap_8
XFILLER_44_1070 vccd vssd sg13cmos5l_decap_8
XFILLER_41_2670 vccd vssd sg13cmos5l_decap_8
XFILLER_20_2209 vccd vssd sg13cmos5l_decap_8
XFILLER_24_1666 vccd vssd sg13cmos5l_decap_8
XFILLER_45_455 vccd vssd sg13cmos5l_decap_8
XFILLER_18_658 vccd vssd sg13cmos5l_decap_8
XFILLER_2_2163 vccd vssd sg13cmos5l_decap_8
XFILLER_32_105 vccd vssd sg13cmos5l_decap_8
XFILLER_18_2116 vccd vssd sg13cmos5l_decap_8
XFILLER_17_168 vccd vssd sg13cmos5l_decap_8
XFILLER_2_1484 vccd vssd sg13cmos5l_decap_8
XFILLER_9_301 vccd vssd sg13cmos5l_decap_8
XFILLER_14_875 vccd vssd sg13cmos5l_decap_8
XFILLER_35_2485 vccd vssd sg13cmos5l_decap_8
XFILLER_31_2327 vccd vssd sg13cmos5l_decap_8
XFILLER_13_385 vccd vssd sg13cmos5l_decap_8
XFILLER_15_91 vccd vssd sg13cmos5l_decap_8
XFILLER_40_182 vccd vssd sg13cmos5l_decap_8
XFILLER_31_1626 vccd vssd sg13cmos5l_decap_8
XFILLER_16_1183 vccd vssd sg13cmos5l_decap_8
XFILLER_9_378 vccd vssd sg13cmos5l_decap_8
XFILLER_12_1036 vccd vssd sg13cmos5l_decap_8
XFILLER_13_2772 vccd vssd sg13cmos5l_decap_8
XFILLER_29_2212 vccd vssd sg13cmos5l_decap_8
X_1500_ _1724_/D hold231/X _1508_/S _1499_/Y vccd vssd sg13cmos5l_a21oi_1
XFILLER_9_2317 vccd vssd sg13cmos5l_decap_8
X_1431_ _1676_/D _1488_/A1 _1437_/S hold220/X vccd vssd sg13cmos5l_o21ai_1
XFILLER_5_595 vccd vssd sg13cmos5l_decap_8
XFILLER_42_2412 vccd vssd sg13cmos5l_decap_8
XFILLER_7_2030 vccd vssd sg13cmos5l_decap_8
XFILLER_9_1638 vccd vssd sg13cmos5l_decap_8
X_1362_ _1364_/C status[72] _1362_/A2 _1362_/B1 status[48] _1361_/X vccd vssd sg13cmos5l_a221oi_1
XFILLER_42_2456 vccd vssd sg13cmos5l_decap_8
XFILLER_37_901 vccd vssd sg13cmos5l_decap_8
X_1293_ _1293_/Y _1439_/B _1293_/B vccd vssd sg13cmos5l_nand2b_1
XFILLER_7_1351 vccd vssd sg13cmos5l_decap_8
Xtiedowns\[116\] status[116] vccd vssd sg13cmos5l_antennanp
XFILLER_42_1788 vccd vssd sg13cmos5l_decap_8
XFILLER_3_1204 vccd vssd sg13cmos5l_decap_8
XFILLER_20_2765 vccd vssd sg13cmos5l_decap_8
XFILLER_36_455 vccd vssd sg13cmos5l_decap_8
XFILLER_36_2249 vccd vssd sg13cmos5l_decap_8
XFILLER_36_499 vccd vssd sg13cmos5l_decap_8
XFILLER_23_105 vccd vssd sg13cmos5l_decap_8
XFILLER_36_1548 vccd vssd sg13cmos5l_decap_8
XFILLER_32_672 vccd vssd sg13cmos5l_decap_8
XFILLER_20_812 vccd vssd sg13cmos5l_decap_8
XFILLER_18_2694 vccd vssd sg13cmos5l_decap_8
XFILLER_31_182 vccd vssd sg13cmos5l_decap_8
XFILLER_18_1971 vccd vssd sg13cmos5l_decap_8
XFILLER_14_1813 vccd vssd sg13cmos5l_decap_8
XFILLER_14_2547 vccd vssd sg13cmos5l_decap_8
XFILLER_30_1103 vccd vssd sg13cmos5l_decap_8
XFILLER_20_889 vccd vssd sg13cmos5l_decap_8
XFILLER_11_49 vccd vssd sg13cmos5l_decap_8
XFILLER_12_2271 vccd vssd sg13cmos5l_decap_8
X_1629_ _1629_/Y _1629_/A _1639_/B_N vccd vssd sg13cmos5l_nor2b_1
XFILLER_25_2665 vccd vssd sg13cmos5l_decap_8
XFILLER_8_1148 vccd vssd sg13cmos5l_decap_8
XFILLER_25_1975 vccd vssd sg13cmos5l_decap_8
XFILLER_21_1817 vccd vssd sg13cmos5l_decap_4
XFILLER_3_2450 vccd vssd sg13cmos5l_decap_8
XFILLER_41_1276 vccd vssd sg13cmos5l_decap_8
XFILLER_36_35 vccd vssd sg13cmos5l_decap_8
XFILLER_27_455 vccd vssd sg13cmos5l_decap_8
XFILLER_3_1771 vccd vssd sg13cmos5l_decap_8
XFILLER_14_105 vccd vssd sg13cmos5l_decap_8
XFILLER_39_1161 vccd vssd sg13cmos5l_decap_8
XFILLER_19_2469 vccd vssd sg13cmos5l_decap_8
XFILLER_39_1194 vccd vssd sg13cmos5l_decap_8
XFILLER_35_1047 vccd vssd sg13cmos5l_decap_8
XFILLER_23_672 vccd vssd sg13cmos5l_decap_8
XFILLER_19_1757 vccd vssd sg13cmos5l_decap_8
XFILLER_11_812 vccd vssd sg13cmos5l_decap_8
XFILLER_13_2002 vccd vssd sg13cmos5l_decap_8
XFILLER_32_2658 vccd vssd sg13cmos5l_decap_8
XFILLER_32_1913 vccd vssd sg13cmos5l_decap_8
XFILLER_22_182 vccd vssd sg13cmos5l_decap_8
XFILLER_17_1470 vccd vssd sg13cmos5l_decap_8
XFILLER_7_805 vccd vssd sg13cmos5l_decap_8
XFILLER_10_322 vccd vssd sg13cmos5l_decap_8
XFILLER_6_315 vccd vssd sg13cmos5l_decap_8
XFILLER_11_889 vccd vssd sg13cmos5l_decap_8
XFILLER_13_1323 vccd vssd sg13cmos5l_decap_8
XFILLER_13_2079 vccd vssd sg13cmos5l_decap_8
XFILLER_32_1968 vccd vssd sg13cmos5l_decap_8
XFILLER_10_399 vccd vssd sg13cmos5l_decap_8
XFILLER_2_532 vccd vssd sg13cmos5l_decap_8
XFILLER_43_2721 vccd vssd sg13cmos5l_decap_8
XFILLER_26_2429 vccd vssd sg13cmos5l_decap_8
XFILLER_26_1706 vccd vssd sg13cmos5l_decap_8
XFILLER_24_2120 vccd vssd sg13cmos5l_decap_8
Xtiedowns\[35\] status[35] vccd vssd sg13cmos5l_antennanp
XFILLER_4_2247 vccd vssd sg13cmos5l_decap_8
XFILLER_8_2394 vccd vssd sg13cmos5l_decap_8
XFILLER_20_1316 vccd vssd sg13cmos5l_decap_8
XFILLER_19_945 vccd vssd sg13cmos5l_decap_8
XFILLER_4_1568 vccd vssd sg13cmos5l_decap_8
XFILLER_45_252 vccd vssd sg13cmos5l_decap_8
XFILLER_34_904 vccd vssd sg13cmos5l_decap_8
XFILLER_18_455 vccd vssd sg13cmos5l_decap_8
XFILLER_2_1281 vccd vssd sg13cmos5l_decap_8
XFILLER_37_2569 vccd vssd sg13cmos5l_decap_8
XFILLER_21_609 vccd vssd sg13cmos5l_decap_8
X_0931_ _0931_/Y hold294/X _0929_/Y _0930_/Y vccd vssd sg13cmos5l_a21oi_1
XFILLER_20_119 vccd vssd sg13cmos5l_decap_8
XFILLER_14_672 vccd vssd sg13cmos5l_decap_8
XFILLER_41_491 vccd vssd sg13cmos5l_decap_8
XFILLER_31_2135 vccd vssd sg13cmos5l_decap_8
XFILLER_18_1267 vccd vssd sg13cmos5l_decap_8
XFILLER_13_182 vccd vssd sg13cmos5l_decap_8
X_0862_ _0862_/Y mask_rev_in[13] vccd vssd sg13cmos5l_inv_1
XFILLER_9_175 vccd vssd sg13cmos5l_decap_8
XFILLER_31_1456 vccd vssd sg13cmos5l_decap_4
XFILLER_13_2591 vccd vssd sg13cmos5l_decap_8
XFILLER_6_882 vccd vssd sg13cmos5l_decap_8
XFILLER_13_1890 vccd vssd sg13cmos5l_decap_8
XFILLER_5_392 vccd vssd sg13cmos5l_decap_8
XFILLER_9_2114 vccd vssd sg13cmos5l_decap_8
XFILLER_44_1828 vccd vssd sg13cmos5l_decap_8
X_1414_ _1414_/Y _1488_/A1 _1407_/A _1412_/B _1409_/X vccd vssd sg13cmos5l_a22oi_1
XFILLER_9_1435 vccd vssd sg13cmos5l_decap_8
XFILLER_25_1238 vccd vssd sg13cmos5l_decap_8
X_1345_ _1345_/Y mask_rev_in[1] _1058_/Y _1063_/X vccd vssd sg13cmos5l_a21oi_1
XFILLER_42_2275 vccd vssd sg13cmos5l_decap_8
XFILLER_3_1001 vccd vssd sg13cmos5l_decap_8
X_1276_ _1276_/Y status[10] _1147_/B _1148_/B vccd vssd sg13cmos5l_a21oi_1
XFILLER_42_1596 vccd vssd sg13cmos5l_decap_8
XFILLER_20_2562 vccd vssd sg13cmos5l_decap_8
XFILLER_37_775 vccd vssd sg13cmos5l_decap_8
XFILLER_36_252 vccd vssd sg13cmos5l_decap_8
XFILLER_20_1861 vccd vssd sg13cmos5l_decap_8
XFILLER_3_1078 vccd vssd sg13cmos5l_decap_8
XFILLER_0_2667 vccd vssd sg13cmos5l_decap_8
XFILLER_0_1911 vccd vssd sg13cmos5l_decap_8
Xwire78 wire78/X wire78/A vccd vssd sg13cmos5l_buf_8
XFILLER_25_948 vccd vssd sg13cmos5l_decap_8
XFILLER_36_1301 vccd vssd sg13cmos5l_decap_8
XFILLER_24_469 vccd vssd sg13cmos5l_decap_8
XFILLER_0_1988 vccd vssd sg13cmos5l_decap_8
XFILLER_12_609 vccd vssd sg13cmos5l_decap_8
XFILLER_36_1345 vccd vssd sg13cmos5l_decap_8
XFILLER_11_119 vccd vssd sg13cmos5l_decap_8
XFILLER_14_1610 vccd vssd sg13cmos5l_decap_8
XFILLER_14_2333 vccd vssd sg13cmos5l_decap_4
XFILLER_14_2344 vccd vssd sg13cmos5l_decap_8
XFILLER_10_2219 vccd vssd sg13cmos5l_decap_8
XFILLER_34_1091 vccd vssd sg13cmos5l_decap_4
XFILLER_20_686 vccd vssd sg13cmos5l_decap_8
XFILLER_4_819 vccd vssd sg13cmos5l_decap_8
XFILLER_14_1687 vccd vssd sg13cmos5l_decap_8
XFILLER_3_329 vccd vssd sg13cmos5l_decap_8
XFILLER_27_2749 vccd vssd sg13cmos5l_decap_8
Xfanout110 _1547_/A hold518/X vccd vssd sg13cmos5l_buf_1
Xfanout121 fanout121/X fanout124/X vccd vssd sg13cmos5l_buf_1
Xfanout143 fanout143/X RSTB vccd vssd sg13cmos5l_buf_1
Xfanout132 _1638_/B_N fanout135/X vccd vssd sg13cmos5l_buf_1
XFILLER_5_2534 vccd vssd sg13cmos5l_decap_8
XFILLER_25_1783 vccd vssd sg13cmos5l_decap_8
XFILLER_1_1708 vccd vssd sg13cmos5l_decap_8
XFILLER_5_1855 vccd vssd sg13cmos5l_decap_8
XFILLER_27_252 vccd vssd sg13cmos5l_decap_8
XFILLER_21_1669 vccd vssd sg13cmos5l_decap_8
XFILLER_16_959 vccd vssd sg13cmos5l_decap_8
XFILLER_15_469 vccd vssd sg13cmos5l_decap_8
XFILLER_31_929 vccd vssd sg13cmos5l_decap_8
XFILLER_30_406 vccd vssd sg13cmos5l_decap_8
XFILLER_19_1554 vccd vssd sg13cmos5l_decap_8
XFILLER_42_299 vccd vssd sg13cmos5l_decap_8
XFILLER_32_2444 vccd vssd sg13cmos5l_decap_8
XFILLER_15_1407 vccd vssd sg13cmos5l_decap_8
XFILLER_8_28 vccd vssd sg13cmos5l_decap_8
XFILLER_36_1890 vccd vssd sg13cmos5l_decap_8
XFILLER_7_602 vccd vssd sg13cmos5l_decap_8
XFILLER_32_1776 vccd vssd sg13cmos5l_decap_8
XFILLER_6_112 vccd vssd sg13cmos5l_decap_8
XFILLER_11_686 vccd vssd sg13cmos5l_decap_8
XFILLER_13_1120 vccd vssd sg13cmos5l_decap_8
XFILLER_7_679 vccd vssd sg13cmos5l_decap_8
XFILLER_10_196 vccd vssd sg13cmos5l_decap_8
XFILLER_12_70 vccd vssd sg13cmos5l_decap_8
XFILLER_6_189 vccd vssd sg13cmos5l_decap_8
XFILLER_13_1197 vccd vssd sg13cmos5l_decap_8
XFILLER_3_896 vccd vssd sg13cmos5l_decap_8
XFILLER_43_2562 vccd vssd sg13cmos5l_decap_4
XFILLER_26_7 vccd vssd sg13cmos5l_decap_8
XFILLER_8_2191 vccd vssd sg13cmos5l_decap_8
XFILLER_43_2584 vccd vssd sg13cmos5l_decap_8
X_1130_ _1662_/D hold192/X _1390_/A _1128_/Y _1129_/Y vccd vssd sg13cmos5l_a22oi_1
XFILLER_4_2044 vccd vssd sg13cmos5l_decap_8
XFILLER_20_1113 vccd vssd sg13cmos5l_decap_8
XFILLER_19_742 vccd vssd sg13cmos5l_decap_8
X_1061_ _1061_/Y _1675_/Q _1382_/A _1060_/Y vccd vssd sg13cmos5l_o21ai_1
XFILLER_18_252 vccd vssd sg13cmos5l_decap_8
XFILLER_0_1218 vccd vssd sg13cmos5l_decap_8
XFILLER_4_1365 vccd vssd sg13cmos5l_decap_8
XFILLER_37_1610 vccd vssd sg13cmos5l_decap_8
XFILLER_33_266 vccd vssd sg13cmos5l_decap_8
XFILLER_21_406 vccd vssd sg13cmos5l_decap_8
XFILLER_15_2620 vccd vssd sg13cmos5l_decap_8
XFILLER_33_1518 vccd vssd sg13cmos5l_decap_8
XFILLER_18_1064 vccd vssd sg13cmos5l_decap_8
X_0914_ _0914_/X _0914_/A _0914_/B vccd vssd sg13cmos5l_xor2_1
X_0845_ _0845_/Y status[2] vccd vssd sg13cmos5l_inv_1
XFILLER_15_2697 vccd vssd sg13cmos5l_decap_8
XFILLER_15_1974 vccd vssd sg13cmos5l_decap_8
XFILLER_11_1827 vccd vssd sg13cmos5l_decap_8
XFILLER_44_2359 vccd vssd sg13cmos5l_decap_8
Xoutbuffers\[66\] control[66] _1734_/Q vccd vssd sg13cmos5l_buf_8
XFILLER_9_1232 vccd vssd sg13cmos5l_decap_8
XFILLER_26_2782 vccd vssd sg13cmos5l_decap_8
XFILLER_22_2613 vccd vssd sg13cmos5l_decap_8
XFILLER_44_1658 vccd vssd sg13cmos5l_decap_8
XFILLER_25_1057 vccd vssd sg13cmos5l_decap_8
XFILLER_25_1035 vccd vssd sg13cmos5l_decap_4
X_1328_ _1328_/Y _1773_/Q _1192_/B _0961_/Y vccd vssd sg13cmos5l_o21ai_1
XFILLER_22_1923 vccd vssd sg13cmos5l_decap_8
XFILLER_42_1393 vccd vssd sg13cmos5l_decap_8
X_1259_ _1259_/Y _0831_/A _0885_/X _1256_/Y _1258_/Y _1391_/A2 vccd vssd sg13cmos5l_a221oi_1
XFILLER_37_572 vccd vssd sg13cmos5l_decap_8
XFILLER_22_1989 vccd vssd sg13cmos5l_decap_8
XFILLER_0_2464 vccd vssd sg13cmos5l_decap_8
XFILLER_25_745 vccd vssd sg13cmos5l_decap_8
XFILLER_40_704 vccd vssd sg13cmos5l_decap_8
XFILLER_33_14 vccd vssd sg13cmos5l_decap_8
XFILLER_24_266 vccd vssd sg13cmos5l_decap_8
XFILLER_0_1785 vccd vssd sg13cmos5l_decap_8
XFILLER_12_406 vccd vssd sg13cmos5l_decap_8
XFILLER_36_1153 vccd vssd sg13cmos5l_decap_8
XFILLER_33_2720 vccd vssd sg13cmos5l_decap_8
XFILLER_36_1186 vccd vssd sg13cmos5l_decap_8
XFILLER_21_973 vccd vssd sg13cmos5l_decap_8
XFILLER_20_483 vccd vssd sg13cmos5l_decap_8
XFILLER_10_2016 vccd vssd sg13cmos5l_decap_8
XFILLER_4_616 vccd vssd sg13cmos5l_decap_8
XFILLER_14_1484 vccd vssd sg13cmos5l_decap_8
XFILLER_3_126 vccd vssd sg13cmos5l_decap_8
XFILLER_10_1337 vccd vssd sg13cmos5l_decap_8
XFILLER_27_2502 vccd vssd sg13cmos5l_decap_8
XFILLER_27_1823 vccd vssd sg13cmos5l_decap_8
XFILLER_27_2579 vccd vssd sg13cmos5l_decap_8
XFILLER_27_1834 vccd vssd sg13cmos5l_decap_4
XFILLER_0_833 vccd vssd sg13cmos5l_decap_8
Xclkbuf_5_22_0_SCK _1807_/CLK clkbuf_3_5_0_SCK/X vccd vssd sg13cmos5l_buf_8
XFILLER_5_2331 vccd vssd sg13cmos5l_decap_8
XFILLER_7_1939 vccd vssd sg13cmos5l_decap_8
XFILLER_40_2757 vccd vssd sg13cmos5l_decap_8
XFILLER_21_1400 vccd vssd sg13cmos5l_decap_8
XFILLER_5_1652 vccd vssd sg13cmos5l_decap_8
XFILLER_1_1505 vccd vssd sg13cmos5l_decap_8
XFILLER_21_1466 vccd vssd sg13cmos5l_decap_8
XFILLER_16_756 vccd vssd sg13cmos5l_decap_8
XFILLER_43_564 vccd vssd sg13cmos5l_decap_8
XFILLER_38_2686 vccd vssd sg13cmos5l_decap_8
XFILLER_31_704 vccd vssd sg13cmos5l_decap_8
XFILLER_30_203 vccd vssd sg13cmos5l_decap_8
XFILLER_15_266 vccd vssd sg13cmos5l_decap_8
XFILLER_34_2539 vccd vssd sg13cmos5l_decap_8
XFILLER_34_1827 vccd vssd sg13cmos5l_decap_4
XFILLER_19_1351 vccd vssd sg13cmos5l_decap_8
XFILLER_15_1204 vccd vssd sg13cmos5l_decap_8
XFILLER_12_973 vccd vssd sg13cmos5l_decap_8
XFILLER_32_1540 vccd vssd sg13cmos5l_decap_8
XFILLER_23_91 vccd vssd sg13cmos5l_decap_8
XFILLER_8_966 vccd vssd sg13cmos5l_decap_8
XFILLER_11_483 vccd vssd sg13cmos5l_decap_8
XFILLER_7_476 vccd vssd sg13cmos5l_decap_8
XFILLER_10_2550 vccd vssd sg13cmos5l_decap_8
XFILLER_10_2572 vccd vssd sg13cmos5l_decap_8
XFILLER_28_1609 vccd vssd sg13cmos5l_decap_8
XFILLER_45_2646 vccd vssd sg13cmos5l_decap_8
XFILLER_3_693 vccd vssd sg13cmos5l_decap_8
XFILLER_6_2128 vccd vssd sg13cmos5l_decap_8
XFILLER_45_1967 vccd vssd sg13cmos5l_decap_8
XFILLER_38_336 vccd vssd sg13cmos5l_decap_8
XFILLER_26_1377 vccd vssd sg13cmos5l_decap_8
XFILLER_6_1449 vccd vssd sg13cmos5l_decap_8
XFILLER_39_2406 vccd vssd sg13cmos5l_decap_8
X_1113_ _1113_/X _0868_/Y _1337_/B _1114_/B vccd vssd sg13cmos5l_a21o_1
XFILLER_4_1162 vccd vssd sg13cmos5l_decap_8
X_1044_ _1044_/Y _1731_/Q _1036_/Y _1040_/Y vccd vssd sg13cmos5l_o21ai_1
XFILLER_1_2751 vccd vssd sg13cmos5l_decap_8
XFILLER_0_1015 vccd vssd sg13cmos5l_decap_8
XFILLER_34_542 vccd vssd sg13cmos5l_decap_8
XFILLER_0_84 vccd vssd sg13cmos5l_decap_8
XFILLER_39_1749 vccd vssd sg13cmos5l_decap_8
XFILLER_37_2152 vccd vssd sg13cmos5l_decap_8
XFILLER_21_203 vccd vssd sg13cmos5l_decap_8
XFILLER_37_1440 vccd vssd sg13cmos5l_decap_8
XFILLER_33_2016 vccd vssd sg13cmos5l_decap_8
XFILLER_17_2748 vccd vssd sg13cmos5l_decap_8
XFILLER_33_1304 vccd vssd sg13cmos5l_decap_8
XFILLER_15_2472 vccd vssd sg13cmos5l_decap_8
XFILLER_15_1771 vccd vssd sg13cmos5l_decap_8
XFILLER_11_1624 vccd vssd sg13cmos5l_decap_8
XFILLER_11_2347 vccd vssd sg13cmos5l_decap_8
X_0828_ _0828_/Y _0828_/A vccd vssd sg13cmos5l_inv_1
XFILLER_44_2145 vccd vssd sg13cmos5l_decap_8
XFILLER_44_1455 vccd vssd sg13cmos5l_decap_8
XFILLER_28_14 vccd vssd sg13cmos5l_decap_8
XFILLER_26_2590 vccd vssd sg13cmos5l_decap_4
XFILLER_22_2410 vccd vssd sg13cmos5l_decap_8
XFILLER_29_336 vccd vssd sg13cmos5l_decap_8
XFILLER_22_2487 vccd vssd sg13cmos5l_decap_8
XFILLER_22_1753 vccd vssd sg13cmos5l_decap_8
XFILLER_2_2548 vccd vssd sg13cmos5l_decap_8
XFILLER_38_870 vccd vssd sg13cmos5l_decap_8
XFILLER_44_35 vccd vssd sg13cmos5l_decap_8
XFILLER_2_1869 vccd vssd sg13cmos5l_decap_8
XFILLER_0_2261 vccd vssd sg13cmos5l_decap_8
XFILLER_25_553 vccd vssd sg13cmos5l_decap_8
XFILLER_0_1582 vccd vssd sg13cmos5l_decap_8
XFILLER_12_203 vccd vssd sg13cmos5l_decap_8
XFILLER_33_2594 vccd vssd sg13cmos5l_decap_8
XFILLER_21_770 vccd vssd sg13cmos5l_decap_8
XFILLER_16_1568 vccd vssd sg13cmos5l_decap_8
XFILLER_33_1882 vccd vssd sg13cmos5l_decap_4
XFILLER_20_280 vccd vssd sg13cmos5l_decap_8
XFILLER_5_903 vccd vssd sg13cmos5l_decap_8
XFILLER_29_2608 vccd vssd sg13cmos5l_decap_8
XFILLER_4_413 vccd vssd sg13cmos5l_decap_8
XFILLER_10_1134 vccd vssd sg13cmos5l_decap_8
XFILLER_14_1281 vccd vssd sg13cmos5l_decap_8
XFILLER_27_2332 vccd vssd sg13cmos5l_decap_8
XFILLER_7_2415 vccd vssd sg13cmos5l_decap_8
XFILLER_0_630 vccd vssd sg13cmos5l_decap_8
XFILLER_27_1664 vccd vssd sg13cmos5l_decap_8
XFILLER_23_2218 vccd vssd sg13cmos5l_decap_8
XFILLER_7_1736 vccd vssd sg13cmos5l_decap_8
XFILLER_40_2554 vccd vssd sg13cmos5l_decap_8
XFILLER_40_1820 vccd vssd sg13cmos5l_decap_8
XFILLER_1_2058 vccd vssd sg13cmos5l_decap_8
XFILLER_1_1302 vccd vssd sg13cmos5l_decap_8
XFILLER_40_1897 vccd vssd sg13cmos5l_decap_8
XFILLER_21_1274 vccd vssd sg13cmos5l_decap_8
XFILLER_18_91 vccd vssd sg13cmos5l_decap_8
XFILLER_31_501 vccd vssd sg13cmos5l_decap_8
XFILLER_16_553 vccd vssd sg13cmos5l_decap_8
XFILLER_1_1379 vccd vssd sg13cmos5l_decap_8
XFILLER_38_2483 vccd vssd sg13cmos5l_decap_8
XFILLER_34_2336 vccd vssd sg13cmos5l_decap_8
XFILLER_38_1782 vccd vssd sg13cmos5l_decap_8
XFILLER_31_578 vccd vssd sg13cmos5l_decap_8
X_1800_ _1800_/Q _1802_/CLK _1800_/D _1635_/Y vccd vssd sg13cmos5l_dfrbpq_1
XFILLER_15_1001 vccd vssd sg13cmos5l_decap_8
XFILLER_12_770 vccd vssd sg13cmos5l_decap_8
X_1731_ _1731_/Q clkload5/A _1731_/D fanout125/X vccd vssd sg13cmos5l_dfrbpq_1
XFILLER_32_2071 vccd vssd sg13cmos5l_decap_8
XFILLER_15_1078 vccd vssd sg13cmos5l_decap_8
XFILLER_8_763 vccd vssd sg13cmos5l_decap_8
XFILLER_11_280 vccd vssd sg13cmos5l_decap_8
XFILLER_12_1911 vccd vssd sg13cmos5l_decap_8
XFILLER_12_2645 vccd vssd sg13cmos5l_decap_8
Xhold207 _1409_/A _1645_/Q vccd vssd sg13cmos5l_dlygate4sd3_1
X_1662_ _1662_/Q _1662_/CLK _1662_/D _1602_/Y vccd vssd sg13cmos5l_dfrbpq_1
XFILLER_7_273 vccd vssd sg13cmos5l_decap_8
Xhold229 hold229/X _0853_/Y vccd vssd sg13cmos5l_dlygate4sd3_1
Xhold218 _1750_/D _1536_/Y vccd vssd sg13cmos5l_dlygate4sd3_1
XFILLER_10_2380 vccd vssd sg13cmos5l_decap_8
XFILLER_12_1988 vccd vssd sg13cmos5l_decap_8
X_1593_ _1791_/D _1562_/A hold519/X _1597_/S vccd vssd sg13cmos5l_mux2_1
XFILLER_4_980 vccd vssd sg13cmos5l_decap_8
XFILLER_45_2443 vccd vssd sg13cmos5l_decap_8
XFILLER_41_2307 vccd vssd sg13cmos5l_decap_8
XFILLER_3_490 vccd vssd sg13cmos5l_decap_8
XFILLER_45_1764 vccd vssd sg13cmos5l_decap_8
XFILLER_39_645 vccd vssd sg13cmos5l_decap_8
XFILLER_26_1174 vccd vssd sg13cmos5l_decap_8
XFILLER_6_1246 vccd vssd sg13cmos5l_decap_8
XFILLER_38_133 vccd vssd sg13cmos5l_decap_8
XFILLER_23_2774 vccd vssd sg13cmos5l_decap_8
XFILLER_15_0 vccd vssd sg13cmos5l_decap_8
Xoutbuffers\[29\] control[29] _1697_/Q vccd vssd sg13cmos5l_buf_8
XFILLER_39_1535 vccd vssd sg13cmos5l_decap_8
X_1027_ _1027_/X _1026_/Y _1025_/Y _1151_/B vccd vssd sg13cmos5l_a21o_1
XFILLER_35_884 vccd vssd sg13cmos5l_decap_8
XFILLER_34_350 vccd vssd sg13cmos5l_decap_8
XFILLER_22_567 vccd vssd sg13cmos5l_decap_8
XFILLER_10_707 vccd vssd sg13cmos5l_decap_8
XFILLER_14_49 vccd vssd sg13cmos5l_decap_8
Xtiedowns\[1\] status[1] vccd vssd sg13cmos5l_antennanp
XFILLER_30_2701 vccd vssd sg13cmos5l_decap_8
XFILLER_11_2100 vccd vssd sg13cmos5l_decap_8
XFILLER_13_1708 vccd vssd sg13cmos5l_decap_8
XFILLER_17_1888 vccd vssd sg13cmos5l_decap_8
XFILLER_30_2778 vccd vssd sg13cmos5l_decap_8
XFILLER_11_1421 vccd vssd sg13cmos5l_decap_8
Xfanout1 _1597_/S _1595_/S vccd vssd sg13cmos5l_buf_1
XFILLER_28_2630 vccd vssd sg13cmos5l_decap_8
XFILLER_2_917 vccd vssd sg13cmos5l_decap_8
XFILLER_11_1498 vccd vssd sg13cmos5l_decap_8
XFILLER_1_427 vccd vssd sg13cmos5l_decap_8
XFILLER_8_2735 vccd vssd sg13cmos5l_decap_8
XFILLER_39_35 vccd vssd sg13cmos5l_decap_8
XFILLER_28_1973 vccd vssd sg13cmos5l_decap_8
XFILLER_24_2538 vccd vssd sg13cmos5l_decap_8
XFILLER_8_2779 vccd vssd sg13cmos5l_decap_8
XFILLER_44_1252 vccd vssd sg13cmos5l_decap_8
XFILLER_24_1826 vccd vssd sg13cmos5l_decap_8
XFILLER_29_133 vccd vssd sg13cmos5l_decap_8
XFILLER_2_2345 vccd vssd sg13cmos5l_decap_8
XFILLER_6_2492 vccd vssd sg13cmos5l_decap_8
XFILLER_45_637 vccd vssd sg13cmos5l_decap_8
XFILLER_22_2284 vccd vssd sg13cmos5l_decap_8
XFILLER_22_1550 vccd vssd sg13cmos5l_decap_8
XFILLER_44_147 vccd vssd sg13cmos5l_decap_8
XFILLER_26_840 vccd vssd sg13cmos5l_decap_8
XFILLER_2_1666 vccd vssd sg13cmos5l_decap_8
XFILLER_41_810 vccd vssd sg13cmos5l_decap_8
XFILLER_25_350 vccd vssd sg13cmos5l_decap_8
XFILLER_35_2623 vccd vssd sg13cmos5l_decap_8
XFILLER_16_2000 vccd vssd sg13cmos5l_decap_8
X_1622__153 _1658_/CLK _1631__159/A vccd vssd sg13cmos5l_inv_1
XFILLER_35_1922 vccd vssd sg13cmos5l_decap_8
XFILLER_13_567 vccd vssd sg13cmos5l_decap_8
XFILLER_41_887 vccd vssd sg13cmos5l_decap_8
XFILLER_40_364 vccd vssd sg13cmos5l_decap_8
XFILLER_16_2077 vccd vssd sg13cmos5l_decap_8
XFILLER_16_1365 vccd vssd sg13cmos5l_decap_8
XFILLER_12_1218 vccd vssd sg13cmos5l_decap_8
XFILLER_5_700 vccd vssd sg13cmos5l_decap_8
Xtiedowns\[65\] status[65] vccd vssd sg13cmos5l_antennanp
XFILLER_29_2405 vccd vssd sg13cmos5l_decap_8
XFILLER_4_210 vccd vssd sg13cmos5l_decap_8
XFILLER_29_1726 vccd vssd sg13cmos5l_decap_8
XFILLER_20_70 vccd vssd sg13cmos5l_decap_8
XFILLER_5_777 vccd vssd sg13cmos5l_decap_8
XFILLER_4_287 vccd vssd sg13cmos5l_decap_8
XFILLER_7_2212 vccd vssd sg13cmos5l_decap_8
XFILLER_42_1904 vccd vssd sg13cmos5l_decap_4
XFILLER_27_1483 vccd vssd sg13cmos5l_decap_8
XFILLER_23_1314 vccd vssd sg13cmos5l_decap_8
XFILLER_1_994 vccd vssd sg13cmos5l_decap_8
XFILLER_7_1533 vccd vssd sg13cmos5l_decap_8
XFILLER_7_2289 vccd vssd sg13cmos5l_decap_8
XFILLER_40_2373 vccd vssd sg13cmos5l_decap_8
XFILLER_40_1683 vccd vssd sg13cmos5l_decap_8
XFILLER_35_147 vccd vssd sg13cmos5l_decap_8
XFILLER_21_1071 vccd vssd sg13cmos5l_decap_8
XFILLER_17_840 vccd vssd sg13cmos5l_decap_8
XFILLER_16_350 vccd vssd sg13cmos5l_decap_8
XFILLER_1_1176 vccd vssd sg13cmos5l_decap_8
XFILLER_44_670 vccd vssd sg13cmos5l_decap_8
Xoutbuffers\[119\] control[119] _1787_/Q vccd vssd sg13cmos5l_buf_8
XFILLER_34_2111 vccd vssd sg13cmos5l_decap_8
XFILLER_32_832 vccd vssd sg13cmos5l_decap_8
XFILLER_34_2177 vccd vssd sg13cmos5l_decap_8
XFILLER_31_364 vccd vssd sg13cmos5l_decap_8
XFILLER_30_2008 vccd vssd sg13cmos5l_decap_8
XFILLER_30_1318 vccd vssd sg13cmos5l_decap_8
X_1714_ _1714_/Q clkload0/A _1714_/D fanout127/X vccd vssd sg13cmos5l_dfrbpq_1
XFILLER_8_560 vccd vssd sg13cmos5l_decap_8
X_1645_ _1645_/Q _1798_/CLK _1645_/D _1610_/Y vccd vssd sg13cmos5l_dfrbpq_1
XFILLER_8_2009 vccd vssd sg13cmos5l_decap_8
XFILLER_12_1785 vccd vssd sg13cmos5l_decap_8
XFILLER_45_2240 vccd vssd sg13cmos5l_decap_8
X_1576_ _1576_/X _1528_/A hold498/X _1577_/S vccd vssd sg13cmos5l_mux2_1
XFILLER_41_2104 vccd vssd sg13cmos5l_decap_8
XFILLER_45_1561 vccd vssd sg13cmos5l_decap_8
XFILLER_41_1447 vccd vssd sg13cmos5l_decap_8
XFILLER_23_2571 vccd vssd sg13cmos5l_decap_8
XFILLER_3_2632 vccd vssd sg13cmos5l_decap_8
XFILLER_6_1043 vccd vssd sg13cmos5l_decap_8
XFILLER_3_1953 vccd vssd sg13cmos5l_decap_8
XFILLER_42_618 vccd vssd sg13cmos5l_decap_8
XFILLER_26_147 vccd vssd sg13cmos5l_decap_8
XFILLER_19_2629 vccd vssd sg13cmos5l_decap_8
XFILLER_35_670 vccd vssd sg13cmos5l_decap_8
XFILLER_17_2320 vccd vssd sg13cmos5l_decap_8
XFILLER_35_1218 vccd vssd sg13cmos5l_decap_8
XFILLER_23_854 vccd vssd sg13cmos5l_decap_8
XFILLER_17_2364 vccd vssd sg13cmos5l_decap_8
XFILLER_41_14 vccd vssd sg13cmos5l_decap_8
XFILLER_22_364 vccd vssd sg13cmos5l_decap_8
XFILLER_17_1652 vccd vssd sg13cmos5l_decap_8
XFILLER_10_504 vccd vssd sg13cmos5l_decap_8
XFILLER_13_1505 vccd vssd sg13cmos5l_decap_8
XFILLER_30_2575 vccd vssd sg13cmos5l_decap_8
XFILLER_2_714 vccd vssd sg13cmos5l_decap_8
XFILLER_1_224 vccd vssd sg13cmos5l_decap_8
XFILLER_11_1295 vccd vssd sg13cmos5l_decap_8
XFILLER_28_2471 vccd vssd sg13cmos5l_decap_8
XFILLER_24_2302 vccd vssd sg13cmos5l_decap_8
XFILLER_8_1820 vccd vssd sg13cmos5l_decap_8
XFILLER_28_1770 vccd vssd sg13cmos5l_decap_8
XFILLER_4_2429 vccd vssd sg13cmos5l_decap_8
XFILLER_8_2576 vccd vssd sg13cmos5l_decap_8
XFILLER_24_1645 vccd vssd sg13cmos5l_decap_8
XFILLER_22_2081 vccd vssd sg13cmos5l_decap_8
XFILLER_2_2142 vccd vssd sg13cmos5l_decap_8
XFILLER_8_1897 vccd vssd sg13cmos5l_decap_8
XFILLER_45_434 vccd vssd sg13cmos5l_decap_8
XFILLER_41_1992 vccd vssd sg13cmos5l_decap_8
XFILLER_18_637 vccd vssd sg13cmos5l_decap_8
XFILLER_17_147 vccd vssd sg13cmos5l_decap_8
XFILLER_2_1463 vccd vssd sg13cmos5l_decap_8
XFILLER_26_692 vccd vssd sg13cmos5l_decap_8
XFILLER_14_854 vccd vssd sg13cmos5l_decap_8
XFILLER_41_684 vccd vssd sg13cmos5l_decap_8
XFILLER_40_161 vccd vssd sg13cmos5l_decap_8
XFILLER_35_2464 vccd vssd sg13cmos5l_decap_8
XFILLER_31_2306 vccd vssd sg13cmos5l_decap_8
XFILLER_18_1449 vccd vssd sg13cmos5l_decap_8
XFILLER_13_364 vccd vssd sg13cmos5l_decap_8
XFILLER_15_70 vccd vssd sg13cmos5l_decap_8
XFILLER_31_1605 vccd vssd sg13cmos5l_decap_8
XFILLER_16_1162 vccd vssd sg13cmos5l_decap_8
XFILLER_9_357 vccd vssd sg13cmos5l_decap_8
XFILLER_12_1015 vccd vssd sg13cmos5l_decap_8
XFILLER_31_91 vccd vssd sg13cmos5l_decap_8
XFILLER_5_574 vccd vssd sg13cmos5l_decap_8
X_1430_ _1430_/Y _1430_/A _1437_/S vccd vssd sg13cmos5l_nand2_1
XFILLER_29_1523 vccd vssd sg13cmos5l_decap_8
X_1361_ _1361_/X status[40] _1361_/B vccd vssd sg13cmos5l_and2_1
XFILLER_9_1617 vccd vssd sg13cmos5l_decap_8
XFILLER_29_1589 vccd vssd sg13cmos5l_decap_8
XFILLER_42_1734 vccd vssd sg13cmos5l_decap_8
X_1292_ _1293_/B _1702_/Q _1463_/B _1453_/B _1694_/Q vccd vssd sg13cmos5l_a22oi_1
XFILLER_27_1280 vccd vssd sg13cmos5l_decap_8
XFILLER_1_791 vccd vssd sg13cmos5l_decap_8
XFILLER_7_1330 vccd vssd sg13cmos5l_decap_8
XFILLER_7_2086 vccd vssd sg13cmos5l_decap_8
XFILLER_23_1155 vccd vssd sg13cmos5l_decap_8
XFILLER_20_2744 vccd vssd sg13cmos5l_decap_8
XFILLER_37_957 vccd vssd sg13cmos5l_decap_8
XFILLER_36_434 vccd vssd sg13cmos5l_decap_8
Xtiedowns\[109\] status[109] vccd vssd sg13cmos5l_antennanp
XFILLER_40_1480 vccd vssd sg13cmos5l_decap_8
XFILLER_37_979 vccd vssd sg13cmos5l_decap_4
XFILLER_36_2228 vccd vssd sg13cmos5l_decap_8
XFILLER_36_1527 vccd vssd sg13cmos5l_decap_8
XFILLER_31_161 vccd vssd sg13cmos5l_decap_8
XFILLER_18_2673 vccd vssd sg13cmos5l_decap_8
XFILLER_18_1950 vccd vssd sg13cmos5l_decap_8
XFILLER_14_2526 vccd vssd sg13cmos5l_decap_8
XFILLER_20_868 vccd vssd sg13cmos5l_decap_8
XFILLER_12_2250 vccd vssd sg13cmos5l_decap_8
XFILLER_14_1869 vccd vssd sg13cmos5l_decap_8
Xoutbuffers\[96\] control[96] _1764_/Q vccd vssd sg13cmos5l_buf_8
XFILLER_30_1159 vccd vssd sg13cmos5l_decap_8
XFILLER_11_28 vccd vssd sg13cmos5l_decap_8
XFILLER_12_1582 vccd vssd sg13cmos5l_decap_8
X_1628_ _1628_/Y _1629_/A _1643_/B_N vccd vssd sg13cmos5l_nor2b_1
XFILLER_28_1022 vccd vssd sg13cmos5l_decap_4
X_1559_ _1559_/X _1591_/A0 hold478/X _1567_/S vccd vssd sg13cmos5l_mux2_1
XFILLER_25_2644 vccd vssd sg13cmos5l_decap_8
XFILLER_5_2738 vccd vssd sg13cmos5l_decap_4
XFILLER_8_1127 vccd vssd sg13cmos5l_decap_8
XFILLER_25_1954 vccd vssd sg13cmos5l_decap_8
XFILLER_41_1255 vccd vssd sg13cmos5l_decap_8
XFILLER_28_935 vccd vssd sg13cmos5l_decap_8
XFILLER_39_294 vccd vssd sg13cmos5l_decap_8
XFILLER_36_14 vccd vssd sg13cmos5l_decap_8
XFILLER_27_434 vccd vssd sg13cmos5l_decap_8
XFILLER_3_1750 vccd vssd sg13cmos5l_decap_8
XFILLER_42_404 vccd vssd sg13cmos5l_decap_8
XFILLER_42_437 vccd vssd sg13cmos5l_decap_8
XFILLER_39_1140 vccd vssd sg13cmos5l_decap_8
Xclkbuf_3_4_0_SCK clkbuf_3_4_0_SCK/X clkbuf_0_SCK/X vccd vssd sg13cmos5l_buf_8
XFILLER_19_2448 vccd vssd sg13cmos5l_decap_8
XFILLER_23_651 vccd vssd sg13cmos5l_decap_8
XFILLER_19_1736 vccd vssd sg13cmos5l_decap_8
XFILLER_36_2784 vccd vssd sg13cmos5l_decap_8
XFILLER_35_1026 vccd vssd sg13cmos5l_decap_8
XFILLER_22_161 vccd vssd sg13cmos5l_decap_8
XFILLER_10_301 vccd vssd sg13cmos5l_decap_8
XFILLER_32_2637 vccd vssd sg13cmos5l_decap_8
XFILLER_17_2183 vccd vssd sg13cmos5l_decap_8
XFILLER_13_1302 vccd vssd sg13cmos5l_decap_8
XFILLER_11_868 vccd vssd sg13cmos5l_decap_8
XFILLER_13_2058 vccd vssd sg13cmos5l_decap_8
XFILLER_30_2383 vccd vssd sg13cmos5l_decap_8
XFILLER_10_378 vccd vssd sg13cmos5l_decap_8
XFILLER_13_1379 vccd vssd sg13cmos5l_decap_8
XFILLER_26_2408 vccd vssd sg13cmos5l_decap_8
XFILLER_2_511 vccd vssd sg13cmos5l_decap_8
XFILLER_11_1092 vccd vssd sg13cmos5l_decap_8
XFILLER_43_2700 vccd vssd sg13cmos5l_decap_8
Xhold390 hold390/X _1697_/Q vccd vssd sg13cmos5l_dlygate4sd3_1
XFILLER_2_588 vccd vssd sg13cmos5l_decap_8
XFILLER_8_2373 vccd vssd sg13cmos5l_decap_8
XFILLER_43_2777 vccd vssd sg13cmos5l_decap_8
XFILLER_42_1019 vccd vssd sg13cmos5l_decap_8
XFILLER_24_2176 vccd vssd sg13cmos5l_decap_8
XFILLER_4_2226 vccd vssd sg13cmos5l_decap_8
Xtiedowns\[28\] status[28] vccd vssd sg13cmos5l_antennanp
XFILLER_19_924 vccd vssd sg13cmos5l_decap_8
XFILLER_8_1694 vccd vssd sg13cmos5l_decap_8
XFILLER_18_434 vccd vssd sg13cmos5l_decap_8
XFILLER_4_1547 vccd vssd sg13cmos5l_decap_8
XFILLER_45_231 vccd vssd sg13cmos5l_decap_8
XFILLER_37_2548 vccd vssd sg13cmos5l_decap_8
XFILLER_2_1260 vccd vssd sg13cmos5l_decap_8
XFILLER_26_91 vccd vssd sg13cmos5l_decap_8
XFILLER_37_1869 vccd vssd sg13cmos5l_decap_8
X_0930_ _0930_/Y _0930_/A _0936_/B vccd vssd sg13cmos5l_nor2_1
XFILLER_18_1246 vccd vssd sg13cmos5l_decap_8
XFILLER_14_651 vccd vssd sg13cmos5l_decap_8
XFILLER_41_470 vccd vssd sg13cmos5l_decap_8
XFILLER_31_2114 vccd vssd sg13cmos5l_decap_8
XFILLER_13_161 vccd vssd sg13cmos5l_decap_8
X_0861_ _0861_/Y status[92] vccd vssd sg13cmos5l_inv_1
XFILLER_35_1593 vccd vssd sg13cmos5l_decap_8
XFILLER_9_154 vccd vssd sg13cmos5l_decap_8
XFILLER_31_1435 vccd vssd sg13cmos5l_decap_8
XFILLER_6_861 vccd vssd sg13cmos5l_decap_8
XFILLER_5_371 vccd vssd sg13cmos5l_decap_8
XFILLER_29_1342 vccd vssd sg13cmos5l_decap_8
XFILLER_9_1414 vccd vssd sg13cmos5l_decap_8
XFILLER_44_1807 vccd vssd sg13cmos5l_decap_8
XFILLER_29_2098 vccd vssd sg13cmos5l_decap_8
XFILLER_25_1217 vccd vssd sg13cmos5l_decap_8
X_1413_ _1413_/Y _1413_/A _1413_/B vccd vssd sg13cmos5l_xnor2_1
XFILLER_42_2254 vccd vssd sg13cmos5l_decap_8
X_1344_ _1344_/Y _1669_/Q _1382_/A _1060_/Y vccd vssd sg13cmos5l_o21ai_1
X_1275_ _1275_/Y _1272_/Y _1273_/X _1274_/Y vccd vssd sg13cmos5l_o21ai_1
XFILLER_3_84 vccd vssd sg13cmos5l_decap_8
XFILLER_42_1575 vccd vssd sg13cmos5l_decap_8
XFILLER_20_2541 vccd vssd sg13cmos5l_decap_8
XFILLER_37_754 vccd vssd sg13cmos5l_decap_8
XFILLER_36_231 vccd vssd sg13cmos5l_decap_8
XFILLER_3_1057 vccd vssd sg13cmos5l_decap_8
XFILLER_0_2646 vccd vssd sg13cmos5l_decap_8
XFILLER_25_927 vccd vssd sg13cmos5l_decap_8
XFILLER_20_1884 vccd vssd sg13cmos5l_decap_8
Xoutbuffers\[11\] control[11] _1679_/Q vccd vssd sg13cmos5l_buf_8
XFILLER_40_919 vccd vssd sg13cmos5l_decap_8
XFILLER_24_448 vccd vssd sg13cmos5l_decap_8
XFILLER_0_1967 vccd vssd sg13cmos5l_decap_8
XFILLER_36_1324 vccd vssd sg13cmos5l_decap_8
XFILLER_33_982 vccd vssd sg13cmos5l_decap_8
XFILLER_16_1909 vccd vssd sg13cmos5l_decap_8
XFILLER_22_49 vccd vssd sg13cmos5l_decap_8
XFILLER_20_665 vccd vssd sg13cmos5l_decap_8
XFILLER_14_1666 vccd vssd sg13cmos5l_decap_8
XFILLER_3_308 vccd vssd sg13cmos5l_decap_8
XFILLER_10_1519 vccd vssd sg13cmos5l_decap_8
XFILLER_27_2728 vccd vssd sg13cmos5l_decap_8
Xfanout100 _1506_/A hold522/X vccd vssd sg13cmos5l_buf_1
Xfanout111 _1488_/A1 _1600_/A1 vccd vssd sg13cmos5l_buf_1
Xfanout122 fanout122/X fanout124/X vccd vssd sg13cmos5l_buf_1
Xfanout144 _1639_/A _1641_/A vccd vssd sg13cmos5l_buf_1
Xfanout133 _1639_/B_N fanout135/X vccd vssd sg13cmos5l_buf_1
XFILLER_5_2513 vccd vssd sg13cmos5l_decap_8
XFILLER_25_1762 vccd vssd sg13cmos5l_decap_8
XFILLER_21_2349 vccd vssd sg13cmos5l_decap_8
XFILLER_5_1834 vccd vssd sg13cmos5l_decap_8
XFILLER_9_1981 vccd vssd sg13cmos5l_decap_8
XFILLER_41_1085 vccd vssd sg13cmos5l_decap_8
XFILLER_28_776 vccd vssd sg13cmos5l_decap_4
XFILLER_27_231 vccd vssd sg13cmos5l_decap_8
XFILLER_21_1648 vccd vssd sg13cmos5l_decap_8
XFILLER_42_212 vccd vssd sg13cmos5l_decap_8
XFILLER_16_938 vccd vssd sg13cmos5l_decap_8
XFILLER_43_768 vccd vssd sg13cmos5l_decap_4
XFILLER_31_908 vccd vssd sg13cmos5l_decap_8
XFILLER_15_448 vccd vssd sg13cmos5l_decap_8
XFILLER_19_1533 vccd vssd sg13cmos5l_decap_8
XFILLER_36_2581 vccd vssd sg13cmos5l_decap_8
XFILLER_32_2423 vccd vssd sg13cmos5l_decap_8
XFILLER_11_665 vccd vssd sg13cmos5l_decap_8
XFILLER_32_1755 vccd vssd sg13cmos5l_decap_8
XFILLER_7_658 vccd vssd sg13cmos5l_decap_8
XFILLER_10_175 vccd vssd sg13cmos5l_decap_8
XFILLER_30_2191 vccd vssd sg13cmos5l_decap_8
XFILLER_6_168 vccd vssd sg13cmos5l_decap_8
XFILLER_13_1176 vccd vssd sg13cmos5l_decap_8
XFILLER_10_2787 vccd vssd sg13cmos5l_decap_4
XFILLER_26_2227 vccd vssd sg13cmos5l_decap_8
XFILLER_3_875 vccd vssd sg13cmos5l_decap_8
XFILLER_43_2541 vccd vssd sg13cmos5l_decap_8
XFILLER_26_1548 vccd vssd sg13cmos5l_decap_8
XFILLER_2_385 vccd vssd sg13cmos5l_decap_8
XFILLER_8_2170 vccd vssd sg13cmos5l_decap_8
XFILLER_4_2023 vccd vssd sg13cmos5l_decap_8
XFILLER_43_1884 vccd vssd sg13cmos5l_decap_4
XFILLER_24_1250 vccd vssd sg13cmos5l_decap_8
XFILLER_19_721 vccd vssd sg13cmos5l_decap_8
XFILLER_19_7 vccd vssd sg13cmos5l_decap_8
XFILLER_4_1344 vccd vssd sg13cmos5l_decap_8
XFILLER_8_1491 vccd vssd sg13cmos5l_decap_8
X_1060_ _1060_/Y _1210_/B _1598_/B vccd vssd sg13cmos5l_nor2_1
XFILLER_18_231 vccd vssd sg13cmos5l_decap_8
XFILLER_39_1909 vccd vssd sg13cmos5l_decap_8
XFILLER_20_1169 vccd vssd sg13cmos5l_decap_8
XFILLER_19_798 vccd vssd sg13cmos5l_decap_8
XFILLER_34_768 vccd vssd sg13cmos5l_decap_4
XFILLER_33_245 vccd vssd sg13cmos5l_decap_8
Xoutbuffers\[101\] control[101] _1769_/Q vccd vssd sg13cmos5l_buf_8
XFILLER_18_1043 vccd vssd sg13cmos5l_decap_8
X_0913_ _0913_/Y _0913_/A _0938_/B vccd vssd sg13cmos5l_nand2_1
X_0844_ _0844_/Y _0844_/A vccd vssd sg13cmos5l_inv_1
XFILLER_15_1953 vccd vssd sg13cmos5l_decap_8
XFILLER_11_1806 vccd vssd sg13cmos5l_decap_8
XFILLER_31_1243 vccd vssd sg13cmos5l_decap_8
XFILLER_45_0 vccd vssd sg13cmos5l_decap_8
XFILLER_44_2327 vccd vssd sg13cmos5l_decap_8
XFILLER_9_1211 vccd vssd sg13cmos5l_decap_8
XFILLER_44_1637 vccd vssd sg13cmos5l_decap_8
Xoutbuffers\[59\] control[59] _1727_/Q vccd vssd sg13cmos5l_buf_8
XFILLER_26_2761 vccd vssd sg13cmos5l_decap_8
XFILLER_22_1902 vccd vssd sg13cmos5l_decap_8
XFILLER_9_1288 vccd vssd sg13cmos5l_decap_8
X_1327_ _1327_/Y status[1] _1148_/B _1324_/Y _1323_/Y _1326_/Y vccd vssd sg13cmos5l_a221oi_1
XFILLER_22_2669 vccd vssd sg13cmos5l_decap_8
XFILLER_22_1979 vccd vssd sg13cmos5l_decap_4
XFILLER_4_2590 vccd vssd sg13cmos5l_decap_8
X_1258_ _1258_/Y _1390_/B _1258_/B _1258_/C vccd vssd sg13cmos5l_nor3_1
X_1189_ _1189_/Y _0859_/Y _1148_/B _0966_/Y vccd vssd sg13cmos5l_a21oi_1
XFILLER_25_724 vccd vssd sg13cmos5l_decap_8
XFILLER_17_49 vccd vssd sg13cmos5l_decap_8
XFILLER_0_2443 vccd vssd sg13cmos5l_decap_8
XFILLER_24_245 vccd vssd sg13cmos5l_decap_8
XFILLER_0_1764 vccd vssd sg13cmos5l_decap_8
XFILLER_33_2776 vccd vssd sg13cmos5l_decap_8
XFILLER_21_952 vccd vssd sg13cmos5l_decap_8
XFILLER_20_462 vccd vssd sg13cmos5l_decap_8
XFILLER_10_1316 vccd vssd sg13cmos5l_decap_8
XFILLER_14_1463 vccd vssd sg13cmos5l_decap_8
XFILLER_3_105 vccd vssd sg13cmos5l_decap_8
XFILLER_27_2558 vccd vssd sg13cmos5l_decap_8
XFILLER_27_1802 vccd vssd sg13cmos5l_decap_8
XFILLER_0_812 vccd vssd sg13cmos5l_decap_8
XFILLER_5_2310 vccd vssd sg13cmos5l_decap_8
XFILLER_7_1918 vccd vssd sg13cmos5l_decap_8
XFILLER_40_2736 vccd vssd sg13cmos5l_decap_8
XFILLER_0_889 vccd vssd sg13cmos5l_decap_8
XFILLER_5_1631 vccd vssd sg13cmos5l_decap_8
XFILLER_5_2387 vccd vssd sg13cmos5l_decap_8
XFILLER_21_1445 vccd vssd sg13cmos5l_decap_8
XFILLER_28_584 vccd vssd sg13cmos5l_decap_8
XFILLER_16_735 vccd vssd sg13cmos5l_decap_8
XFILLER_38_2665 vccd vssd sg13cmos5l_decap_8
XFILLER_19_1330 vccd vssd sg13cmos5l_decap_8
XFILLER_15_245 vccd vssd sg13cmos5l_decap_8
XFILLER_38_1986 vccd vssd sg13cmos5l_decap_8
XFILLER_34_1806 vccd vssd sg13cmos5l_decap_8
XFILLER_19_2086 vccd vssd sg13cmos5l_decap_8
Xtiedowns\[95\] status[95] vccd vssd sg13cmos5l_antennanp
XFILLER_30_259 vccd vssd sg13cmos5l_decap_8
XFILLER_12_952 vccd vssd sg13cmos5l_decap_8
XFILLER_32_2275 vccd vssd sg13cmos5l_decap_8
XFILLER_23_70 vccd vssd sg13cmos5l_decap_8
XFILLER_8_945 vccd vssd sg13cmos5l_decap_8
XFILLER_11_462 vccd vssd sg13cmos5l_decap_8
XFILLER_7_455 vccd vssd sg13cmos5l_decap_8
XFILLER_45_2625 vccd vssd sg13cmos5l_decap_8
XFILLER_26_2024 vccd vssd sg13cmos5l_decap_8
XFILLER_3_672 vccd vssd sg13cmos5l_decap_8
XFILLER_6_2107 vccd vssd sg13cmos5l_decap_8
XFILLER_10_1883 vccd vssd sg13cmos5l_decap_8
XFILLER_45_1946 vccd vssd sg13cmos5l_decap_8
XFILLER_2_182 vccd vssd sg13cmos5l_decap_8
XFILLER_39_805 vccd vssd sg13cmos5l_decap_8
XFILLER_26_1356 vccd vssd sg13cmos5l_decap_8
XFILLER_6_1428 vccd vssd sg13cmos5l_decap_8
XFILLER_38_315 vccd vssd sg13cmos5l_decap_8
X_1112_ _1112_/Y _1738_/Q _1510_/B _1109_/Y _1110_/Y _1111_/X vccd vssd sg13cmos5l_a221oi_1
XFILLER_1_2730 vccd vssd sg13cmos5l_decap_8
XFILLER_4_1141 vccd vssd sg13cmos5l_decap_8
X_1043_ _1043_/Y _1058_/B _1046_/B _1070_/C vccd vssd sg13cmos5l_nor3_1
XFILLER_39_1728 vccd vssd sg13cmos5l_decap_8
XFILLER_34_521 vccd vssd sg13cmos5l_decap_8
XFILLER_19_595 vccd vssd sg13cmos5l_decap_8
XFILLER_0_63 vccd vssd sg13cmos5l_decap_8
XFILLER_17_2727 vccd vssd sg13cmos5l_decap_8
XFILLER_22_749 vccd vssd sg13cmos5l_decap_8
XFILLER_37_1485 vccd vssd sg13cmos5l_decap_8
XFILLER_21_259 vccd vssd sg13cmos5l_decap_8
XFILLER_15_2451 vccd vssd sg13cmos5l_decap_8
XFILLER_33_1349 vccd vssd sg13cmos5l_decap_8
XFILLER_15_1750 vccd vssd sg13cmos5l_decap_8
XFILLER_11_2326 vccd vssd sg13cmos5l_decap_8
XFILLER_31_1051 vccd vssd sg13cmos5l_decap_8
XFILLER_11_1603 vccd vssd sg13cmos5l_decap_8
X_0827_ _0827_/Y _0827_/A vccd vssd sg13cmos5l_inv_1
XFILLER_44_2124 vccd vssd sg13cmos5l_decap_8
XFILLER_1_609 vccd vssd sg13cmos5l_decap_8
XFILLER_0_119 vccd vssd sg13cmos5l_decap_8
XFILLER_44_1434 vccd vssd sg13cmos5l_decap_8
XFILLER_29_315 vccd vssd sg13cmos5l_decap_8
XFILLER_2_2527 vccd vssd sg13cmos5l_decap_8
XFILLER_6_2685 vccd vssd sg13cmos5l_decap_8
XFILLER_9_1085 vccd vssd sg13cmos5l_decap_8
XFILLER_45_819 vccd vssd sg13cmos5l_decap_8
XFILLER_26_1890 vccd vssd sg13cmos5l_decap_8
XFILLER_22_2466 vccd vssd sg13cmos5l_decap_8
XFILLER_22_1732 vccd vssd sg13cmos5l_decap_8
XFILLER_44_329 vccd vssd sg13cmos5l_decap_8
XFILLER_2_1848 vccd vssd sg13cmos5l_decap_8
XFILLER_0_2240 vccd vssd sg13cmos5l_decap_8
XFILLER_6_1995 vccd vssd sg13cmos5l_decap_8
XFILLER_44_14 vccd vssd sg13cmos5l_decap_8
XFILLER_38_1205 vccd vssd sg13cmos5l_decap_8
XFILLER_37_392 vccd vssd sg13cmos5l_decap_8
XFILLER_25_532 vccd vssd sg13cmos5l_decap_8
XFILLER_0_1561 vccd vssd sg13cmos5l_decap_8
XFILLER_25_598 vccd vssd sg13cmos5l_decap_8
XFILLER_16_2237 vccd vssd sg13cmos5l_decap_8
XFILLER_13_749 vccd vssd sg13cmos5l_decap_8
XFILLER_40_546 vccd vssd sg13cmos5l_decap_8
XFILLER_16_2259 vccd vssd sg13cmos5l_decap_8
XFILLER_12_259 vccd vssd sg13cmos5l_decap_8
XFILLER_33_2573 vccd vssd sg13cmos5l_decap_8
XFILLER_16_1547 vccd vssd sg13cmos5l_decap_8
XFILLER_14_1260 vccd vssd sg13cmos5l_decap_8
XFILLER_33_1894 vccd vssd sg13cmos5l_decap_8
XFILLER_10_1113 vccd vssd sg13cmos5l_decap_8
XFILLER_5_959 vccd vssd sg13cmos5l_decap_8
XFILLER_27_2311 vccd vssd sg13cmos5l_decap_8
XFILLER_4_469 vccd vssd sg13cmos5l_decap_8
XFILLER_27_2366 vccd vssd sg13cmos5l_decap_4
XFILLER_27_1643 vccd vssd sg13cmos5l_decap_8
XFILLER_7_1715 vccd vssd sg13cmos5l_decap_8
XFILLER_40_2533 vccd vssd sg13cmos5l_decap_8
XFILLER_0_686 vccd vssd sg13cmos5l_decap_8
XFILLER_1_2037 vccd vssd sg13cmos5l_decap_8
XFILLER_5_2184 vccd vssd sg13cmos5l_decap_8
Xtiedowns\[10\] status[10] vccd vssd sg13cmos5l_antennanp
XFILLER_40_1876 vccd vssd sg13cmos5l_decap_8
XFILLER_35_329 vccd vssd sg13cmos5l_decap_8
XFILLER_21_1253 vccd vssd sg13cmos5l_decap_8
XFILLER_18_70 vccd vssd sg13cmos5l_decap_8
XFILLER_28_392 vccd vssd sg13cmos5l_decap_8
XFILLER_16_532 vccd vssd sg13cmos5l_decap_8
XFILLER_1_1358 vccd vssd sg13cmos5l_decap_8
XFILLER_44_863 vccd vssd sg13cmos5l_decap_8
XFILLER_43_395 vccd vssd sg13cmos5l_decap_4
XFILLER_38_1761 vccd vssd sg13cmos5l_decap_8
XFILLER_34_2315 vccd vssd sg13cmos5l_decap_8
XFILLER_34_1625 vccd vssd sg13cmos5l_decap_4
XFILLER_34_91 vccd vssd sg13cmos5l_decap_8
XFILLER_31_557 vccd vssd sg13cmos5l_decap_8
XFILLER_34_1669 vccd vssd sg13cmos5l_decap_8
XFILLER_12_2624 vccd vssd sg13cmos5l_decap_8
XFILLER_32_2083 vccd vssd sg13cmos5l_decap_8
X_1730_ _1730_/Q _1736_/CLK _1730_/D fanout126/X vccd vssd sg13cmos5l_dfrbpq_1
XFILLER_15_1057 vccd vssd sg13cmos5l_decap_8
XFILLER_8_742 vccd vssd sg13cmos5l_decap_8
XFILLER_32_1371 vccd vssd sg13cmos5l_decap_8
X_1661_ _1661_/Q _1661_/CLK _1661_/D _1603_/Y vccd vssd sg13cmos5l_dfrbpq_1
Xhold208 _1645_/D _1415_/X vccd vssd sg13cmos5l_dlygate4sd3_1
XFILLER_7_252 vccd vssd sg13cmos5l_decap_8
Xhold219 _1430_/A _1676_/Q vccd vssd sg13cmos5l_dlygate4sd3_1
XFILLER_28_2108 vccd vssd sg13cmos5l_decap_8
XFILLER_12_1967 vccd vssd sg13cmos5l_decap_8
XFILLER_45_2422 vccd vssd sg13cmos5l_decap_8
X_1592_ _1592_/X _1560_/A hold476/X _1597_/S vccd vssd sg13cmos5l_mux2_1
XFILLER_10_1680 vccd vssd sg13cmos5l_decap_8
XFILLER_45_2499 vccd vssd sg13cmos5l_decap_8
XFILLER_45_1743 vccd vssd sg13cmos5l_decap_8
XFILLER_39_613 vccd vssd sg13cmos5l_decap_8
XFILLER_38_112 vccd vssd sg13cmos5l_decap_8
XFILLER_26_1153 vccd vssd sg13cmos5l_decap_8
XFILLER_23_2753 vccd vssd sg13cmos5l_decap_8
XFILLER_6_1225 vccd vssd sg13cmos5l_decap_8
XFILLER_26_329 vccd vssd sg13cmos5l_decap_8
XFILLER_39_1514 vccd vssd sg13cmos5l_decap_8
XFILLER_38_189 vccd vssd sg13cmos5l_decap_8
XFILLER_35_830 vccd vssd sg13cmos5l_decap_8
XFILLER_19_392 vccd vssd sg13cmos5l_decap_8
X_1026_ _1026_/Y _1787_/Q _1279_/B vccd vssd sg13cmos5l_nand2b_1
XFILLER_17_2513 vccd vssd sg13cmos5l_decap_4
XFILLER_34_384 vccd vssd sg13cmos5l_decap_8
XFILLER_22_546 vccd vssd sg13cmos5l_decap_8
XFILLER_14_28 vccd vssd sg13cmos5l_decap_8
XFILLER_33_1113 vccd vssd sg13cmos5l_decap_8
XFILLER_17_1867 vccd vssd sg13cmos5l_decap_8
XFILLER_30_2757 vccd vssd sg13cmos5l_decap_8
Xclkbuf_5_21_0_SCK _1631__159/A clkbuf_3_5_0_SCK/X vccd vssd sg13cmos5l_buf_8
XFILLER_11_1400 vccd vssd sg13cmos5l_decap_8
XFILLER_11_2156 vccd vssd sg13cmos5l_decap_8
Xfanout2 _1587_/S _1585_/S vccd vssd sg13cmos5l_buf_1
XFILLER_30_49 vccd vssd sg13cmos5l_decap_8
XFILLER_1_406 vccd vssd sg13cmos5l_decap_8
XFILLER_11_1477 vccd vssd sg13cmos5l_decap_8
XFILLER_39_14 vccd vssd sg13cmos5l_decap_8
XFILLER_44_1231 vccd vssd sg13cmos5l_decap_8
XFILLER_28_2686 vccd vssd sg13cmos5l_decap_8
XFILLER_28_1952 vccd vssd sg13cmos5l_decap_8
XFILLER_24_2517 vccd vssd sg13cmos5l_decap_8
XFILLER_24_1805 vccd vssd sg13cmos5l_decap_8
XFILLER_8_2758 vccd vssd sg13cmos5l_decap_8
XFILLER_29_112 vccd vssd sg13cmos5l_decap_8
XFILLER_6_2471 vccd vssd sg13cmos5l_decap_8
XFILLER_22_2263 vccd vssd sg13cmos5l_decap_8
XFILLER_2_2324 vccd vssd sg13cmos5l_decap_8
XFILLER_45_616 vccd vssd sg13cmos5l_decap_8
XFILLER_18_819 vccd vssd sg13cmos5l_decap_8
XFILLER_6_1792 vccd vssd sg13cmos5l_decap_8
XFILLER_44_126 vccd vssd sg13cmos5l_decap_8
XFILLER_29_189 vccd vssd sg13cmos5l_decap_8
XFILLER_17_329 vccd vssd sg13cmos5l_decap_8
XFILLER_2_1645 vccd vssd sg13cmos5l_decap_8
XFILLER_38_1002 vccd vssd sg13cmos5l_decap_8
XFILLER_35_2602 vccd vssd sg13cmos5l_decap_8
XFILLER_35_1901 vccd vssd sg13cmos5l_decap_8
XFILLER_26_896 vccd vssd sg13cmos5l_decap_8
XFILLER_41_866 vccd vssd sg13cmos5l_decap_8
XFILLER_40_343 vccd vssd sg13cmos5l_decap_8
XFILLER_38_1079 vccd vssd sg13cmos5l_decap_8
XFILLER_35_2679 vccd vssd sg13cmos5l_decap_8
XFILLER_16_2056 vccd vssd sg13cmos5l_decap_8
XFILLER_13_546 vccd vssd sg13cmos5l_decap_8
XFILLER_16_1344 vccd vssd sg13cmos5l_decap_8
XFILLER_9_539 vccd vssd sg13cmos5l_decap_8
XFILLER_33_1691 vccd vssd sg13cmos5l_decap_8
XFILLER_5_756 vccd vssd sg13cmos5l_decap_8
XFILLER_11_2690 vccd vssd sg13cmos5l_decap_8
XFILLER_29_1705 vccd vssd sg13cmos5l_decap_8
XFILLER_4_266 vccd vssd sg13cmos5l_decap_8
Xtiedowns\[58\] status[58] vccd vssd sg13cmos5l_antennanp
XFILLER_7_1512 vccd vssd sg13cmos5l_decap_8
XFILLER_27_1462 vccd vssd sg13cmos5l_decap_8
XFILLER_1_973 vccd vssd sg13cmos5l_decap_8
XFILLER_7_2268 vccd vssd sg13cmos5l_decap_8
XFILLER_40_2352 vccd vssd sg13cmos5l_decap_8
XFILLER_0_483 vccd vssd sg13cmos5l_decap_8
XFILLER_29_91 vccd vssd sg13cmos5l_decap_8
XFILLER_7_1589 vccd vssd sg13cmos5l_decap_8
XFILLER_36_649 vccd vssd sg13cmos5l_decap_8
XFILLER_35_126 vccd vssd sg13cmos5l_decap_8
XFILLER_21_1050 vccd vssd sg13cmos5l_decap_8
XFILLER_1_1155 vccd vssd sg13cmos5l_decap_8
XFILLER_32_811 vccd vssd sg13cmos5l_decap_8
XFILLER_17_896 vccd vssd sg13cmos5l_decap_8
XFILLER_31_343 vccd vssd sg13cmos5l_decap_8
XFILLER_38_1580 vccd vssd sg13cmos5l_decap_8
XFILLER_34_2156 vccd vssd sg13cmos5l_decap_8
XFILLER_32_888 vccd vssd sg13cmos5l_decap_8
XFILLER_34_1455 vccd vssd sg13cmos5l_decap_8
XFILLER_16_2590 vccd vssd sg13cmos5l_decap_8
X_1713_ _1713_/Q _1713_/CLK _1713_/D fanout127/X vccd vssd sg13cmos5l_dfrbpq_1
XFILLER_12_1764 vccd vssd sg13cmos5l_decap_8
X_1644_ _1644_/Y _1644_/A _1644_/B_N vccd vssd sg13cmos5l_nor2b_1
XFILLER_6_84 vccd vssd sg13cmos5l_decap_8
X_1575_ _1575_/X _1595_/A0 hold486/X _1575_/S vccd vssd sg13cmos5l_mux2_1
XFILLER_8_1309 vccd vssd sg13cmos5l_decap_8
XFILLER_45_2296 vccd vssd sg13cmos5l_decap_8
XFILLER_45_1540 vccd vssd sg13cmos5l_decap_8
XFILLER_41_1426 vccd vssd sg13cmos5l_decap_8
Xoutbuffers\[41\] control[41] _1709_/Q vccd vssd sg13cmos5l_buf_8
XFILLER_23_2550 vccd vssd sg13cmos5l_decap_8
XFILLER_3_2611 vccd vssd sg13cmos5l_decap_8
XFILLER_6_1022 vccd vssd sg13cmos5l_decap_8
XFILLER_39_487 vccd vssd sg13cmos5l_decap_8
XFILLER_3_1932 vccd vssd sg13cmos5l_decap_8
XFILLER_39_2012 vccd vssd sg13cmos5l_decap_8
XFILLER_26_126 vccd vssd sg13cmos5l_decap_8
XFILLER_3_2688 vccd vssd sg13cmos5l_decap_8
XFILLER_6_1099 vccd vssd sg13cmos5l_decap_8
XFILLER_19_2608 vccd vssd sg13cmos5l_decap_8
X_1009_ _1050_/A _1009_/A _1058_/B vccd vssd sg13cmos5l_or2_1
XFILLER_25_49 vccd vssd sg13cmos5l_decap_8
XFILLER_23_833 vccd vssd sg13cmos5l_decap_8
XFILLER_39_1388 vccd vssd sg13cmos5l_decap_8
XFILLER_22_343 vccd vssd sg13cmos5l_decap_8
XFILLER_17_2343 vccd vssd sg13cmos5l_decap_8
XFILLER_17_1631 vccd vssd sg13cmos5l_decap_8
XFILLER_30_2554 vccd vssd sg13cmos5l_decap_8
XFILLER_30_1831 vccd vssd sg13cmos5l_decap_8
XFILLER_30_1897 vccd vssd sg13cmos5l_decap_4
XFILLER_11_1274 vccd vssd sg13cmos5l_decap_8
XFILLER_28_2450 vccd vssd sg13cmos5l_decap_8
XFILLER_1_203 vccd vssd sg13cmos5l_decap_8
XFILLER_8_2555 vccd vssd sg13cmos5l_decap_8
XFILLER_24_1602 vccd vssd sg13cmos5l_decap_8
XFILLER_4_2408 vccd vssd sg13cmos5l_decap_8
XFILLER_8_1876 vccd vssd sg13cmos5l_decap_8
XFILLER_22_2060 vccd vssd sg13cmos5l_decap_8
XFILLER_18_616 vccd vssd sg13cmos5l_decap_8
XFILLER_2_2121 vccd vssd sg13cmos5l_decap_8
XFILLER_4_1729 vccd vssd sg13cmos5l_decap_8
XFILLER_45_413 vccd vssd sg13cmos5l_decap_8
XFILLER_41_1971 vccd vssd sg13cmos5l_decap_8
XFILLER_17_126 vccd vssd sg13cmos5l_decap_8
XFILLER_2_1442 vccd vssd sg13cmos5l_decap_8
XFILLER_33_619 vccd vssd sg13cmos5l_decap_8
XFILLER_2_2198 vccd vssd sg13cmos5l_decap_8
XFILLER_26_671 vccd vssd sg13cmos5l_decap_8
XFILLER_14_833 vccd vssd sg13cmos5l_decap_8
XFILLER_18_1428 vccd vssd sg13cmos5l_decap_8
XFILLER_13_343 vccd vssd sg13cmos5l_decap_8
XFILLER_41_663 vccd vssd sg13cmos5l_decap_8
XFILLER_40_140 vccd vssd sg13cmos5l_decap_8
XFILLER_35_1720 vccd vssd sg13cmos5l_decap_8
XFILLER_16_1141 vccd vssd sg13cmos5l_decap_8
XFILLER_9_336 vccd vssd sg13cmos5l_decap_8
XFILLER_35_1786 vccd vssd sg13cmos5l_decap_8
XFILLER_31_70 vccd vssd sg13cmos5l_decap_8
XFILLER_5_553 vccd vssd sg13cmos5l_decap_8
XFILLER_29_2247 vccd vssd sg13cmos5l_decap_8
X_1360_ _1364_/B status[64] _0974_/Y _1360_/B1 status[56] vccd vssd sg13cmos5l_a22oi_1
XFILLER_42_2447 vccd vssd sg13cmos5l_decap_4
XFILLER_1_770 vccd vssd sg13cmos5l_decap_8
XFILLER_7_2065 vccd vssd sg13cmos5l_decap_8
XFILLER_42_1713 vccd vssd sg13cmos5l_decap_8
X_1291_ _1291_/Y _0842_/Y _1474_/B _1289_/Y _1290_/Y _1162_/B vccd vssd sg13cmos5l_a221oi_1
XFILLER_0_280 vccd vssd sg13cmos5l_decap_8
XFILLER_20_2723 vccd vssd sg13cmos5l_decap_8
XFILLER_7_1386 vccd vssd sg13cmos5l_decap_8
XFILLER_37_936 vccd vssd sg13cmos5l_decap_8
XFILLER_36_413 vccd vssd sg13cmos5l_decap_8
XFILLER_3_1239 vccd vssd sg13cmos5l_decap_8
XFILLER_45_980 vccd vssd sg13cmos5l_decap_8
XFILLER_36_1506 vccd vssd sg13cmos5l_decap_8
XFILLER_18_2652 vccd vssd sg13cmos5l_decap_8
XFILLER_17_693 vccd vssd sg13cmos5l_decap_8
XFILLER_31_140 vccd vssd sg13cmos5l_decap_8
XFILLER_14_2505 vccd vssd sg13cmos5l_decap_8
XFILLER_20_847 vccd vssd sg13cmos5l_decap_8
XFILLER_14_1848 vccd vssd sg13cmos5l_decap_8
XFILLER_34_1296 vccd vssd sg13cmos5l_decap_8
XFILLER_30_1138 vccd vssd sg13cmos5l_decap_8
Xoutbuffers\[89\] control[89] _1757_/Q vccd vssd sg13cmos5l_buf_8
XFILLER_12_1561 vccd vssd sg13cmos5l_decap_8
XFILLER_28_1001 vccd vssd sg13cmos5l_decap_8
XFILLER_25_2623 vccd vssd sg13cmos5l_decap_8
XFILLER_25_2601 vccd vssd sg13cmos5l_decap_8
XFILLER_8_1106 vccd vssd sg13cmos5l_decap_8
X_1558_ _1764_/D _1590_/A1 _1567_/S hold343/X vccd vssd sg13cmos5l_o21ai_1
XFILLER_5_2717 vccd vssd sg13cmos5l_decap_8
XFILLER_45_2093 vccd vssd sg13cmos5l_decap_8
X_1489_ _1489_/X _1401_/A hold354/X _1495_/B vccd vssd sg13cmos5l_mux2_1
XFILLER_41_1234 vccd vssd sg13cmos5l_decap_8
XFILLER_28_914 vccd vssd sg13cmos5l_decap_8
XFILLER_39_273 vccd vssd sg13cmos5l_decap_8
XFILLER_27_413 vccd vssd sg13cmos5l_decap_8
XFILLER_3_2485 vccd vssd sg13cmos5l_decap_8
XFILLER_19_2427 vccd vssd sg13cmos5l_decap_8
XFILLER_23_630 vccd vssd sg13cmos5l_decap_8
XFILLER_19_1715 vccd vssd sg13cmos5l_decap_8
XFILLER_36_2763 vccd vssd sg13cmos5l_decap_8
XFILLER_35_1016 vccd vssd sg13cmos5l_decap_4
XFILLER_32_2616 vccd vssd sg13cmos5l_decap_8
XFILLER_22_140 vccd vssd sg13cmos5l_decap_8
XFILLER_17_2151 vccd vssd sg13cmos5l_decap_8
XFILLER_11_847 vccd vssd sg13cmos5l_decap_8
XFILLER_13_2037 vccd vssd sg13cmos5l_decap_8
XFILLER_10_357 vccd vssd sg13cmos5l_decap_8
XFILLER_13_1358 vccd vssd sg13cmos5l_decap_8
XFILLER_11_1071 vccd vssd sg13cmos5l_decap_8
Xhold380 _1701_/D _1466_/X vccd vssd sg13cmos5l_dlygate4sd3_1
XFILLER_43_2756 vccd vssd sg13cmos5l_decap_8
Xhold391 _1697_/D _1460_/X vccd vssd sg13cmos5l_dlygate4sd3_1
XFILLER_28_2280 vccd vssd sg13cmos5l_decap_4
XFILLER_2_567 vccd vssd sg13cmos5l_decap_8
XFILLER_8_2352 vccd vssd sg13cmos5l_decap_8
XFILLER_24_2155 vccd vssd sg13cmos5l_decap_8
XFILLER_4_2205 vccd vssd sg13cmos5l_decap_8
XFILLER_19_903 vccd vssd sg13cmos5l_decap_8
XFILLER_4_1526 vccd vssd sg13cmos5l_decap_8
XFILLER_8_1673 vccd vssd sg13cmos5l_decap_8
XFILLER_45_210 vccd vssd sg13cmos5l_decap_8
XFILLER_18_413 vccd vssd sg13cmos5l_decap_8
XFILLER_45_287 vccd vssd sg13cmos5l_decap_8
XFILLER_37_2527 vccd vssd sg13cmos5l_decap_8
XFILLER_33_427 vccd vssd sg13cmos5l_decap_8
XFILLER_27_991 vccd vssd sg13cmos5l_decap_8
XFILLER_26_490 vccd vssd sg13cmos5l_decap_8
XFILLER_26_70 vccd vssd sg13cmos5l_decap_8
XFILLER_14_630 vccd vssd sg13cmos5l_decap_8
XFILLER_37_1848 vccd vssd sg13cmos5l_decap_8
XFILLER_18_1225 vccd vssd sg13cmos5l_decap_8
XFILLER_13_140 vccd vssd sg13cmos5l_decap_8
XFILLER_9_133 vccd vssd sg13cmos5l_decap_8
X_0860_ _0860_/Y status[44] vccd vssd sg13cmos5l_inv_1
XFILLER_35_1572 vccd vssd sg13cmos5l_decap_8
XFILLER_31_2148 vccd vssd sg13cmos5l_decap_8
XFILLER_31_1414 vccd vssd sg13cmos5l_decap_8
XFILLER_42_91 vccd vssd sg13cmos5l_decap_8
XFILLER_6_840 vccd vssd sg13cmos5l_decap_8
XFILLER_5_350 vccd vssd sg13cmos5l_decap_8
XFILLER_29_2077 vccd vssd sg13cmos5l_decap_8
XFILLER_29_1321 vccd vssd sg13cmos5l_decap_8
X_1412_ _1413_/B _0900_/B _1412_/B vccd vssd sg13cmos5l_nand2b_1
XFILLER_9_2149 vccd vssd sg13cmos5l_decap_8
XFILLER_42_2233 vccd vssd sg13cmos5l_decap_8
X_1343_ _1343_/Y _1677_/Q _1429_/B _1342_/Y _1341_/Y _1419_/B vccd vssd sg13cmos5l_a221oi_1
XFILLER_29_1398 vccd vssd sg13cmos5l_decap_8
XFILLER_3_63 vccd vssd sg13cmos5l_decap_8
Xtiedowns\[121\] status[121] vccd vssd sg13cmos5l_antennanp
X_1274_ _1274_/Y _0846_/Y _1232_/B _1147_/B vccd vssd sg13cmos5l_a21oi_1
XFILLER_42_1554 vccd vssd sg13cmos5l_decap_8
XFILLER_20_2520 vccd vssd sg13cmos5l_decap_8
XFILLER_37_733 vccd vssd sg13cmos5l_decap_8
XFILLER_36_210 vccd vssd sg13cmos5l_decap_8
XFILLER_3_1036 vccd vssd sg13cmos5l_decap_8
XFILLER_0_2625 vccd vssd sg13cmos5l_decap_8
XFILLER_4_2783 vccd vssd sg13cmos5l_decap_8
XFILLER_7_1183 vccd vssd sg13cmos5l_decap_8
XFILLER_25_906 vccd vssd sg13cmos5l_decap_8
XFILLER_36_287 vccd vssd sg13cmos5l_decap_8
XFILLER_24_427 vccd vssd sg13cmos5l_decap_8
XFILLER_20_2597 vccd vssd sg13cmos5l_decap_8
XFILLER_18_980 vccd vssd sg13cmos5l_decap_8
XFILLER_0_1946 vccd vssd sg13cmos5l_decap_8
XFILLER_20_1896 vccd vssd sg13cmos5l_decap_8
XFILLER_17_490 vccd vssd sg13cmos5l_decap_8
XFILLER_36_2059 vccd vssd sg13cmos5l_decap_8
XFILLER_33_961 vccd vssd sg13cmos5l_decap_8
XFILLER_34_1060 vccd vssd sg13cmos5l_decap_8
XFILLER_22_28 vccd vssd sg13cmos5l_decap_8
XFILLER_20_644 vccd vssd sg13cmos5l_decap_8
XFILLER_18_1792 vccd vssd sg13cmos5l_decap_8
XFILLER_14_2379 vccd vssd sg13cmos5l_decap_8
X_0989_ _0990_/A status[127] wire74/X _1309_/B1 status[111] vccd vssd sg13cmos5l_a22oi_1
XFILLER_31_2682 vccd vssd sg13cmos5l_decap_8
XFILLER_14_1645 vccd vssd sg13cmos5l_decap_8
XFILLER_31_1970 vccd vssd sg13cmos5l_decap_8
XFILLER_27_2707 vccd vssd sg13cmos5l_decap_8
Xfanout101 _1481_/A _1504_/A vccd vssd sg13cmos5l_buf_1
Xfanout112 _1590_/A1 _0823_/Y vccd vssd sg13cmos5l_buf_1
Xfanout134 fanout134/X fanout135/X vccd vssd sg13cmos5l_buf_1
Xfanout123 fanout123/X fanout124/X vccd vssd sg13cmos5l_buf_1
Xfanout145 _1641_/A _1629_/A vccd vssd sg13cmos5l_buf_1
XFILLER_9_1960 vccd vssd sg13cmos5l_decap_8
XFILLER_9_2694 vccd vssd sg13cmos5l_decap_8
XFILLER_21_2328 vccd vssd sg13cmos5l_decap_8
XFILLER_5_1813 vccd vssd sg13cmos5l_decap_8
XFILLER_41_1064 vccd vssd sg13cmos5l_decap_8
XFILLER_27_210 vccd vssd sg13cmos5l_decap_8
XFILLER_21_1627 vccd vssd sg13cmos5l_decap_8
XFILLER_28_755 vccd vssd sg13cmos5l_decap_8
XFILLER_16_917 vccd vssd sg13cmos5l_decap_8
XFILLER_3_2282 vccd vssd sg13cmos5l_decap_8
XFILLER_19_2202 vccd vssd sg13cmos5l_decap_8
XFILLER_15_427 vccd vssd sg13cmos5l_decap_8
XFILLER_42_246 vccd vssd sg13cmos5l_decap_8
XFILLER_27_287 vccd vssd sg13cmos5l_decap_8
XFILLER_19_1512 vccd vssd sg13cmos5l_decap_8
XFILLER_42_279 vccd vssd sg13cmos5l_decap_8
XFILLER_36_2560 vccd vssd sg13cmos5l_decap_8
XFILLER_32_2402 vccd vssd sg13cmos5l_decap_8
XFILLER_19_2268 vccd vssd sg13cmos5l_decap_8
XFILLER_24_994 vccd vssd sg13cmos5l_decap_8
XFILLER_19_1589 vccd vssd sg13cmos5l_decap_8
XFILLER_11_644 vccd vssd sg13cmos5l_decap_8
XFILLER_32_2479 vccd vssd sg13cmos5l_decap_8
XFILLER_32_1734 vccd vssd sg13cmos5l_decap_8
XFILLER_7_637 vccd vssd sg13cmos5l_decap_8
XFILLER_10_154 vccd vssd sg13cmos5l_decap_8
XFILLER_30_2170 vccd vssd sg13cmos5l_decap_8
XFILLER_6_147 vccd vssd sg13cmos5l_decap_8
XFILLER_10_2766 vccd vssd sg13cmos5l_decap_8
XFILLER_13_1155 vccd vssd sg13cmos5l_decap_8
XFILLER_26_2206 vccd vssd sg13cmos5l_decap_8
XFILLER_3_854 vccd vssd sg13cmos5l_decap_8
XFILLER_5_0 vccd vssd sg13cmos5l_decap_8
Xtiedowns\[40\] status[40] vccd vssd sg13cmos5l_antennanp
XFILLER_2_364 vccd vssd sg13cmos5l_decap_8
XFILLER_26_1527 vccd vssd sg13cmos5l_decap_8
XFILLER_4_2002 vccd vssd sg13cmos5l_decap_8
XFILLER_19_700 vccd vssd sg13cmos5l_decap_8
XFILLER_8_1470 vccd vssd sg13cmos5l_decap_8
XFILLER_18_210 vccd vssd sg13cmos5l_decap_8
XFILLER_4_1323 vccd vssd sg13cmos5l_decap_8
XFILLER_4_2079 vccd vssd sg13cmos5l_decap_8
XFILLER_37_91 vccd vssd sg13cmos5l_decap_8
XFILLER_20_1148 vccd vssd sg13cmos5l_decap_8
XFILLER_19_777 vccd vssd sg13cmos5l_decap_8
XFILLER_33_224 vccd vssd sg13cmos5l_decap_8
XFILLER_18_287 vccd vssd sg13cmos5l_decap_8
XFILLER_37_1645 vccd vssd sg13cmos5l_decap_8
XFILLER_18_1022 vccd vssd sg13cmos5l_decap_8
XFILLER_30_931 vccd vssd sg13cmos5l_decap_8
XFILLER_15_994 vccd vssd sg13cmos5l_decap_8
X_0912_ _0914_/A _0970_/A _0936_/B _0912_/C vccd vssd sg13cmos5l_nand3_1
XFILLER_15_1932 vccd vssd sg13cmos5l_decap_8
X_0843_ _0843_/Y _0843_/A vccd vssd sg13cmos5l_inv_1
XFILLER_18_1099 vccd vssd sg13cmos5l_decap_8
XFILLER_44_2306 vccd vssd sg13cmos5l_decap_8
Xclkbuf_3_3_0_SCK clkbuf_3_3_0_SCK/X clkbuf_0_SCK/X vccd vssd sg13cmos5l_buf_8
XFILLER_26_2740 vccd vssd sg13cmos5l_decap_8
XFILLER_44_1616 vccd vssd sg13cmos5l_decap_8
XFILLER_38_0 vccd vssd sg13cmos5l_decap_8
XFILLER_25_1004 vccd vssd sg13cmos5l_decap_8
X_1326_ _1326_/Y _1326_/A vccd vssd sg13cmos5l_inv_1
XFILLER_29_508 vccd vssd sg13cmos5l_decap_8
XFILLER_22_2648 vccd vssd sg13cmos5l_decap_8
XFILLER_2_2709 vccd vssd sg13cmos5l_decap_8
XFILLER_9_1267 vccd vssd sg13cmos5l_decap_8
XFILLER_42_1351 vccd vssd sg13cmos5l_decap_8
XFILLER_37_552 vccd vssd sg13cmos5l_decap_8
XFILLER_17_28 vccd vssd sg13cmos5l_decap_8
XFILLER_0_2422 vccd vssd sg13cmos5l_decap_8
X_1257_ _1258_/C mask_rev_in[27] _1350_/B vccd vssd sg13cmos5l_nor2b_1
X_1188_ _1188_/Y _1186_/Y _1185_/Y _1187_/Y vccd vssd sg13cmos5l_o21ai_1
XFILLER_25_703 vccd vssd sg13cmos5l_decap_8
XFILLER_20_2394 vccd vssd sg13cmos5l_decap_8
XFILLER_4_1890 vccd vssd sg13cmos5l_decap_8
XFILLER_24_224 vccd vssd sg13cmos5l_decap_8
XFILLER_20_1682 vccd vssd sg13cmos5l_decap_8
XFILLER_0_2499 vccd vssd sg13cmos5l_decap_8
XFILLER_0_1743 vccd vssd sg13cmos5l_decap_8
XFILLER_40_739 vccd vssd sg13cmos5l_decap_8
XFILLER_33_49 vccd vssd sg13cmos5l_decap_8
XFILLER_21_931 vccd vssd sg13cmos5l_decap_8
XFILLER_33_2755 vccd vssd sg13cmos5l_decap_8
XFILLER_20_441 vccd vssd sg13cmos5l_decap_8
XFILLER_16_1729 vccd vssd sg13cmos5l_decap_8
XFILLER_14_2121 vccd vssd sg13cmos5l_decap_8
XFILLER_14_1442 vccd vssd sg13cmos5l_decap_8
XFILLER_14_2187 vccd vssd sg13cmos5l_decap_8
XFILLER_27_2537 vccd vssd sg13cmos5l_decap_8
XFILLER_7_2609 vccd vssd sg13cmos5l_decap_4
XFILLER_40_2715 vccd vssd sg13cmos5l_decap_8
XFILLER_27_1869 vccd vssd sg13cmos5l_decap_8
XFILLER_0_868 vccd vssd sg13cmos5l_decap_8
XFILLER_5_1610 vccd vssd sg13cmos5l_decap_8
XFILLER_21_2147 vccd vssd sg13cmos5l_decap_8
XFILLER_1_2219 vccd vssd sg13cmos5l_decap_8
XFILLER_5_2366 vccd vssd sg13cmos5l_decap_8
XFILLER_16_714 vccd vssd sg13cmos5l_decap_8
XFILLER_5_1687 vccd vssd sg13cmos5l_decap_8
XFILLER_38_2644 vccd vssd sg13cmos5l_decap_8
XFILLER_15_224 vccd vssd sg13cmos5l_decap_8
XFILLER_19_2065 vccd vssd sg13cmos5l_decap_8
XFILLER_38_1954 vccd vssd sg13cmos5l_decap_8
XFILLER_31_739 vccd vssd sg13cmos5l_decap_8
XFILLER_24_791 vccd vssd sg13cmos5l_decap_8
XFILLER_12_931 vccd vssd sg13cmos5l_decap_8
XFILLER_30_238 vccd vssd sg13cmos5l_decap_8
XFILLER_19_1386 vccd vssd sg13cmos5l_decap_8
XFILLER_11_441 vccd vssd sg13cmos5l_decap_8
Xtiedowns\[88\] status[88] vccd vssd sg13cmos5l_antennanp
XFILLER_32_2254 vccd vssd sg13cmos5l_decap_8
XFILLER_15_1239 vccd vssd sg13cmos5l_decap_8
XFILLER_8_924 vccd vssd sg13cmos5l_decap_8
XFILLER_32_2298 vccd vssd sg13cmos5l_decap_8
XFILLER_7_434 vccd vssd sg13cmos5l_decap_8
XFILLER_45_2604 vccd vssd sg13cmos5l_decap_8
XFILLER_10_1862 vccd vssd sg13cmos5l_decap_8
XFILLER_26_2003 vccd vssd sg13cmos5l_decap_8
XFILLER_3_651 vccd vssd sg13cmos5l_decap_8
XFILLER_45_1925 vccd vssd sg13cmos5l_decap_8
XFILLER_31_7 vccd vssd sg13cmos5l_decap_8
XFILLER_2_161 vccd vssd sg13cmos5l_decap_8
XFILLER_6_1407 vccd vssd sg13cmos5l_decap_8
X_1111_ _1111_/X _1730_/Q _1372_/B1 _1486_/B vccd vssd sg13cmos5l_a21o_1
XFILLER_24_1081 vccd vssd sg13cmos5l_decap_8
XFILLER_4_1120 vccd vssd sg13cmos5l_decap_8
X_1042_ _1042_/Y _1042_/A _1042_/B vccd vssd sg13cmos5l_nand2_1
XFILLER_21_2692 vccd vssd sg13cmos5l_decap_8
XFILLER_19_574 vccd vssd sg13cmos5l_decap_8
XFILLER_0_42 vccd vssd sg13cmos5l_decap_8
XFILLER_21_1980 vccd vssd sg13cmos5l_decap_8
XFILLER_1_2786 vccd vssd sg13cmos5l_decap_4
XFILLER_4_1197 vccd vssd sg13cmos5l_decap_8
XFILLER_17_2706 vccd vssd sg13cmos5l_decap_8
XFILLER_37_2187 vccd vssd sg13cmos5l_decap_8
XFILLER_34_599 vccd vssd sg13cmos5l_decap_8
XFILLER_22_728 vccd vssd sg13cmos5l_decap_8
XFILLER_15_791 vccd vssd sg13cmos5l_decap_8
XFILLER_30_750 vccd vssd sg13cmos5l_decap_8
XFILLER_21_238 vccd vssd sg13cmos5l_decap_8
XFILLER_15_2430 vccd vssd sg13cmos5l_decap_8
XFILLER_9_84 vccd vssd sg13cmos5l_decap_8
XFILLER_11_2305 vccd vssd sg13cmos5l_decap_8
XFILLER_31_1030 vccd vssd sg13cmos5l_decap_8
X_0826_ _0826_/Y _0826_/A vccd vssd sg13cmos5l_inv_1
XFILLER_31_1096 vccd vssd sg13cmos5l_decap_8
XFILLER_11_1659 vccd vssd sg13cmos5l_decap_8
XFILLER_44_2103 vccd vssd sg13cmos5l_decap_8
Xoutbuffers\[71\] control[71] _1739_/Q vccd vssd sg13cmos5l_buf_8
XFILLER_44_1413 vccd vssd sg13cmos5l_decap_8
XFILLER_9_1064 vccd vssd sg13cmos5l_decap_8
XFILLER_22_2445 vccd vssd sg13cmos5l_decap_8
XFILLER_22_1711 vccd vssd sg13cmos5l_decap_8
XFILLER_2_2506 vccd vssd sg13cmos5l_decap_8
XFILLER_6_2664 vccd vssd sg13cmos5l_decap_8
X_1309_ _1311_/A status[113] wire81/X _1309_/B1 status[105] vccd vssd sg13cmos5l_a22oi_1
XFILLER_28_49 vccd vssd sg13cmos5l_decap_8
XFILLER_6_1974 vccd vssd sg13cmos5l_decap_8
XFILLER_44_308 vccd vssd sg13cmos5l_decap_8
XFILLER_2_1827 vccd vssd sg13cmos5l_decap_8
XFILLER_37_371 vccd vssd sg13cmos5l_decap_8
XFILLER_25_511 vccd vssd sg13cmos5l_decap_8
XFILLER_22_1788 vccd vssd sg13cmos5l_decap_8
XFILLER_0_1540 vccd vssd sg13cmos5l_decap_8
XFILLER_25_577 vccd vssd sg13cmos5l_decap_8
XFILLER_0_2296 vccd vssd sg13cmos5l_decap_8
XFILLER_40_525 vccd vssd sg13cmos5l_decap_8
XFILLER_16_2216 vccd vssd sg13cmos5l_decap_8
XFILLER_13_728 vccd vssd sg13cmos5l_decap_8
XFILLER_33_2552 vccd vssd sg13cmos5l_decap_8
XFILLER_16_1526 vccd vssd sg13cmos5l_decap_8
XFILLER_12_238 vccd vssd sg13cmos5l_decap_8
XFILLER_5_938 vccd vssd sg13cmos5l_decap_8
XFILLER_4_448 vccd vssd sg13cmos5l_decap_8
XFILLER_10_1169 vccd vssd sg13cmos5l_decap_8
XFILLER_44_2681 vccd vssd sg13cmos5l_decap_8
XFILLER_40_2512 vccd vssd sg13cmos5l_decap_8
XFILLER_0_665 vccd vssd sg13cmos5l_decap_8
XFILLER_5_2163 vccd vssd sg13cmos5l_decap_8
XFILLER_44_1991 vccd vssd sg13cmos5l_decap_8
XFILLER_1_2016 vccd vssd sg13cmos5l_decap_8
XFILLER_40_2589 vccd vssd sg13cmos5l_decap_8
XFILLER_40_1855 vccd vssd sg13cmos5l_decap_8
XFILLER_35_308 vccd vssd sg13cmos5l_decap_8
XFILLER_25_1390 vccd vssd sg13cmos5l_decap_8
XFILLER_5_1484 vccd vssd sg13cmos5l_decap_8
XFILLER_44_842 vccd vssd sg13cmos5l_decap_8
XFILLER_28_371 vccd vssd sg13cmos5l_decap_8
XFILLER_16_511 vccd vssd sg13cmos5l_decap_8
XFILLER_1_1337 vccd vssd sg13cmos5l_decap_8
XFILLER_16_588 vccd vssd sg13cmos5l_decap_8
XFILLER_34_1604 vccd vssd sg13cmos5l_decap_8
XFILLER_34_70 vccd vssd sg13cmos5l_decap_8
XFILLER_16_2750 vccd vssd sg13cmos5l_decap_8
XFILLER_34_1648 vccd vssd sg13cmos5l_decap_8
XFILLER_19_1183 vccd vssd sg13cmos5l_decap_8
XFILLER_16_2783 vccd vssd sg13cmos5l_decap_8
XFILLER_15_1036 vccd vssd sg13cmos5l_decap_8
XFILLER_8_721 vccd vssd sg13cmos5l_decap_8
XFILLER_12_2603 vccd vssd sg13cmos5l_decap_8
XFILLER_32_1350 vccd vssd sg13cmos5l_decap_8
XFILLER_7_231 vccd vssd sg13cmos5l_decap_8
X_1660_ _1660_/Q _1660_/CLK _1660_/D _1604_/Y vccd vssd sg13cmos5l_dfrbpq_1
XFILLER_8_798 vccd vssd sg13cmos5l_decap_8
XFILLER_12_1946 vccd vssd sg13cmos5l_decap_8
X_1591_ _1591_/X _1591_/A0 hold474/X _1597_/S vccd vssd sg13cmos5l_mux2_1
XFILLER_32_1394 vccd vssd sg13cmos5l_decap_8
Xhold209 _0898_/B _1806_/Q vccd vssd sg13cmos5l_dlygate4sd3_1
XFILLER_45_2401 vccd vssd sg13cmos5l_decap_8
XFILLER_45_1722 vccd vssd sg13cmos5l_decap_8
XFILLER_45_2478 vccd vssd sg13cmos5l_decap_8
XFILLER_6_1204 vccd vssd sg13cmos5l_decap_8
XFILLER_23_2732 vccd vssd sg13cmos5l_decap_8
XFILLER_45_1799 vccd vssd sg13cmos5l_decap_8
XFILLER_22_1029 vccd vssd sg13cmos5l_decap_8
XFILLER_39_2216 vccd vssd sg13cmos5l_decap_8
XFILLER_38_168 vccd vssd sg13cmos5l_decap_8
XFILLER_26_308 vccd vssd sg13cmos5l_decap_8
XFILLER_19_371 vccd vssd sg13cmos5l_decap_8
XFILLER_1_2583 vccd vssd sg13cmos5l_decap_8
X_1025_ _1025_/Y _1020_/Y _1019_/Y _1024_/Y vccd vssd sg13cmos5l_o21ai_1
XFILLER_35_864 vccd vssd sg13cmos5l_decap_8
XFILLER_22_525 vccd vssd sg13cmos5l_decap_8
XFILLER_17_2547 vccd vssd sg13cmos5l_decap_8
XFILLER_37_1283 vccd vssd sg13cmos5l_decap_8
XFILLER_33_1125 vccd vssd sg13cmos5l_decap_8
XFILLER_17_1846 vccd vssd sg13cmos5l_decap_8
XFILLER_33_1158 vccd vssd sg13cmos5l_decap_8
XFILLER_30_2736 vccd vssd sg13cmos5l_decap_8
XFILLER_30_580 vccd vssd sg13cmos5l_decap_8
XFILLER_11_2135 vccd vssd sg13cmos5l_decap_8
XFILLER_30_28 vccd vssd sg13cmos5l_decap_8
Xfanout3 _1577_/S _1575_/S vccd vssd sg13cmos5l_buf_1
XFILLER_11_1456 vccd vssd sg13cmos5l_decap_8
XFILLER_11_2179 vccd vssd sg13cmos5l_decap_8
X_1789_ _1789_/Q _1795_/CLK _1789_/D fanout115/X vccd vssd sg13cmos5l_dfrbpq_1
XFILLER_8_2704 vccd vssd sg13cmos5l_decap_8
XFILLER_28_2665 vccd vssd sg13cmos5l_decap_8
XFILLER_28_1931 vccd vssd sg13cmos5l_decap_8
XFILLER_44_1210 vccd vssd sg13cmos5l_decap_8
XFILLER_6_2450 vccd vssd sg13cmos5l_decap_8
XFILLER_44_1287 vccd vssd sg13cmos5l_decap_8
XFILLER_22_2242 vccd vssd sg13cmos5l_decap_8
XFILLER_2_2303 vccd vssd sg13cmos5l_decap_8
XFILLER_29_168 vccd vssd sg13cmos5l_decap_8
XFILLER_17_308 vccd vssd sg13cmos5l_decap_8
XFILLER_2_1624 vccd vssd sg13cmos5l_decap_8
XFILLER_6_1771 vccd vssd sg13cmos5l_decap_8
XFILLER_44_105 vccd vssd sg13cmos5l_decap_8
XFILLER_22_1585 vccd vssd sg13cmos5l_decap_8
XFILLER_26_875 vccd vssd sg13cmos5l_decap_8
XFILLER_0_2093 vccd vssd sg13cmos5l_decap_8
XFILLER_38_1025 vccd vssd sg13cmos5l_decap_8
XFILLER_25_385 vccd vssd sg13cmos5l_decap_8
XFILLER_13_525 vccd vssd sg13cmos5l_decap_8
XFILLER_41_845 vccd vssd sg13cmos5l_decap_8
XFILLER_40_322 vccd vssd sg13cmos5l_decap_8
XFILLER_35_2658 vccd vssd sg13cmos5l_decap_8
XFILLER_16_2035 vccd vssd sg13cmos5l_decap_8
XFILLER_16_1323 vccd vssd sg13cmos5l_decap_8
XFILLER_9_518 vccd vssd sg13cmos5l_decap_8
XFILLER_40_399 vccd vssd sg13cmos5l_decap_8
XFILLER_35_1979 vccd vssd sg13cmos5l_decap_8
XFILLER_33_1670 vccd vssd sg13cmos5l_decap_8
XFILLER_5_735 vccd vssd sg13cmos5l_decap_8
XFILLER_4_245 vccd vssd sg13cmos5l_decap_8
XFILLER_45_1029 vccd vssd sg13cmos5l_decap_8
XFILLER_42_2629 vccd vssd sg13cmos5l_decap_8
XFILLER_27_2175 vccd vssd sg13cmos5l_decap_8
XFILLER_27_1441 vccd vssd sg13cmos5l_decap_8
XFILLER_23_2017 vccd vssd sg13cmos5l_decap_8
XFILLER_1_952 vccd vssd sg13cmos5l_decap_8
XFILLER_7_2247 vccd vssd sg13cmos5l_decap_8
XFILLER_42_1917 vccd vssd sg13cmos5l_decap_8
XFILLER_0_462 vccd vssd sg13cmos5l_decap_8
XFILLER_40_2331 vccd vssd sg13cmos5l_decap_8
XFILLER_29_70 vccd vssd sg13cmos5l_decap_8
XFILLER_7_1568 vccd vssd sg13cmos5l_decap_8
XFILLER_36_628 vccd vssd sg13cmos5l_decap_8
XFILLER_35_105 vccd vssd sg13cmos5l_decap_8
XFILLER_1_1134 vccd vssd sg13cmos5l_decap_8
XFILLER_5_1281 vccd vssd sg13cmos5l_decap_8
XFILLER_17_875 vccd vssd sg13cmos5l_decap_8
XFILLER_45_91 vccd vssd sg13cmos5l_decap_8
XFILLER_16_385 vccd vssd sg13cmos5l_decap_8
XFILLER_34_2135 vccd vssd sg13cmos5l_decap_8
XFILLER_32_867 vccd vssd sg13cmos5l_decap_8
XFILLER_31_322 vccd vssd sg13cmos5l_decap_8
XFILLER_34_1434 vccd vssd sg13cmos5l_decap_8
XFILLER_31_399 vccd vssd sg13cmos5l_decap_8
X_1712_ _1712_/Q clkload0/A _1712_/D fanout127/X vccd vssd sg13cmos5l_dfrbpq_1
XFILLER_16_1890 vccd vssd sg13cmos5l_decap_8
XANTENNA_1 RSTB vccd vssd sg13cmos5l_antennanp
X_1643_ _1643_/Y _1644_/A _1643_/B_N vccd vssd sg13cmos5l_nor2b_1
XFILLER_8_595 vccd vssd sg13cmos5l_decap_8
XFILLER_12_1743 vccd vssd sg13cmos5l_decap_8
XFILLER_6_63 vccd vssd sg13cmos5l_decap_8
XFILLER_28_1205 vccd vssd sg13cmos5l_decap_8
X_1574_ _1574_/X _1481_/A hold496/X _1577_/S vccd vssd sg13cmos5l_mux2_1
XFILLER_45_2275 vccd vssd sg13cmos5l_decap_8
XFILLER_41_2139 vccd vssd sg13cmos5l_decap_8
XFILLER_6_1001 vccd vssd sg13cmos5l_decap_8
XFILLER_45_1596 vccd vssd sg13cmos5l_decap_8
XFILLER_41_1405 vccd vssd sg13cmos5l_decap_8
XFILLER_20_0 vccd vssd sg13cmos5l_decap_8
XFILLER_39_455 vccd vssd sg13cmos5l_decap_4
XFILLER_3_1911 vccd vssd sg13cmos5l_decap_8
XFILLER_3_2667 vccd vssd sg13cmos5l_decap_8
XFILLER_6_1078 vccd vssd sg13cmos5l_decap_8
Xoutbuffers\[34\] control[34] _1702_/Q vccd vssd sg13cmos5l_buf_8
XFILLER_26_105 vccd vssd sg13cmos5l_decap_8
XFILLER_23_1883 vccd vssd sg13cmos5l_decap_8
XFILLER_3_1988 vccd vssd sg13cmos5l_decap_8
XFILLER_1_2380 vccd vssd sg13cmos5l_decap_8
XFILLER_41_119 vccd vssd sg13cmos5l_decap_8
X_1008_ _1321_/B _1008_/A _1048_/A vccd vssd sg13cmos5l_nand2_1
XFILLER_25_28 vccd vssd sg13cmos5l_decap_8
XFILLER_23_812 vccd vssd sg13cmos5l_decap_8
XFILLER_34_182 vccd vssd sg13cmos5l_decap_8
XFILLER_22_322 vccd vssd sg13cmos5l_decap_8
XFILLER_17_1610 vccd vssd sg13cmos5l_decap_8
XFILLER_23_889 vccd vssd sg13cmos5l_decap_8
XFILLER_37_1091 vccd vssd sg13cmos5l_decap_8
XFILLER_22_399 vccd vssd sg13cmos5l_decap_8
XFILLER_17_2399 vccd vssd sg13cmos5l_decap_8
XFILLER_17_1687 vccd vssd sg13cmos5l_decap_8
XFILLER_10_539 vccd vssd sg13cmos5l_decap_8
XFILLER_41_49 vccd vssd sg13cmos5l_decap_8
XFILLER_30_1876 vccd vssd sg13cmos5l_decap_8
XFILLER_11_1253 vccd vssd sg13cmos5l_decap_8
XFILLER_2_749 vccd vssd sg13cmos5l_decap_8
XFILLER_9_7 vccd vssd sg13cmos5l_decap_8
XFILLER_1_259 vccd vssd sg13cmos5l_decap_8
XFILLER_8_2534 vccd vssd sg13cmos5l_decap_8
XFILLER_24_2337 vccd vssd sg13cmos5l_decap_4
XFILLER_2_2100 vccd vssd sg13cmos5l_decap_8
XFILLER_4_1708 vccd vssd sg13cmos5l_decap_8
XFILLER_8_1855 vccd vssd sg13cmos5l_decap_8
XFILLER_44_1084 vccd vssd sg13cmos5l_decap_8
XFILLER_41_2684 vccd vssd sg13cmos5l_decap_8
XFILLER_41_1950 vccd vssd sg13cmos5l_decap_8
XFILLER_17_105 vccd vssd sg13cmos5l_decap_8
XFILLER_2_2177 vccd vssd sg13cmos5l_decap_8
XFILLER_2_1421 vccd vssd sg13cmos5l_decap_8
XFILLER_45_469 vccd vssd sg13cmos5l_decap_8
XFILLER_37_2709 vccd vssd sg13cmos5l_decap_8
XFILLER_26_650 vccd vssd sg13cmos5l_decap_8
XFILLER_32_119 vccd vssd sg13cmos5l_decap_8
XFILLER_2_1498 vccd vssd sg13cmos5l_decap_8
XFILLER_14_812 vccd vssd sg13cmos5l_decap_8
XFILLER_41_642 vccd vssd sg13cmos5l_decap_8
XFILLER_39_2591 vccd vssd sg13cmos5l_decap_8
XFILLER_25_182 vccd vssd sg13cmos5l_decap_8
XFILLER_18_1407 vccd vssd sg13cmos5l_decap_8
XFILLER_13_322 vccd vssd sg13cmos5l_decap_8
XFILLER_16_1120 vccd vssd sg13cmos5l_decap_8
XFILLER_9_315 vccd vssd sg13cmos5l_decap_8
XFILLER_14_889 vccd vssd sg13cmos5l_decap_8
XFILLER_35_2499 vccd vssd sg13cmos5l_decap_8
XFILLER_13_399 vccd vssd sg13cmos5l_decap_8
XFILLER_40_196 vccd vssd sg13cmos5l_decap_8
XFILLER_33_2190 vccd vssd sg13cmos5l_decap_8
Xtiedowns\[70\] status[70] vccd vssd sg13cmos5l_antennanp
XFILLER_16_1197 vccd vssd sg13cmos5l_decap_8
XFILLER_5_532 vccd vssd sg13cmos5l_decap_8
XFILLER_13_2786 vccd vssd sg13cmos5l_decap_4
XFILLER_29_2226 vccd vssd sg13cmos5l_decap_8
XFILLER_29_1536 vccd vssd sg13cmos5l_decap_8
XFILLER_42_2426 vccd vssd sg13cmos5l_decap_4
XFILLER_7_2044 vccd vssd sg13cmos5l_decap_8
X_1290_ _1290_/Y _1718_/Q _1337_/B _1114_/B vccd vssd sg13cmos5l_a21oi_1
XFILLER_20_2702 vccd vssd sg13cmos5l_decap_8
XFILLER_37_915 vccd vssd sg13cmos5l_decap_8
Xclkbuf_5_20_0_SCK _1652_/CLK clkbuf_3_5_0_SCK/X vccd vssd sg13cmos5l_buf_8
XFILLER_3_1218 vccd vssd sg13cmos5l_decap_8
XFILLER_7_1365 vccd vssd sg13cmos5l_decap_8
XFILLER_40_2172 vccd vssd sg13cmos5l_decap_8
XFILLER_20_2779 vccd vssd sg13cmos5l_decap_8
XFILLER_24_609 vccd vssd sg13cmos5l_decap_8
Xoutbuffers\[124\] control[124] _1792_/Q vccd vssd sg13cmos5l_buf_8
XFILLER_23_119 vccd vssd sg13cmos5l_decap_8
XFILLER_17_672 vccd vssd sg13cmos5l_decap_8
XFILLER_16_182 vccd vssd sg13cmos5l_decap_8
XFILLER_34_1220 vccd vssd sg13cmos5l_decap_8
XFILLER_32_686 vccd vssd sg13cmos5l_decap_8
XFILLER_20_826 vccd vssd sg13cmos5l_decap_8
XFILLER_18_1985 vccd vssd sg13cmos5l_decap_8
XFILLER_34_1275 vccd vssd sg13cmos5l_decap_8
XFILLER_31_196 vccd vssd sg13cmos5l_decap_8
XFILLER_30_1117 vccd vssd sg13cmos5l_decap_8
XFILLER_14_1827 vccd vssd sg13cmos5l_decap_8
XFILLER_9_882 vccd vssd sg13cmos5l_decap_8
XFILLER_12_1540 vccd vssd sg13cmos5l_decap_8
XFILLER_12_2285 vccd vssd sg13cmos5l_decap_4
XFILLER_8_392 vccd vssd sg13cmos5l_decap_8
X_1557_ _1557_/Y _1557_/A _1567_/S vccd vssd sg13cmos5l_nand2_1
XFILLER_45_2072 vccd vssd sg13cmos5l_decap_8
XFILLER_25_1912 vccd vssd sg13cmos5l_decap_8
XFILLER_25_2679 vccd vssd sg13cmos5l_decap_8
X_1488_ _1716_/D _1488_/A1 _1495_/B hold281/X vccd vssd sg13cmos5l_o21ai_1
XFILLER_45_1393 vccd vssd sg13cmos5l_decap_8
XFILLER_39_252 vccd vssd sg13cmos5l_decap_8
XFILLER_3_2464 vccd vssd sg13cmos5l_decap_8
XFILLER_36_49 vccd vssd sg13cmos5l_decap_8
XFILLER_27_469 vccd vssd sg13cmos5l_decap_8
XFILLER_19_2406 vccd vssd sg13cmos5l_decap_8
XFILLER_15_609 vccd vssd sg13cmos5l_decap_8
XFILLER_36_981 vccd vssd sg13cmos5l_decap_8
XFILLER_3_1785 vccd vssd sg13cmos5l_decap_8
XFILLER_14_119 vccd vssd sg13cmos5l_decap_8
XFILLER_36_2742 vccd vssd sg13cmos5l_decap_8
XFILLER_17_2130 vccd vssd sg13cmos5l_decap_8
XFILLER_23_686 vccd vssd sg13cmos5l_decap_8
XFILLER_11_826 vccd vssd sg13cmos5l_decap_8
XFILLER_13_2016 vccd vssd sg13cmos5l_decap_8
XFILLER_32_1938 vccd vssd sg13cmos5l_decap_8
XFILLER_32_1927 vccd vssd sg13cmos5l_decap_4
XFILLER_22_196 vccd vssd sg13cmos5l_decap_8
XFILLER_17_1484 vccd vssd sg13cmos5l_decap_8
XFILLER_7_819 vccd vssd sg13cmos5l_decap_8
XFILLER_10_336 vccd vssd sg13cmos5l_decap_8
XFILLER_6_329 vccd vssd sg13cmos5l_decap_8
XFILLER_13_1337 vccd vssd sg13cmos5l_decap_8
XFILLER_11_1050 vccd vssd sg13cmos5l_decap_8
Xhold370 _1703_/D _1468_/X vccd vssd sg13cmos5l_dlygate4sd3_1
Xhold381 _0938_/A _1798_/Q vccd vssd sg13cmos5l_dlygate4sd3_1
XFILLER_2_546 vccd vssd sg13cmos5l_decap_8
XFILLER_43_2735 vccd vssd sg13cmos5l_decap_8
Xhold392 hold392/X _1758_/Q vccd vssd sg13cmos5l_dlygate4sd3_1
XFILLER_8_2331 vccd vssd sg13cmos5l_decap_8
XFILLER_24_2134 vccd vssd sg13cmos5l_decap_8
XFILLER_8_1652 vccd vssd sg13cmos5l_decap_8
XFILLER_24_1444 vccd vssd sg13cmos5l_decap_8
XFILLER_4_1505 vccd vssd sg13cmos5l_decap_8
XFILLER_41_2481 vccd vssd sg13cmos5l_decap_8
XFILLER_19_959 vccd vssd sg13cmos5l_decap_8
XFILLER_34_918 vccd vssd sg13cmos5l_decap_8
XFILLER_18_469 vccd vssd sg13cmos5l_decap_8
XFILLER_45_266 vccd vssd sg13cmos5l_decap_8
XFILLER_33_406 vccd vssd sg13cmos5l_decap_8
XFILLER_22_1190 vccd vssd sg13cmos5l_decap_8
XFILLER_18_1204 vccd vssd sg13cmos5l_decap_8
XFILLER_2_1295 vccd vssd sg13cmos5l_decap_8
XFILLER_42_973 vccd vssd sg13cmos5l_decap_8
XFILLER_35_2263 vccd vssd sg13cmos5l_decap_4
XFILLER_9_112 vccd vssd sg13cmos5l_decap_8
XFILLER_14_686 vccd vssd sg13cmos5l_decap_8
XFILLER_42_70 vccd vssd sg13cmos5l_decap_8
XFILLER_13_196 vccd vssd sg13cmos5l_decap_8
XFILLER_9_189 vccd vssd sg13cmos5l_decap_8
XFILLER_13_2572 vccd vssd sg13cmos5l_decap_8
XFILLER_29_1300 vccd vssd sg13cmos5l_decap_8
XFILLER_6_896 vccd vssd sg13cmos5l_decap_8
XFILLER_29_2056 vccd vssd sg13cmos5l_decap_8
XFILLER_9_2128 vccd vssd sg13cmos5l_decap_8
X_1411_ _1411_/Y _0833_/Y _1412_/B hold175/X vccd vssd sg13cmos5l_a21oi_1
XFILLER_42_2212 vccd vssd sg13cmos5l_decap_8
X_1342_ _1342_/Y _1685_/Q _1342_/B vccd vssd sg13cmos5l_nand2b_1
XFILLER_3_42 vccd vssd sg13cmos5l_decap_8
XFILLER_9_1449 vccd vssd sg13cmos5l_decap_8
X_1273_ _1273_/X status[26] _1007_/X _1232_/B vccd vssd sg13cmos5l_a21o_1
XFILLER_42_2289 vccd vssd sg13cmos5l_decap_8
XFILLER_42_1533 vccd vssd sg13cmos5l_decap_8
XFILLER_7_1162 vccd vssd sg13cmos5l_decap_8
Xtiedowns\[114\] status[114] vccd vssd sg13cmos5l_antennanp
XFILLER_37_712 vccd vssd sg13cmos5l_decap_8
XFILLER_3_1015 vccd vssd sg13cmos5l_decap_8
XFILLER_0_2604 vccd vssd sg13cmos5l_decap_8
XFILLER_4_2762 vccd vssd sg13cmos5l_decap_8
XFILLER_20_2576 vccd vssd sg13cmos5l_decap_8
XFILLER_37_789 vccd vssd sg13cmos5l_decap_8
XFILLER_36_266 vccd vssd sg13cmos5l_decap_8
XFILLER_24_406 vccd vssd sg13cmos5l_decap_8
XFILLER_0_1925 vccd vssd sg13cmos5l_decap_8
XFILLER_36_1359 vccd vssd sg13cmos5l_decap_8
XFILLER_20_623 vccd vssd sg13cmos5l_decap_8
XFILLER_18_2483 vccd vssd sg13cmos5l_decap_8
XFILLER_18_1771 vccd vssd sg13cmos5l_decap_8
XFILLER_14_1624 vccd vssd sg13cmos5l_decap_8
XFILLER_14_2358 vccd vssd sg13cmos5l_decap_8
X_0988_ wire73/A _1021_/B _0988_/B _0988_/C _1045_/A vccd vssd sg13cmos5l_nor4_2
XFILLER_31_2661 vccd vssd sg13cmos5l_decap_8
XFILLER_12_2093 vccd vssd sg13cmos5l_decap_8
XFILLER_31_1993 vccd vssd sg13cmos5l_decap_8
Xfanout102 _1504_/A hold520/X vccd vssd sg13cmos5l_buf_1
X_1609_ _1609_/Y _1639_/A _1643_/B_N vccd vssd sg13cmos5l_nor2b_1
Xfanout113 _1600_/A1 _0823_/Y vccd vssd sg13cmos5l_buf_1
Xfanout124 fanout124/X fanout129/X vccd vssd sg13cmos5l_buf_1
Xfanout135 fanout135/X fanout143/X vccd vssd sg13cmos5l_buf_1
XFILLER_9_2673 vccd vssd sg13cmos5l_decap_8
Xfanout146 _1644_/A _1605_/A vccd vssd sg13cmos5l_buf_1
XFILLER_45_1190 vccd vssd sg13cmos5l_decap_8
XFILLER_5_2548 vccd vssd sg13cmos5l_decap_8
XFILLER_41_1043 vccd vssd sg13cmos5l_decap_8
XFILLER_28_723 vccd vssd sg13cmos5l_decap_8
XFILLER_25_1797 vccd vssd sg13cmos5l_decap_8
XFILLER_21_1606 vccd vssd sg13cmos5l_decap_8
XFILLER_3_2261 vccd vssd sg13cmos5l_decap_8
XFILLER_5_1869 vccd vssd sg13cmos5l_decap_8
XFILLER_43_704 vccd vssd sg13cmos5l_decap_8
XFILLER_27_266 vccd vssd sg13cmos5l_decap_8
XFILLER_3_1582 vccd vssd sg13cmos5l_decap_8
XFILLER_15_406 vccd vssd sg13cmos5l_decap_8
XFILLER_19_2247 vccd vssd sg13cmos5l_decap_8
XFILLER_24_973 vccd vssd sg13cmos5l_decap_8
XFILLER_23_483 vccd vssd sg13cmos5l_decap_8
XFILLER_19_1568 vccd vssd sg13cmos5l_decap_8
XFILLER_11_623 vccd vssd sg13cmos5l_decap_8
XFILLER_32_2458 vccd vssd sg13cmos5l_decap_8
XFILLER_32_1713 vccd vssd sg13cmos5l_decap_8
XFILLER_7_616 vccd vssd sg13cmos5l_decap_8
XFILLER_10_133 vccd vssd sg13cmos5l_decap_8
XFILLER_17_1281 vccd vssd sg13cmos5l_decap_8
XFILLER_6_126 vccd vssd sg13cmos5l_decap_8
XFILLER_10_2712 vccd vssd sg13cmos5l_decap_8
XFILLER_13_1134 vccd vssd sg13cmos5l_decap_8
XFILLER_10_2745 vccd vssd sg13cmos5l_decap_8
XFILLER_12_84 vccd vssd sg13cmos5l_decap_8
XFILLER_3_833 vccd vssd sg13cmos5l_decap_8
XFILLER_2_343 vccd vssd sg13cmos5l_decap_8
XFILLER_43_2554 vccd vssd sg13cmos5l_decap_4
Xtiedowns\[33\] status[33] vccd vssd sg13cmos5l_antennanp
XFILLER_38_509 vccd vssd sg13cmos5l_decap_8
XFILLER_4_1302 vccd vssd sg13cmos5l_decap_8
XFILLER_43_1864 vccd vssd sg13cmos5l_decap_8
XFILLER_4_2058 vccd vssd sg13cmos5l_decap_8
XFILLER_20_1127 vccd vssd sg13cmos5l_decap_8
XFILLER_19_756 vccd vssd sg13cmos5l_decap_8
XFILLER_37_70 vccd vssd sg13cmos5l_decap_8
XFILLER_33_203 vccd vssd sg13cmos5l_decap_8
XFILLER_18_266 vccd vssd sg13cmos5l_decap_8
XFILLER_4_1379 vccd vssd sg13cmos5l_decap_8
XFILLER_2_1092 vccd vssd sg13cmos5l_decap_8
XFILLER_37_1624 vccd vssd sg13cmos5l_decap_8
XFILLER_18_1001 vccd vssd sg13cmos5l_decap_8
XFILLER_15_973 vccd vssd sg13cmos5l_decap_8
XFILLER_37_1679 vccd vssd sg13cmos5l_decap_4
XFILLER_30_910 vccd vssd sg13cmos5l_decap_8
XFILLER_15_2634 vccd vssd sg13cmos5l_decap_8
XFILLER_14_483 vccd vssd sg13cmos5l_decap_8
XFILLER_41_291 vccd vssd sg13cmos5l_decap_8
X_0911_ _0911_/Y _0912_/C vccd vssd sg13cmos5l_inv_1
XFILLER_18_1078 vccd vssd sg13cmos5l_decap_8
XFILLER_15_1911 vccd vssd sg13cmos5l_decap_8
X_0842_ _0842_/Y _0842_/A vccd vssd sg13cmos5l_inv_1
XFILLER_15_1988 vccd vssd sg13cmos5l_decap_8
XFILLER_13_2391 vccd vssd sg13cmos5l_decap_8
XFILLER_6_693 vccd vssd sg13cmos5l_decap_8
XFILLER_9_1246 vccd vssd sg13cmos5l_decap_8
XFILLER_42_2053 vccd vssd sg13cmos5l_decap_8
X_1325_ _1326_/A _1588_/B _1789_/Q _1279_/B _1781_/Q _1151_/B vccd vssd sg13cmos5l_a221oi_1
XFILLER_22_2627 vccd vssd sg13cmos5l_decap_8
XFILLER_42_1330 vccd vssd sg13cmos5l_decap_8
XFILLER_37_531 vccd vssd sg13cmos5l_decap_8
XFILLER_0_2401 vccd vssd sg13cmos5l_decap_8
X_1256_ _1256_/Y _1253_/Y _1254_/Y _1255_/Y vccd vssd sg13cmos5l_o21ai_1
X_1187_ _1187_/Y status[20] _1232_/B _1147_/B status[12] _1148_/B vccd vssd sg13cmos5l_a221oi_1
XFILLER_20_2373 vccd vssd sg13cmos5l_decap_8
XFILLER_0_1722 vccd vssd sg13cmos5l_decap_8
XFILLER_37_586 vccd vssd sg13cmos5l_decap_8
XFILLER_25_759 vccd vssd sg13cmos5l_decap_8
XFILLER_24_203 vccd vssd sg13cmos5l_decap_8
XFILLER_20_1661 vccd vssd sg13cmos5l_decap_8
XFILLER_0_2478 vccd vssd sg13cmos5l_decap_8
XFILLER_40_718 vccd vssd sg13cmos5l_decap_8
XFILLER_16_2409 vccd vssd sg13cmos5l_decap_8
XFILLER_0_1799 vccd vssd sg13cmos5l_decap_8
XFILLER_36_1123 vccd vssd sg13cmos5l_decap_8
XFILLER_33_2734 vccd vssd sg13cmos5l_decap_8
XFILLER_33_28 vccd vssd sg13cmos5l_decap_8
XFILLER_21_910 vccd vssd sg13cmos5l_decap_8
XFILLER_16_1708 vccd vssd sg13cmos5l_decap_8
XFILLER_14_2100 vccd vssd sg13cmos5l_decap_8
XFILLER_32_1009 vccd vssd sg13cmos5l_decap_8
XFILLER_32_280 vccd vssd sg13cmos5l_decap_8
XFILLER_20_420 vccd vssd sg13cmos5l_decap_8
XFILLER_21_987 vccd vssd sg13cmos5l_decap_8
XFILLER_14_1421 vccd vssd sg13cmos5l_decap_8
XFILLER_20_497 vccd vssd sg13cmos5l_decap_8
XFILLER_14_1498 vccd vssd sg13cmos5l_decap_8
XFILLER_31_1790 vccd vssd sg13cmos5l_decap_8
XFILLER_27_2516 vccd vssd sg13cmos5l_decap_8
XFILLER_43_1105 vccd vssd sg13cmos5l_decap_4
XFILLER_0_847 vccd vssd sg13cmos5l_decap_8
XFILLER_5_2345 vccd vssd sg13cmos5l_decap_8
XFILLER_9_2492 vccd vssd sg13cmos5l_decap_8
XFILLER_21_2126 vccd vssd sg13cmos5l_decap_8
XFILLER_21_1414 vccd vssd sg13cmos5l_decap_8
XFILLER_5_1666 vccd vssd sg13cmos5l_decap_8
XFILLER_28_553 vccd vssd sg13cmos5l_decap_8
XFILLER_1_1519 vccd vssd sg13cmos5l_decap_8
XFILLER_43_534 vccd vssd sg13cmos5l_decap_8
XFILLER_38_2623 vccd vssd sg13cmos5l_decap_8
XFILLER_19_2000 vccd vssd sg13cmos5l_decap_8
XFILLER_15_203 vccd vssd sg13cmos5l_decap_8
XFILLER_43_545 vccd vssd sg13cmos5l_decap_4
XFILLER_38_1922 vccd vssd sg13cmos5l_decap_8
XFILLER_31_718 vccd vssd sg13cmos5l_decap_8
XFILLER_30_217 vccd vssd sg13cmos5l_decap_8
XFILLER_24_770 vccd vssd sg13cmos5l_decap_8
XFILLER_12_910 vccd vssd sg13cmos5l_decap_8
XFILLER_36_2391 vccd vssd sg13cmos5l_decap_8
XFILLER_23_280 vccd vssd sg13cmos5l_decap_8
XFILLER_19_1365 vccd vssd sg13cmos5l_decap_8
XFILLER_15_1218 vccd vssd sg13cmos5l_decap_8
XFILLER_8_903 vccd vssd sg13cmos5l_decap_8
XFILLER_11_420 vccd vssd sg13cmos5l_decap_8
XFILLER_7_413 vccd vssd sg13cmos5l_decap_8
XFILLER_12_987 vccd vssd sg13cmos5l_decap_8
XFILLER_11_497 vccd vssd sg13cmos5l_decap_8
XFILLER_10_2542 vccd vssd sg13cmos5l_decap_4
XFILLER_3_630 vccd vssd sg13cmos5l_decap_8
XFILLER_10_1841 vccd vssd sg13cmos5l_decap_8
XFILLER_10_2586 vccd vssd sg13cmos5l_decap_8
XFILLER_45_1904 vccd vssd sg13cmos5l_decap_8
XFILLER_2_140 vccd vssd sg13cmos5l_decap_8
XFILLER_26_2059 vccd vssd sg13cmos5l_decap_8
XFILLER_24_7 vccd vssd sg13cmos5l_decap_8
X_1110_ _1110_/Y _0869_/Y _1284_/B1 _1198_/A vccd vssd sg13cmos5l_a21oi_1
XFILLER_24_1060 vccd vssd sg13cmos5l_decap_8
X_1041_ _1041_/X _1042_/A _1042_/B vccd vssd sg13cmos5l_and2_1
XFILLER_21_2671 vccd vssd sg13cmos5l_decap_8
XFILLER_19_553 vccd vssd sg13cmos5l_decap_8
XFILLER_1_2765 vccd vssd sg13cmos5l_decap_8
XFILLER_0_21 vccd vssd sg13cmos5l_decap_8
XFILLER_4_1176 vccd vssd sg13cmos5l_decap_8
XFILLER_0_1029 vccd vssd sg13cmos5l_decap_8
XFILLER_34_556 vccd vssd sg13cmos5l_decap_8
XFILLER_22_707 vccd vssd sg13cmos5l_decap_8
XFILLER_0_98 vccd vssd sg13cmos5l_decap_8
XFILLER_37_2166 vccd vssd sg13cmos5l_decap_8
XFILLER_21_217 vccd vssd sg13cmos5l_decap_8
XFILLER_15_770 vccd vssd sg13cmos5l_decap_8
XFILLER_37_1454 vccd vssd sg13cmos5l_decap_4
XFILLER_33_1318 vccd vssd sg13cmos5l_decap_4
XFILLER_9_63 vccd vssd sg13cmos5l_decap_8
XFILLER_14_280 vccd vssd sg13cmos5l_decap_8
XFILLER_15_2486 vccd vssd sg13cmos5l_decap_8
XFILLER_31_1075 vccd vssd sg13cmos5l_decap_8
X_0825_ _1407_/A _1394_/A vccd vssd sg13cmos5l_inv_1
XFILLER_15_1785 vccd vssd sg13cmos5l_decap_8
XFILLER_7_980 vccd vssd sg13cmos5l_decap_8
XFILLER_11_1638 vccd vssd sg13cmos5l_decap_8
XFILLER_6_490 vccd vssd sg13cmos5l_decap_8
XFILLER_44_2159 vccd vssd sg13cmos5l_decap_8
Xoutbuffers\[64\] control[64] _1732_/Q vccd vssd sg13cmos5l_buf_8
XFILLER_6_2643 vccd vssd sg13cmos5l_decap_8
XFILLER_9_1043 vccd vssd sg13cmos5l_decap_8
XFILLER_44_1469 vccd vssd sg13cmos5l_decap_8
XFILLER_28_28 vccd vssd sg13cmos5l_decap_8
XFILLER_22_2424 vccd vssd sg13cmos5l_decap_8
X_1308_ _1311_/B status[97] _1357_/A2 _1261_/B vccd vssd sg13cmos5l_a21oi_1
XFILLER_2_1806 vccd vssd sg13cmos5l_decap_8
XFILLER_6_1953 vccd vssd sg13cmos5l_decap_8
XFILLER_42_1193 vccd vssd sg13cmos5l_decap_8
XFILLER_37_350 vccd vssd sg13cmos5l_decap_8
X_1239_ _1239_/Y _1759_/Q _1544_/B _1155_/B vccd vssd sg13cmos5l_a21oi_1
XFILLER_22_1767 vccd vssd sg13cmos5l_decap_8
XFILLER_0_2275 vccd vssd sg13cmos5l_decap_8
XFILLER_44_49 vccd vssd sg13cmos5l_decap_8
XFILLER_25_567 vccd vssd sg13cmos5l_decap_4
XFILLER_13_707 vccd vssd sg13cmos5l_decap_8
XFILLER_40_504 vccd vssd sg13cmos5l_decap_8
XFILLER_0_1596 vccd vssd sg13cmos5l_decap_8
XFILLER_12_217 vccd vssd sg13cmos5l_decap_8
XFILLER_16_1505 vccd vssd sg13cmos5l_decap_8
XFILLER_33_1863 vccd vssd sg13cmos5l_decap_8
XFILLER_21_784 vccd vssd sg13cmos5l_decap_8
XFILLER_20_294 vccd vssd sg13cmos5l_decap_8
XFILLER_5_917 vccd vssd sg13cmos5l_decap_8
XFILLER_4_427 vccd vssd sg13cmos5l_decap_8
XFILLER_10_1148 vccd vssd sg13cmos5l_decap_8
XFILLER_14_1295 vccd vssd sg13cmos5l_decap_8
XFILLER_27_2346 vccd vssd sg13cmos5l_decap_8
XFILLER_7_2429 vccd vssd sg13cmos5l_decap_8
XFILLER_44_2660 vccd vssd sg13cmos5l_decap_8
XFILLER_0_644 vccd vssd sg13cmos5l_decap_8
XFILLER_44_1970 vccd vssd sg13cmos5l_decap_8
XFILLER_27_1678 vccd vssd sg13cmos5l_decap_4
XFILLER_5_2142 vccd vssd sg13cmos5l_decap_8
XFILLER_40_2568 vccd vssd sg13cmos5l_decap_8
XFILLER_40_1834 vccd vssd sg13cmos5l_decap_8
XFILLER_21_1211 vccd vssd sg13cmos5l_decap_8
XFILLER_29_873 vccd vssd sg13cmos5l_decap_8
XFILLER_28_350 vccd vssd sg13cmos5l_decap_8
XFILLER_1_1316 vccd vssd sg13cmos5l_decap_8
XFILLER_5_1463 vccd vssd sg13cmos5l_decap_8
XFILLER_44_821 vccd vssd sg13cmos5l_decap_8
XFILLER_21_1288 vccd vssd sg13cmos5l_decap_8
XFILLER_16_567 vccd vssd sg13cmos5l_decap_8
XFILLER_44_887 vccd vssd sg13cmos5l_decap_8
XFILLER_38_2497 vccd vssd sg13cmos5l_decap_8
Xclkbuf_3_2_0_SCK clkbuf_5_9_0_SCK/A clkbuf_0_SCK/X vccd vssd sg13cmos5l_buf_8
XFILLER_31_515 vccd vssd sg13cmos5l_decap_8
XFILLER_19_1162 vccd vssd sg13cmos5l_decap_8
XFILLER_38_1796 vccd vssd sg13cmos5l_decap_8
XFILLER_16_2762 vccd vssd sg13cmos5l_decap_8
XFILLER_15_1015 vccd vssd sg13cmos5l_decap_8
XFILLER_8_700 vccd vssd sg13cmos5l_decap_8
XFILLER_7_210 vccd vssd sg13cmos5l_decap_8
XFILLER_12_784 vccd vssd sg13cmos5l_decap_8
XFILLER_12_2659 vccd vssd sg13cmos5l_decap_8
XFILLER_8_777 vccd vssd sg13cmos5l_decap_8
XFILLER_11_294 vccd vssd sg13cmos5l_decap_8
XFILLER_12_1925 vccd vssd sg13cmos5l_decap_8
X_1590_ _1788_/D _1590_/A1 _1597_/S hold307/X vccd vssd sg13cmos5l_o21ai_1
XFILLER_7_287 vccd vssd sg13cmos5l_decap_8
XFILLER_10_2394 vccd vssd sg13cmos5l_decap_8
XFILLER_45_2457 vccd vssd sg13cmos5l_decap_8
XFILLER_45_1701 vccd vssd sg13cmos5l_decap_8
XFILLER_4_994 vccd vssd sg13cmos5l_decap_8
XFILLER_23_2711 vccd vssd sg13cmos5l_decap_8
XFILLER_45_1778 vccd vssd sg13cmos5l_decap_8
XFILLER_43_2170 vccd vssd sg13cmos5l_decap_8
XFILLER_41_1609 vccd vssd sg13cmos5l_decap_8
XFILLER_39_659 vccd vssd sg13cmos5l_decap_8
XFILLER_26_1188 vccd vssd sg13cmos5l_decap_8
XFILLER_22_1008 vccd vssd sg13cmos5l_decap_8
XFILLER_38_147 vccd vssd sg13cmos5l_decap_8
XFILLER_19_350 vccd vssd sg13cmos5l_decap_8
X_1024_ _1024_/Y _1795_/Q _1588_/B _1279_/B vccd vssd sg13cmos5l_a21oi_1
XFILLER_1_2562 vccd vssd sg13cmos5l_decap_8
XFILLER_39_1549 vccd vssd sg13cmos5l_decap_8
XFILLER_35_898 vccd vssd sg13cmos5l_decap_8
XFILLER_34_364 vccd vssd sg13cmos5l_decap_8
XFILLER_22_504 vccd vssd sg13cmos5l_decap_8
XFILLER_1_1883 vccd vssd sg13cmos5l_decap_8
XFILLER_37_1251 vccd vssd sg13cmos5l_decap_8
XFILLER_17_1836 vccd vssd sg13cmos5l_decap_4
Xoutbuffers\[8\] control[8] _1676_/Q vccd vssd sg13cmos5l_buf_8
XFILLER_30_2715 vccd vssd sg13cmos5l_decap_8
XFILLER_11_2114 vccd vssd sg13cmos5l_decap_8
XFILLER_15_1582 vccd vssd sg13cmos5l_decap_8
Xfanout4 _1567_/S _1566_/S vccd vssd sg13cmos5l_buf_1
XFILLER_11_1435 vccd vssd sg13cmos5l_decap_8
X_1788_ _1788_/Q _1790_/CLK _1788_/D fanout115/X vccd vssd sg13cmos5l_dfrbpq_1
XFILLER_28_2644 vccd vssd sg13cmos5l_decap_8
XFILLER_28_1910 vccd vssd sg13cmos5l_decap_8
XFILLER_39_49 vccd vssd sg13cmos5l_decap_8
XFILLER_28_1987 vccd vssd sg13cmos5l_decap_8
XFILLER_22_2221 vccd vssd sg13cmos5l_decap_8
XFILLER_44_1266 vccd vssd sg13cmos5l_decap_8
XFILLER_40_1108 vccd vssd sg13cmos5l_decap_4
XFILLER_6_1750 vccd vssd sg13cmos5l_decap_8
XFILLER_29_147 vccd vssd sg13cmos5l_decap_8
XFILLER_2_2359 vccd vssd sg13cmos5l_decap_8
XFILLER_2_1603 vccd vssd sg13cmos5l_decap_8
XFILLER_22_1564 vccd vssd sg13cmos5l_decap_8
XFILLER_26_854 vccd vssd sg13cmos5l_decap_8
XFILLER_0_2072 vccd vssd sg13cmos5l_decap_8
XFILLER_41_824 vccd vssd sg13cmos5l_decap_8
XFILLER_39_2773 vccd vssd sg13cmos5l_decap_8
XFILLER_40_301 vccd vssd sg13cmos5l_decap_8
XFILLER_25_364 vccd vssd sg13cmos5l_decap_8
XFILLER_16_2014 vccd vssd sg13cmos5l_decap_8
XFILLER_13_504 vccd vssd sg13cmos5l_decap_8
XFILLER_35_2637 vccd vssd sg13cmos5l_decap_8
XFILLER_16_1302 vccd vssd sg13cmos5l_decap_8
XFILLER_0_1393 vccd vssd sg13cmos5l_decap_8
XFILLER_35_1958 vccd vssd sg13cmos5l_decap_8
XFILLER_33_2383 vccd vssd sg13cmos5l_decap_8
XFILLER_21_581 vccd vssd sg13cmos5l_decap_8
XFILLER_16_1379 vccd vssd sg13cmos5l_decap_8
XFILLER_5_714 vccd vssd sg13cmos5l_decap_8
XFILLER_29_2419 vccd vssd sg13cmos5l_decap_8
XFILLER_4_224 vccd vssd sg13cmos5l_decap_8
XFILLER_14_1092 vccd vssd sg13cmos5l_decap_8
XFILLER_45_1008 vccd vssd sg13cmos5l_decap_8
XFILLER_20_84 vccd vssd sg13cmos5l_decap_8
XFILLER_27_2154 vccd vssd sg13cmos5l_decap_8
XFILLER_27_1431 vccd vssd sg13cmos5l_decap_4
XFILLER_1_931 vccd vssd sg13cmos5l_decap_8
XFILLER_7_2226 vccd vssd sg13cmos5l_decap_8
XFILLER_40_2310 vccd vssd sg13cmos5l_decap_8
XFILLER_0_441 vccd vssd sg13cmos5l_decap_8
XFILLER_27_1497 vccd vssd sg13cmos5l_decap_8
XFILLER_23_1328 vccd vssd sg13cmos5l_decap_8
XFILLER_7_1547 vccd vssd sg13cmos5l_decap_8
XFILLER_40_2387 vccd vssd sg13cmos5l_decap_8
XFILLER_40_1642 vccd vssd sg13cmos5l_decap_8
XFILLER_36_607 vccd vssd sg13cmos5l_decap_8
XFILLER_5_1260 vccd vssd sg13cmos5l_decap_8
XFILLER_29_692 vccd vssd sg13cmos5l_decap_8
XFILLER_1_1113 vccd vssd sg13cmos5l_decap_8
XFILLER_40_1697 vccd vssd sg13cmos5l_decap_8
XFILLER_21_1085 vccd vssd sg13cmos5l_decap_8
XFILLER_17_854 vccd vssd sg13cmos5l_decap_8
XFILLER_45_70 vccd vssd sg13cmos5l_decap_8
XFILLER_44_684 vccd vssd sg13cmos5l_decap_8
XFILLER_31_301 vccd vssd sg13cmos5l_decap_8
XFILLER_16_364 vccd vssd sg13cmos5l_decap_8
XFILLER_43_183 vccd vssd sg13cmos5l_decap_8
XFILLER_32_846 vccd vssd sg13cmos5l_decap_8
XFILLER_31_378 vccd vssd sg13cmos5l_decap_8
XFILLER_12_581 vccd vssd sg13cmos5l_decap_8
X_1711_ _1711_/Q _1711_/CLK _1711_/D fanout130/X vccd vssd sg13cmos5l_dfrbpq_1
XFILLER_8_574 vccd vssd sg13cmos5l_decap_8
XFILLER_12_1722 vccd vssd sg13cmos5l_decap_8
XFILLER_32_1192 vccd vssd sg13cmos5l_decap_8
XANTENNA_2 RSTB vccd vssd sg13cmos5l_antennanp
XFILLER_6_42 vccd vssd sg13cmos5l_decap_8
X_1642_ _1642_/Y _1644_/A _1643_/B_N vccd vssd sg13cmos5l_nor2b_1
XFILLER_10_2191 vccd vssd sg13cmos5l_decap_8
XFILLER_12_1799 vccd vssd sg13cmos5l_decap_8
X_1573_ _1573_/X _1562_/A hold494/X _1577_/S vccd vssd sg13cmos5l_mux2_1
XFILLER_45_2254 vccd vssd sg13cmos5l_decap_8
XFILLER_28_1239 vccd vssd sg13cmos5l_decap_8
XFILLER_4_791 vccd vssd sg13cmos5l_decap_8
XFILLER_41_2118 vccd vssd sg13cmos5l_decap_8
XFILLER_39_401 vccd vssd sg13cmos5l_decap_8
XFILLER_45_1575 vccd vssd sg13cmos5l_decap_8
XFILLER_39_434 vccd vssd sg13cmos5l_decap_8
XFILLER_23_2585 vccd vssd sg13cmos5l_decap_8
XFILLER_3_2646 vccd vssd sg13cmos5l_decap_8
XFILLER_6_1057 vccd vssd sg13cmos5l_decap_8
XFILLER_13_0 vccd vssd sg13cmos5l_decap_8
XFILLER_23_1862 vccd vssd sg13cmos5l_decap_8
Xoutbuffers\[27\] control[27] _1695_/Q vccd vssd sg13cmos5l_buf_8
XFILLER_39_2036 vccd vssd sg13cmos5l_decap_8
XFILLER_39_1313 vccd vssd sg13cmos5l_decap_8
XFILLER_3_1967 vccd vssd sg13cmos5l_decap_8
X_1007_ _1007_/X _1036_/A _1048_/A vccd vssd sg13cmos5l_and2_1
XFILLER_34_161 vccd vssd sg13cmos5l_decap_8
XFILLER_22_301 vccd vssd sg13cmos5l_decap_8
XFILLER_19_1909 vccd vssd sg13cmos5l_decap_8
XFILLER_1_1680 vccd vssd sg13cmos5l_decap_8
XFILLER_35_695 vccd vssd sg13cmos5l_decap_8
XFILLER_17_2334 vccd vssd sg13cmos5l_decap_4
XFILLER_37_1070 vccd vssd sg13cmos5l_decap_8
XFILLER_23_868 vccd vssd sg13cmos5l_decap_8
XFILLER_17_2378 vccd vssd sg13cmos5l_decap_8
XFILLER_13_2209 vccd vssd sg13cmos5l_decap_8
XFILLER_41_28 vccd vssd sg13cmos5l_decap_8
XFILLER_22_378 vccd vssd sg13cmos5l_decap_8
XFILLER_17_1666 vccd vssd sg13cmos5l_decap_8
XFILLER_10_518 vccd vssd sg13cmos5l_decap_8
XFILLER_13_1519 vccd vssd sg13cmos5l_decap_8
XFILLER_30_2589 vccd vssd sg13cmos5l_decap_8
XFILLER_11_1232 vccd vssd sg13cmos5l_decap_8
Xhold530 hold530/X _1656_/Q vccd vssd sg13cmos5l_dlygate4sd3_1
XFILLER_2_728 vccd vssd sg13cmos5l_decap_8
XFILLER_8_2513 vccd vssd sg13cmos5l_decap_8
XFILLER_24_2316 vccd vssd sg13cmos5l_decap_8
XFILLER_1_238 vccd vssd sg13cmos5l_decap_8
XFILLER_28_2485 vccd vssd sg13cmos5l_decap_8
XFILLER_8_1834 vccd vssd sg13cmos5l_decap_8
XFILLER_44_1063 vccd vssd sg13cmos5l_decap_8
XFILLER_28_1784 vccd vssd sg13cmos5l_decap_8
XFILLER_41_2663 vccd vssd sg13cmos5l_decap_8
XFILLER_24_1659 vccd vssd sg13cmos5l_decap_8
XFILLER_22_2095 vccd vssd sg13cmos5l_decap_8
XFILLER_2_2156 vccd vssd sg13cmos5l_decap_8
XFILLER_2_1400 vccd vssd sg13cmos5l_decap_8
XFILLER_45_448 vccd vssd sg13cmos5l_decap_8
XFILLER_39_2570 vccd vssd sg13cmos5l_decap_8
XFILLER_18_2109 vccd vssd sg13cmos5l_decap_8
XFILLER_2_1477 vccd vssd sg13cmos5l_decap_8
XFILLER_41_621 vccd vssd sg13cmos5l_decap_8
XFILLER_25_161 vccd vssd sg13cmos5l_decap_8
XFILLER_0_1190 vccd vssd sg13cmos5l_decap_8
XFILLER_13_301 vccd vssd sg13cmos5l_decap_8
XFILLER_35_2478 vccd vssd sg13cmos5l_decap_8
XFILLER_14_868 vccd vssd sg13cmos5l_decap_8
XFILLER_15_84 vccd vssd sg13cmos5l_decap_8
XFILLER_41_698 vccd vssd sg13cmos5l_decap_8
XFILLER_40_175 vccd vssd sg13cmos5l_decap_8
XFILLER_13_378 vccd vssd sg13cmos5l_decap_8
XFILLER_31_1619 vccd vssd sg13cmos5l_decap_8
XFILLER_16_1176 vccd vssd sg13cmos5l_decap_8
XFILLER_13_2765 vccd vssd sg13cmos5l_decap_8
XFILLER_5_511 vccd vssd sg13cmos5l_decap_8
XFILLER_12_1029 vccd vssd sg13cmos5l_decap_8
Xtiedowns\[63\] status[63] vccd vssd sg13cmos5l_antennanp
XFILLER_29_2205 vccd vssd sg13cmos5l_decap_8
XFILLER_5_588 vccd vssd sg13cmos5l_decap_8
XFILLER_42_2405 vccd vssd sg13cmos5l_decap_8
XFILLER_7_2023 vccd vssd sg13cmos5l_decap_8
XFILLER_7_1344 vccd vssd sg13cmos5l_decap_8
XFILLER_42_1748 vccd vssd sg13cmos5l_decap_8
XFILLER_40_2151 vccd vssd sg13cmos5l_decap_8
XFILLER_27_1294 vccd vssd sg13cmos5l_decap_8
XFILLER_23_1169 vccd vssd sg13cmos5l_decap_4
XFILLER_20_2758 vccd vssd sg13cmos5l_decap_8
XFILLER_40_1494 vccd vssd sg13cmos5l_decap_8
XFILLER_36_448 vccd vssd sg13cmos5l_decap_8
XFILLER_36_2209 vccd vssd sg13cmos5l_decap_8
XFILLER_17_651 vccd vssd sg13cmos5l_decap_8
Xoutbuffers\[117\] control[117] _1785_/Q vccd vssd sg13cmos5l_buf_8
XFILLER_16_161 vccd vssd sg13cmos5l_decap_8
XFILLER_32_665 vccd vssd sg13cmos5l_decap_8
XFILLER_20_805 vccd vssd sg13cmos5l_decap_8
XFILLER_18_2687 vccd vssd sg13cmos5l_decap_8
XFILLER_31_175 vccd vssd sg13cmos5l_decap_8
XFILLER_18_1964 vccd vssd sg13cmos5l_decap_8
XFILLER_14_1806 vccd vssd sg13cmos5l_decap_8
XFILLER_9_861 vccd vssd sg13cmos5l_decap_8
XFILLER_8_371 vccd vssd sg13cmos5l_decap_8
XFILLER_12_2264 vccd vssd sg13cmos5l_decap_8
XFILLER_12_1596 vccd vssd sg13cmos5l_decap_8
X_1556_ _1566_/S _1588_/A _1556_/B vccd vssd sg13cmos5l_nand2_1
XFILLER_29_2783 vccd vssd sg13cmos5l_decap_8
XFILLER_45_2051 vccd vssd sg13cmos5l_decap_8
XFILLER_45_1372 vccd vssd sg13cmos5l_decap_8
XFILLER_25_2658 vccd vssd sg13cmos5l_decap_8
X_1487_ _1487_/Y _1487_/A _1495_/B vccd vssd sg13cmos5l_nand2_1
XFILLER_39_231 vccd vssd sg13cmos5l_decap_8
XFILLER_25_1968 vccd vssd sg13cmos5l_decap_8
XFILLER_3_2443 vccd vssd sg13cmos5l_decap_8
XFILLER_41_1269 vccd vssd sg13cmos5l_decap_8
XFILLER_36_28 vccd vssd sg13cmos5l_decap_8
XFILLER_28_949 vccd vssd sg13cmos5l_decap_8
XFILLER_27_448 vccd vssd sg13cmos5l_decap_8
XFILLER_23_1692 vccd vssd sg13cmos5l_decap_8
XFILLER_3_1764 vccd vssd sg13cmos5l_decap_8
XFILLER_42_418 vccd vssd sg13cmos5l_decap_4
XFILLER_39_1154 vccd vssd sg13cmos5l_decap_8
XFILLER_36_2721 vccd vssd sg13cmos5l_decap_8
XFILLER_39_1187 vccd vssd sg13cmos5l_decap_8
XFILLER_23_665 vccd vssd sg13cmos5l_decap_8
XFILLER_11_805 vccd vssd sg13cmos5l_decap_8
XFILLER_32_1906 vccd vssd sg13cmos5l_decap_8
XFILLER_22_175 vccd vssd sg13cmos5l_decap_8
XFILLER_17_2197 vccd vssd sg13cmos5l_decap_8
XFILLER_10_315 vccd vssd sg13cmos5l_decap_8
XFILLER_17_1463 vccd vssd sg13cmos5l_decap_8
XFILLER_6_308 vccd vssd sg13cmos5l_decap_8
XFILLER_13_1316 vccd vssd sg13cmos5l_decap_8
XFILLER_30_2397 vccd vssd sg13cmos5l_decap_8
XFILLER_30_1652 vccd vssd sg13cmos5l_decap_8
XFILLER_30_1696 vccd vssd sg13cmos5l_decap_8
Xhold371 hold371/X _1725_/Q vccd vssd sg13cmos5l_dlygate4sd3_1
Xhold360 hold360/X _1735_/Q vccd vssd sg13cmos5l_dlygate4sd3_1
XFILLER_2_525 vccd vssd sg13cmos5l_decap_8
XFILLER_8_2310 vccd vssd sg13cmos5l_decap_8
XFILLER_43_2714 vccd vssd sg13cmos5l_decap_8
Xhold393 _1758_/D _1549_/X vccd vssd sg13cmos5l_dlygate4sd3_1
XFILLER_24_2113 vccd vssd sg13cmos5l_decap_8
Xhold382 hold382/X _0932_/Y vccd vssd sg13cmos5l_dlygate4sd3_1
XFILLER_28_1581 vccd vssd sg13cmos5l_decap_8
XFILLER_24_1412 vccd vssd sg13cmos5l_decap_8
XFILLER_8_1631 vccd vssd sg13cmos5l_decap_8
XFILLER_8_2387 vccd vssd sg13cmos5l_decap_8
XFILLER_20_1309 vccd vssd sg13cmos5l_decap_8
XFILLER_19_938 vccd vssd sg13cmos5l_decap_8
XFILLER_45_245 vccd vssd sg13cmos5l_decap_8
XFILLER_18_448 vccd vssd sg13cmos5l_decap_8
XFILLER_2_1274 vccd vssd sg13cmos5l_decap_8
XFILLER_42_952 vccd vssd sg13cmos5l_decap_8
XFILLER_14_665 vccd vssd sg13cmos5l_decap_8
XFILLER_41_484 vccd vssd sg13cmos5l_decap_8
XFILLER_13_175 vccd vssd sg13cmos5l_decap_8
XFILLER_31_1449 vccd vssd sg13cmos5l_decap_8
XFILLER_9_168 vccd vssd sg13cmos5l_decap_8
XFILLER_13_2584 vccd vssd sg13cmos5l_decap_8
XFILLER_29_2002 vccd vssd sg13cmos5l_decap_8
XFILLER_10_882 vccd vssd sg13cmos5l_decap_8
XFILLER_6_875 vccd vssd sg13cmos5l_decap_8
XFILLER_9_2107 vccd vssd sg13cmos5l_decap_8
XFILLER_13_1883 vccd vssd sg13cmos5l_decap_8
XFILLER_5_385 vccd vssd sg13cmos5l_decap_8
X_1410_ _1410_/Y _1412_/B _1409_/X _0900_/B vccd vssd sg13cmos5l_a21oi_1
XFILLER_3_21 vccd vssd sg13cmos5l_decap_8
XFILLER_9_1428 vccd vssd sg13cmos5l_decap_8
XFILLER_42_1512 vccd vssd sg13cmos5l_decap_8
X_1341_ _1341_/Y _1339_/Y _1338_/Y _1340_/Y vccd vssd sg13cmos5l_o21ai_1
X_1272_ _1272_/Y _0847_/Y _1363_/A2 _1270_/Y _1271_/Y _1144_/B vccd vssd sg13cmos5l_a221oi_1
XFILLER_3_98 vccd vssd sg13cmos5l_decap_8
XFILLER_4_2730 vccd vssd sg13cmos5l_decap_8
XFILLER_7_1141 vccd vssd sg13cmos5l_decap_8
XFILLER_4_2752 vccd vssd sg13cmos5l_decap_8
XFILLER_42_1589 vccd vssd sg13cmos5l_decap_8
XFILLER_37_768 vccd vssd sg13cmos5l_decap_8
XFILLER_20_2555 vccd vssd sg13cmos5l_decap_8
XFILLER_0_1904 vccd vssd sg13cmos5l_decap_8
Xtiedowns\[107\] status[107] vccd vssd sg13cmos5l_antennanp
XFILLER_40_1291 vccd vssd sg13cmos5l_decap_8
XFILLER_36_245 vccd vssd sg13cmos5l_decap_8
XFILLER_33_930 vccd vssd sg13cmos5l_decap_8
XFILLER_18_2462 vccd vssd sg13cmos5l_decap_8
XFILLER_36_1338 vccd vssd sg13cmos5l_decap_8
XFILLER_20_602 vccd vssd sg13cmos5l_decap_8
XFILLER_18_1750 vccd vssd sg13cmos5l_decap_8
XFILLER_14_2326 vccd vssd sg13cmos5l_decap_8
XFILLER_31_2640 vccd vssd sg13cmos5l_decap_8
XFILLER_14_1603 vccd vssd sg13cmos5l_decap_8
X_0987_ _1064_/A _1070_/A _1045_/A vccd vssd sg13cmos5l_nor2_1
XFILLER_20_679 vccd vssd sg13cmos5l_decap_8
Xoutbuffers\[94\] control[94] _1762_/Q vccd vssd sg13cmos5l_buf_8
XFILLER_12_2072 vccd vssd sg13cmos5l_decap_8
XFILLER_12_1393 vccd vssd sg13cmos5l_decap_8
X_1608_ _1608_/Y _1617_/A _1644_/B_N vccd vssd sg13cmos5l_nor2b_1
Xfanout103 _1562_/A _1445_/A vccd vssd sg13cmos5l_buf_1
XFILLER_29_2580 vccd vssd sg13cmos5l_decap_8
Xfanout114 fanout114/X fanout117/X vccd vssd sg13cmos5l_buf_1
Xfanout147 _1617_/A _1605_/A vccd vssd sg13cmos5l_buf_1
X_1539_ _1539_/X _1481_/A hold472/X _1541_/S vccd vssd sg13cmos5l_mux2_1
Xfanout125 fanout125/X fanout126/X vccd vssd sg13cmos5l_buf_1
XFILLER_5_2527 vccd vssd sg13cmos5l_decap_8
Xfanout136 _1643_/B_N fanout140/X vccd vssd sg13cmos5l_buf_1
XFILLER_9_1995 vccd vssd sg13cmos5l_decap_8
XFILLER_41_1022 vccd vssd sg13cmos5l_decap_8
XFILLER_28_702 vccd vssd sg13cmos5l_decap_8
XFILLER_25_1776 vccd vssd sg13cmos5l_decap_8
XFILLER_3_2240 vccd vssd sg13cmos5l_decap_8
XFILLER_5_1848 vccd vssd sg13cmos5l_decap_8
XFILLER_23_2190 vccd vssd sg13cmos5l_decap_8
XFILLER_41_1099 vccd vssd sg13cmos5l_decap_8
XFILLER_27_245 vccd vssd sg13cmos5l_decap_8
XFILLER_3_1561 vccd vssd sg13cmos5l_decap_8
XFILLER_24_952 vccd vssd sg13cmos5l_decap_8
XFILLER_36_2595 vccd vssd sg13cmos5l_decap_8
XFILLER_23_462 vccd vssd sg13cmos5l_decap_8
XFILLER_19_1547 vccd vssd sg13cmos5l_decap_8
XFILLER_11_602 vccd vssd sg13cmos5l_decap_8
XFILLER_36_1883 vccd vssd sg13cmos5l_decap_8
XFILLER_32_2437 vccd vssd sg13cmos5l_decap_8
XFILLER_17_1260 vccd vssd sg13cmos5l_decap_8
XFILLER_10_112 vccd vssd sg13cmos5l_decap_8
XFILLER_6_105 vccd vssd sg13cmos5l_decap_8
XFILLER_11_679 vccd vssd sg13cmos5l_decap_8
XFILLER_13_1113 vccd vssd sg13cmos5l_decap_8
XFILLER_32_1769 vccd vssd sg13cmos5l_decap_8
XFILLER_10_189 vccd vssd sg13cmos5l_decap_8
XFILLER_12_63 vccd vssd sg13cmos5l_decap_8
XFILLER_3_812 vccd vssd sg13cmos5l_decap_8
XFILLER_30_1482 vccd vssd sg13cmos5l_decap_8
XFILLER_2_322 vccd vssd sg13cmos5l_decap_8
XFILLER_43_2500 vccd vssd sg13cmos5l_decap_4
XFILLER_3_889 vccd vssd sg13cmos5l_decap_8
XFILLER_2_399 vccd vssd sg13cmos5l_decap_8
Xhold190 hold190/X _0832_/Y vccd vssd sg13cmos5l_dlygate4sd3_1
XFILLER_4_2037 vccd vssd sg13cmos5l_decap_8
XFILLER_8_2184 vccd vssd sg13cmos5l_decap_8
Xtiedowns\[26\] status[26] vccd vssd sg13cmos5l_antennanp
XFILLER_24_1264 vccd vssd sg13cmos5l_decap_4
XFILLER_20_1106 vccd vssd sg13cmos5l_decap_8
XFILLER_19_735 vccd vssd sg13cmos5l_decap_8
XFILLER_4_1358 vccd vssd sg13cmos5l_decap_8
XFILLER_18_245 vccd vssd sg13cmos5l_decap_8
XFILLER_2_1071 vccd vssd sg13cmos5l_decap_8
XFILLER_37_1603 vccd vssd sg13cmos5l_decap_8
XFILLER_33_259 vccd vssd sg13cmos5l_decap_8
XFILLER_15_952 vccd vssd sg13cmos5l_decap_8
XFILLER_42_760 vccd vssd sg13cmos5l_decap_8
X_0910_ _0912_/C _1394_/C _0910_/B vccd vssd sg13cmos5l_nand2_1
XFILLER_15_2613 vccd vssd sg13cmos5l_decap_8
XFILLER_14_462 vccd vssd sg13cmos5l_decap_8
XFILLER_42_793 vccd vssd sg13cmos5l_decap_8
XFILLER_41_270 vccd vssd sg13cmos5l_decap_8
XFILLER_35_2083 vccd vssd sg13cmos5l_decap_8
XFILLER_18_1057 vccd vssd sg13cmos5l_decap_8
XFILLER_35_1382 vccd vssd sg13cmos5l_decap_8
X_0841_ _0841_/Y _0841_/A vccd vssd sg13cmos5l_inv_1
XFILLER_15_1967 vccd vssd sg13cmos5l_decap_8
XFILLER_31_1257 vccd vssd sg13cmos5l_decap_8
XFILLER_13_2370 vccd vssd sg13cmos5l_decap_8
XFILLER_6_672 vccd vssd sg13cmos5l_decap_8
XFILLER_13_1680 vccd vssd sg13cmos5l_decap_8
XFILLER_5_182 vccd vssd sg13cmos5l_decap_8
XFILLER_9_1225 vccd vssd sg13cmos5l_decap_8
X_1324_ _1324_/Y status[9] _1324_/B vccd vssd sg13cmos5l_nand2b_1
XFILLER_42_2032 vccd vssd sg13cmos5l_decap_8
XFILLER_26_2775 vccd vssd sg13cmos5l_decap_8
XFILLER_22_2606 vccd vssd sg13cmos5l_decap_8
XFILLER_42_2098 vccd vssd sg13cmos5l_decap_8
XFILLER_22_1916 vccd vssd sg13cmos5l_decap_8
XFILLER_42_1386 vccd vssd sg13cmos5l_decap_8
XFILLER_37_510 vccd vssd sg13cmos5l_decap_8
X_1255_ _1255_/Y mask_rev_in[19] _1347_/B1 _1389_/A2 vccd vssd sg13cmos5l_a21oi_1
X_1186_ _1186_/Y status[28] _1321_/B _1011_/X vccd vssd sg13cmos5l_o21ai_1
XFILLER_20_1640 vccd vssd sg13cmos5l_decap_8
XFILLER_0_2457 vccd vssd sg13cmos5l_decap_8
XFILLER_0_1701 vccd vssd sg13cmos5l_decap_8
XFILLER_25_738 vccd vssd sg13cmos5l_decap_8
XFILLER_36_1102 vccd vssd sg13cmos5l_decap_8
XFILLER_24_259 vccd vssd sg13cmos5l_decap_8
XFILLER_0_1778 vccd vssd sg13cmos5l_decap_8
XFILLER_33_2713 vccd vssd sg13cmos5l_decap_8
XFILLER_36_1179 vccd vssd sg13cmos5l_decap_8
XFILLER_36_1146 vccd vssd sg13cmos5l_decap_8
XFILLER_21_966 vccd vssd sg13cmos5l_decap_8
XFILLER_14_1400 vccd vssd sg13cmos5l_decap_8
XFILLER_20_476 vccd vssd sg13cmos5l_decap_8
XFILLER_10_2009 vccd vssd sg13cmos5l_decap_8
XFILLER_31_2481 vccd vssd sg13cmos5l_decap_8
XFILLER_4_609 vccd vssd sg13cmos5l_decap_8
XFILLER_14_1477 vccd vssd sg13cmos5l_decap_8
XFILLER_3_119 vccd vssd sg13cmos5l_decap_8
XFILLER_12_1190 vccd vssd sg13cmos5l_decap_8
XFILLER_27_1816 vccd vssd sg13cmos5l_decap_8
XFILLER_0_826 vccd vssd sg13cmos5l_decap_8
XFILLER_9_2471 vccd vssd sg13cmos5l_decap_8
XFILLER_5_2324 vccd vssd sg13cmos5l_decap_8
XFILLER_9_1792 vccd vssd sg13cmos5l_decap_8
XFILLER_5_1645 vccd vssd sg13cmos5l_decap_8
XFILLER_38_2602 vccd vssd sg13cmos5l_decap_8
XFILLER_21_1459 vccd vssd sg13cmos5l_decap_8
XFILLER_38_1901 vccd vssd sg13cmos5l_decap_8
XFILLER_28_598 vccd vssd sg13cmos5l_decap_4
XFILLER_16_749 vccd vssd sg13cmos5l_decap_8
XFILLER_38_2679 vccd vssd sg13cmos5l_decap_8
XFILLER_15_259 vccd vssd sg13cmos5l_decap_8
XFILLER_36_2370 vccd vssd sg13cmos5l_decap_8
XFILLER_32_2201 vccd vssd sg13cmos5l_decap_8
XFILLER_19_1344 vccd vssd sg13cmos5l_decap_8
XFILLER_12_966 vccd vssd sg13cmos5l_decap_8
XFILLER_32_1533 vccd vssd sg13cmos5l_decap_8
XFILLER_23_84 vccd vssd sg13cmos5l_decap_8
XFILLER_8_959 vccd vssd sg13cmos5l_decap_8
XFILLER_11_476 vccd vssd sg13cmos5l_decap_8
XFILLER_7_469 vccd vssd sg13cmos5l_decap_8
XFILLER_10_1820 vccd vssd sg13cmos5l_decap_8
XFILLER_10_2565 vccd vssd sg13cmos5l_decap_8
XFILLER_30_1290 vccd vssd sg13cmos5l_decap_8
XFILLER_45_2639 vccd vssd sg13cmos5l_decap_8
XFILLER_10_1897 vccd vssd sg13cmos5l_decap_8
XFILLER_3_686 vccd vssd sg13cmos5l_decap_8
XFILLER_2_196 vccd vssd sg13cmos5l_decap_8
XFILLER_43_1662 vccd vssd sg13cmos5l_decap_8
XFILLER_43_1673 vccd vssd sg13cmos5l_decap_8
XFILLER_38_329 vccd vssd sg13cmos5l_decap_8
XFILLER_21_2650 vccd vssd sg13cmos5l_decap_8
XFILLER_19_532 vccd vssd sg13cmos5l_decap_8
XFILLER_17_7 vccd vssd sg13cmos5l_decap_8
X_1040_ _1040_/Y _1034_/Y _1040_/B vccd vssd sg13cmos5l_nand2b_2
XFILLER_1_2744 vccd vssd sg13cmos5l_decap_8
XFILLER_0_1008 vccd vssd sg13cmos5l_decap_8
XFILLER_4_1155 vccd vssd sg13cmos5l_decap_8
XFILLER_34_535 vccd vssd sg13cmos5l_decap_8
XFILLER_21_1960 vccd vssd sg13cmos5l_decap_4
XFILLER_0_77 vccd vssd sg13cmos5l_decap_8
XFILLER_37_1433 vccd vssd sg13cmos5l_decap_8
XFILLER_33_2009 vccd vssd sg13cmos5l_decap_8
XFILLER_9_42 vccd vssd sg13cmos5l_decap_8
XFILLER_37_1499 vccd vssd sg13cmos5l_decap_8
XFILLER_15_2465 vccd vssd sg13cmos5l_decap_8
X_0824_ _0926_/A _0930_/A vccd vssd sg13cmos5l_inv_1
XFILLER_15_1764 vccd vssd sg13cmos5l_decap_8
XFILLER_11_1617 vccd vssd sg13cmos5l_decap_8
XFILLER_43_0 vccd vssd sg13cmos5l_decap_8
XFILLER_44_2138 vccd vssd sg13cmos5l_decap_8
XFILLER_9_1022 vccd vssd sg13cmos5l_decap_8
XFILLER_22_2403 vccd vssd sg13cmos5l_decap_8
XFILLER_6_2622 vccd vssd sg13cmos5l_decap_8
XFILLER_44_1448 vccd vssd sg13cmos5l_decap_8
Xoutbuffers\[57\] control[57] _1725_/Q vccd vssd sg13cmos5l_buf_8
XFILLER_26_2583 vccd vssd sg13cmos5l_decap_8
XFILLER_6_1932 vccd vssd sg13cmos5l_decap_8
X_1307_ _1307_/Y status[81] _1359_/A2 vccd vssd sg13cmos5l_nor2b_1
XFILLER_29_329 vccd vssd sg13cmos5l_decap_8
XFILLER_6_2699 vccd vssd sg13cmos5l_decap_8
XFILLER_9_1099 vccd vssd sg13cmos5l_decap_8
XFILLER_38_863 vccd vssd sg13cmos5l_decap_8
X_1238_ _1238_/X _0854_/Y _1152_/B _1544_/B vccd vssd sg13cmos5l_a21o_1
XFILLER_22_1746 vccd vssd sg13cmos5l_decap_8
XFILLER_0_2254 vccd vssd sg13cmos5l_decap_8
XFILLER_44_28 vccd vssd sg13cmos5l_decap_8
X_1169_ _1169_/Y _1167_/Y _1166_/Y _1168_/Y vccd vssd sg13cmos5l_o21ai_1
XFILLER_25_546 vccd vssd sg13cmos5l_decap_8
XFILLER_0_1575 vccd vssd sg13cmos5l_decap_8
XFILLER_21_763 vccd vssd sg13cmos5l_decap_8
XFILLER_33_2587 vccd vssd sg13cmos5l_decap_8
XFILLER_33_1842 vccd vssd sg13cmos5l_decap_8
XFILLER_20_273 vccd vssd sg13cmos5l_decap_8
XFILLER_4_406 vccd vssd sg13cmos5l_decap_8
XFILLER_14_1274 vccd vssd sg13cmos5l_decap_8
XFILLER_10_1127 vccd vssd sg13cmos5l_decap_8
XFILLER_27_2325 vccd vssd sg13cmos5l_decap_8
XFILLER_7_2408 vccd vssd sg13cmos5l_decap_8
XFILLER_27_1657 vccd vssd sg13cmos5l_decap_8
XFILLER_0_623 vccd vssd sg13cmos5l_decap_8
XFILLER_25_2060 vccd vssd sg13cmos5l_decap_8
XFILLER_5_2121 vccd vssd sg13cmos5l_decap_8
XFILLER_7_1729 vccd vssd sg13cmos5l_decap_8
XFILLER_40_2547 vccd vssd sg13cmos5l_decap_8
XFILLER_40_1813 vccd vssd sg13cmos5l_decap_8
XFILLER_5_1442 vccd vssd sg13cmos5l_decap_8
XFILLER_44_800 vccd vssd sg13cmos5l_decap_8
XFILLER_5_2198 vccd vssd sg13cmos5l_decap_8
XFILLER_38_2410 vccd vssd sg13cmos5l_decap_4
XFILLER_21_1267 vccd vssd sg13cmos5l_decap_8
XFILLER_18_84 vccd vssd sg13cmos5l_decap_8
XFILLER_43_321 vccd vssd sg13cmos5l_decap_8
XFILLER_16_546 vccd vssd sg13cmos5l_decap_8
XFILLER_44_877 vccd vssd sg13cmos5l_decap_4
XFILLER_38_2476 vccd vssd sg13cmos5l_decap_8
XFILLER_38_1775 vccd vssd sg13cmos5l_decap_8
XFILLER_34_2329 vccd vssd sg13cmos5l_decap_8
XFILLER_19_1141 vccd vssd sg13cmos5l_decap_8
Xtiedowns\[93\] status[93] vccd vssd sg13cmos5l_antennanp
XFILLER_32_2042 vccd vssd sg13cmos5l_decap_8
XFILLER_12_763 vccd vssd sg13cmos5l_decap_8
XFILLER_32_2064 vccd vssd sg13cmos5l_decap_8
XFILLER_8_756 vccd vssd sg13cmos5l_decap_8
XFILLER_11_273 vccd vssd sg13cmos5l_decap_8
XFILLER_12_1904 vccd vssd sg13cmos5l_decap_8
XFILLER_12_2638 vccd vssd sg13cmos5l_decap_8
XFILLER_7_266 vccd vssd sg13cmos5l_decap_8
XFILLER_32_1385 vccd vssd sg13cmos5l_decap_4
XFILLER_10_2373 vccd vssd sg13cmos5l_decap_8
XFILLER_45_2436 vccd vssd sg13cmos5l_decap_8
XFILLER_4_973 vccd vssd sg13cmos5l_decap_8
XFILLER_10_1694 vccd vssd sg13cmos5l_decap_8
XFILLER_3_483 vccd vssd sg13cmos5l_decap_8
XFILLER_45_1757 vccd vssd sg13cmos5l_decap_8
XFILLER_39_638 vccd vssd sg13cmos5l_decap_8
XFILLER_38_126 vccd vssd sg13cmos5l_decap_8
XFILLER_26_1167 vccd vssd sg13cmos5l_decap_8
XFILLER_23_2767 vccd vssd sg13cmos5l_decap_8
XFILLER_6_1239 vccd vssd sg13cmos5l_decap_8
XFILLER_1_2541 vccd vssd sg13cmos5l_decap_8
XFILLER_35_822 vccd vssd sg13cmos5l_decap_4
X_1023_ _1192_/B _1036_/A _1064_/A vccd vssd sg13cmos5l_nand2_1
XFILLER_34_343 vccd vssd sg13cmos5l_decap_8
XFILLER_1_1862 vccd vssd sg13cmos5l_decap_8
XFILLER_37_1230 vccd vssd sg13cmos5l_decap_8
XFILLER_34_398 vccd vssd sg13cmos5l_decap_8
XFILLER_15_1561 vccd vssd sg13cmos5l_decap_8
XFILLER_11_1414 vccd vssd sg13cmos5l_decap_8
X_1787_ _1787_/Q _1795_/CLK _1787_/D fanout114/X vccd vssd sg13cmos5l_dfrbpq_1
Xfanout5 _1555_/S _1549_/S vccd vssd sg13cmos5l_buf_1
XFILLER_28_2623 vccd vssd sg13cmos5l_decap_8
XFILLER_39_28 vccd vssd sg13cmos5l_decap_8
XFILLER_44_1245 vccd vssd sg13cmos5l_decap_8
XFILLER_28_1966 vccd vssd sg13cmos5l_decap_8
XFILLER_26_2380 vccd vssd sg13cmos5l_decap_8
XFILLER_24_1819 vccd vssd sg13cmos5l_decap_8
XFILLER_29_126 vccd vssd sg13cmos5l_decap_8
XFILLER_6_2485 vccd vssd sg13cmos5l_decap_8
XFILLER_22_2277 vccd vssd sg13cmos5l_decap_8
XFILLER_2_2338 vccd vssd sg13cmos5l_decap_8
XFILLER_26_833 vccd vssd sg13cmos5l_decap_8
XFILLER_39_2752 vccd vssd sg13cmos5l_decap_8
XFILLER_25_343 vccd vssd sg13cmos5l_decap_8
XFILLER_2_1659 vccd vssd sg13cmos5l_decap_8
XFILLER_0_2051 vccd vssd sg13cmos5l_decap_8
XFILLER_41_803 vccd vssd sg13cmos5l_decap_8
XFILLER_35_2616 vccd vssd sg13cmos5l_decap_8
XFILLER_0_1372 vccd vssd sg13cmos5l_decap_8
XFILLER_35_1915 vccd vssd sg13cmos5l_decap_8
XFILLER_40_357 vccd vssd sg13cmos5l_decap_8
XFILLER_21_560 vccd vssd sg13cmos5l_decap_8
XFILLER_16_1358 vccd vssd sg13cmos5l_decap_8
XFILLER_4_203 vccd vssd sg13cmos5l_decap_8
XFILLER_14_1071 vccd vssd sg13cmos5l_decap_8
XFILLER_29_1719 vccd vssd sg13cmos5l_decap_8
XFILLER_27_2122 vccd vssd sg13cmos5l_decap_4
XFILLER_20_63 vccd vssd sg13cmos5l_decap_8
XFILLER_1_910 vccd vssd sg13cmos5l_decap_8
XFILLER_7_2205 vccd vssd sg13cmos5l_decap_8
XFILLER_11_1981 vccd vssd sg13cmos5l_decap_8
XFILLER_42_2609 vccd vssd sg13cmos5l_decap_8
XFILLER_27_1410 vccd vssd sg13cmos5l_decap_8
XFILLER_0_420 vccd vssd sg13cmos5l_decap_8
XFILLER_1_987 vccd vssd sg13cmos5l_decap_8
XFILLER_7_1526 vccd vssd sg13cmos5l_decap_8
XFILLER_27_1476 vccd vssd sg13cmos5l_decap_8
XFILLER_23_1307 vccd vssd sg13cmos5l_decap_8
XFILLER_0_497 vccd vssd sg13cmos5l_decap_8
XFILLER_40_2366 vccd vssd sg13cmos5l_decap_8
XFILLER_40_1676 vccd vssd sg13cmos5l_decap_8
XFILLER_29_660 vccd vssd sg13cmos5l_decap_8
XFILLER_21_1064 vccd vssd sg13cmos5l_decap_8
XFILLER_17_833 vccd vssd sg13cmos5l_decap_8
XFILLER_44_663 vccd vssd sg13cmos5l_decap_8
XFILLER_38_2262 vccd vssd sg13cmos5l_decap_8
XFILLER_32_825 vccd vssd sg13cmos5l_decap_8
XFILLER_16_343 vccd vssd sg13cmos5l_decap_8
XFILLER_1_1169 vccd vssd sg13cmos5l_decap_8
XFILLER_38_2295 vccd vssd sg13cmos5l_decap_4
XFILLER_34_2104 vccd vssd sg13cmos5l_decap_8
XFILLER_31_357 vccd vssd sg13cmos5l_decap_8
XFILLER_12_560 vccd vssd sg13cmos5l_decap_8
XFILLER_34_1469 vccd vssd sg13cmos5l_decap_4
X_1710_ _1710_/Q _1711_/CLK _1710_/D fanout127/X vccd vssd sg13cmos5l_dfrbpq_1
XFILLER_8_553 vccd vssd sg13cmos5l_decap_8
XFILLER_12_1701 vccd vssd sg13cmos5l_decap_8
XFILLER_32_1171 vccd vssd sg13cmos5l_decap_8
XANTENNA_3 RSTB vccd vssd sg13cmos5l_antennanp
XFILLER_6_21 vccd vssd sg13cmos5l_decap_8
X_1641_ _1641_/Y _1641_/A _1643_/B_N vccd vssd sg13cmos5l_nor2b_1
XFILLER_10_2170 vccd vssd sg13cmos5l_decap_8
XFILLER_12_1778 vccd vssd sg13cmos5l_decap_8
X_1572_ _1572_/X _1560_/A hold445/X _1577_/S vccd vssd sg13cmos5l_mux2_1
XFILLER_4_770 vccd vssd sg13cmos5l_decap_8
XFILLER_6_98 vccd vssd sg13cmos5l_decap_8
XFILLER_45_2233 vccd vssd sg13cmos5l_decap_8
XFILLER_3_280 vccd vssd sg13cmos5l_decap_8
XFILLER_10_1491 vccd vssd sg13cmos5l_decap_8
XFILLER_45_1554 vccd vssd sg13cmos5l_decap_8
XFILLER_7_2750 vccd vssd sg13cmos5l_decap_8
XFILLER_3_2625 vccd vssd sg13cmos5l_decap_8
XFILLER_6_1036 vccd vssd sg13cmos5l_decap_8
XFILLER_7_2783 vccd vssd sg13cmos5l_decap_8
XFILLER_23_2564 vccd vssd sg13cmos5l_decap_8
XFILLER_3_1946 vccd vssd sg13cmos5l_decap_8
X_1006_ _1048_/A _1070_/B _1046_/B vccd vssd sg13cmos5l_nor2_1
XFILLER_35_663 vccd vssd sg13cmos5l_decap_8
XFILLER_34_140 vccd vssd sg13cmos5l_decap_8
XFILLER_17_2313 vccd vssd sg13cmos5l_decap_8
XFILLER_23_847 vccd vssd sg13cmos5l_decap_8
XFILLER_22_357 vccd vssd sg13cmos5l_decap_8
XFILLER_17_2357 vccd vssd sg13cmos5l_decap_8
XFILLER_17_1645 vccd vssd sg13cmos5l_decap_8
XFILLER_34_2693 vccd vssd sg13cmos5l_decap_8
XFILLER_30_2568 vccd vssd sg13cmos5l_decap_8
XFILLER_11_1211 vccd vssd sg13cmos5l_decap_8
Xhold520 hold520/X _1651_/Q vccd vssd sg13cmos5l_dlygate4sd3_1
Xhold531 hold531/X _1661_/Q vccd vssd sg13cmos5l_dlygate4sd3_1
XFILLER_2_707 vccd vssd sg13cmos5l_decap_8
XFILLER_11_1288 vccd vssd sg13cmos5l_decap_8
XFILLER_28_2464 vccd vssd sg13cmos5l_decap_8
XFILLER_1_217 vccd vssd sg13cmos5l_decap_8
Xclkbuf_3_1_0_SCK clkbuf_5_7_0_SCK/A clkbuf_0_SCK/X vccd vssd sg13cmos5l_buf_8
XFILLER_28_1763 vccd vssd sg13cmos5l_decap_8
XFILLER_8_1813 vccd vssd sg13cmos5l_decap_8
XFILLER_8_2569 vccd vssd sg13cmos5l_decap_8
XFILLER_44_1042 vccd vssd sg13cmos5l_decap_8
XFILLER_41_2642 vccd vssd sg13cmos5l_decap_8
XFILLER_22_2041 vccd vssd sg13cmos5l_decap_8
XFILLER_2_2135 vccd vssd sg13cmos5l_decap_8
XFILLER_6_2282 vccd vssd sg13cmos5l_decap_8
XFILLER_45_427 vccd vssd sg13cmos5l_decap_8
XFILLER_22_2074 vccd vssd sg13cmos5l_decap_8
XFILLER_41_1985 vccd vssd sg13cmos5l_decap_8
XFILLER_2_1456 vccd vssd sg13cmos5l_decap_8
XFILLER_41_600 vccd vssd sg13cmos5l_decap_8
XFILLER_25_140 vccd vssd sg13cmos5l_decap_8
XFILLER_26_685 vccd vssd sg13cmos5l_decap_8
XFILLER_14_847 vccd vssd sg13cmos5l_decap_8
XFILLER_41_677 vccd vssd sg13cmos5l_decap_8
XFILLER_35_2457 vccd vssd sg13cmos5l_decap_8
XFILLER_35_1734 vccd vssd sg13cmos5l_decap_8
XFILLER_13_357 vccd vssd sg13cmos5l_decap_8
XFILLER_15_63 vccd vssd sg13cmos5l_decap_8
XFILLER_40_154 vccd vssd sg13cmos5l_decap_8
XFILLER_35_1756 vccd vssd sg13cmos5l_decap_4
XFILLER_16_1155 vccd vssd sg13cmos5l_decap_8
XFILLER_12_1008 vccd vssd sg13cmos5l_decap_8
XFILLER_31_84 vccd vssd sg13cmos5l_decap_8
XFILLER_5_567 vccd vssd sg13cmos5l_decap_8
Xtiedowns\[56\] status[56] vccd vssd sg13cmos5l_antennanp
XFILLER_7_2002 vccd vssd sg13cmos5l_decap_8
XFILLER_42_1727 vccd vssd sg13cmos5l_decap_8
XFILLER_27_1262 vccd vssd sg13cmos5l_decap_8
XFILLER_1_784 vccd vssd sg13cmos5l_decap_8
XFILLER_7_1323 vccd vssd sg13cmos5l_decap_8
XFILLER_7_2079 vccd vssd sg13cmos5l_decap_8
XFILLER_40_2130 vccd vssd sg13cmos5l_decap_8
XFILLER_23_1148 vccd vssd sg13cmos5l_decap_8
XFILLER_0_294 vccd vssd sg13cmos5l_decap_8
XFILLER_36_427 vccd vssd sg13cmos5l_decap_8
XFILLER_20_2737 vccd vssd sg13cmos5l_decap_8
XFILLER_40_1473 vccd vssd sg13cmos5l_decap_8
XFILLER_17_630 vccd vssd sg13cmos5l_decap_8
XFILLER_18_2611 vccd vssd sg13cmos5l_decap_8
XFILLER_16_140 vccd vssd sg13cmos5l_decap_8
XFILLER_45_994 vccd vssd sg13cmos5l_decap_8
XFILLER_44_482 vccd vssd sg13cmos5l_decap_8
XFILLER_18_2666 vccd vssd sg13cmos5l_decap_8
XFILLER_14_2519 vccd vssd sg13cmos5l_decap_8
XFILLER_31_154 vccd vssd sg13cmos5l_decap_8
XFILLER_9_840 vccd vssd sg13cmos5l_decap_8
XFILLER_12_2243 vccd vssd sg13cmos5l_decap_8
XFILLER_8_350 vccd vssd sg13cmos5l_decap_8
XFILLER_12_1575 vccd vssd sg13cmos5l_decap_8
XFILLER_45_2030 vccd vssd sg13cmos5l_decap_8
X_1555_ _1555_/X _1472_/A hold348/X _1555_/S vccd vssd sg13cmos5l_mux2_1
XFILLER_29_2762 vccd vssd sg13cmos5l_decap_8
XFILLER_28_1015 vccd vssd sg13cmos5l_decap_8
XFILLER_25_2637 vccd vssd sg13cmos5l_decap_8
XFILLER_45_1351 vccd vssd sg13cmos5l_decap_8
XFILLER_39_210 vccd vssd sg13cmos5l_decap_8
X_1486_ _1497_/S _1588_/A _1486_/B vccd vssd sg13cmos5l_nand2_1
XFILLER_3_2422 vccd vssd sg13cmos5l_decap_8
XFILLER_41_1248 vccd vssd sg13cmos5l_decap_8
XFILLER_28_928 vccd vssd sg13cmos5l_decap_8
XFILLER_7_1890 vccd vssd sg13cmos5l_decap_8
XFILLER_39_287 vccd vssd sg13cmos5l_decap_8
XFILLER_27_427 vccd vssd sg13cmos5l_decap_8
XFILLER_23_1671 vccd vssd sg13cmos5l_decap_8
XFILLER_3_1743 vccd vssd sg13cmos5l_decap_8
XFILLER_3_2499 vccd vssd sg13cmos5l_decap_8
XFILLER_36_2700 vccd vssd sg13cmos5l_decap_8
XFILLER_35_493 vccd vssd sg13cmos5l_decap_8
XFILLER_35_471 vccd vssd sg13cmos5l_decap_4
XFILLER_19_1729 vccd vssd sg13cmos5l_decap_8
XFILLER_36_2777 vccd vssd sg13cmos5l_decap_8
XFILLER_23_644 vccd vssd sg13cmos5l_decap_8
XFILLER_22_154 vccd vssd sg13cmos5l_decap_8
XFILLER_17_1442 vccd vssd sg13cmos5l_decap_8
XFILLER_30_2321 vccd vssd sg13cmos5l_decap_8
XFILLER_30_2376 vccd vssd sg13cmos5l_decap_8
XFILLER_30_1631 vccd vssd sg13cmos5l_decap_8
XFILLER_2_504 vccd vssd sg13cmos5l_decap_8
Xhold361 _1735_/D _1515_/X vccd vssd sg13cmos5l_dlygate4sd3_1
Xhold350 hold350/X _1706_/Q vccd vssd sg13cmos5l_dlygate4sd3_1
XFILLER_11_1085 vccd vssd sg13cmos5l_decap_8
Xhold372 _1725_/D _1501_/X vccd vssd sg13cmos5l_dlygate4sd3_1
Xhold394 hold394/X _1709_/Q vccd vssd sg13cmos5l_dlygate4sd3_1
Xhold383 hold383/X _0933_/Y vccd vssd sg13cmos5l_dlygate4sd3_1
XFILLER_8_1610 vccd vssd sg13cmos5l_decap_8
XFILLER_28_2294 vccd vssd sg13cmos5l_decap_8
XFILLER_4_2219 vccd vssd sg13cmos5l_decap_8
XFILLER_8_2366 vccd vssd sg13cmos5l_decap_8
XFILLER_41_2450 vccd vssd sg13cmos5l_decap_8
XFILLER_24_2169 vccd vssd sg13cmos5l_decap_8
XFILLER_8_1687 vccd vssd sg13cmos5l_decap_8
XFILLER_24_1479 vccd vssd sg13cmos5l_decap_8
XFILLER_19_917 vccd vssd sg13cmos5l_decap_8
XFILLER_45_224 vccd vssd sg13cmos5l_decap_8
XFILLER_41_1782 vccd vssd sg13cmos5l_decap_8
XFILLER_18_427 vccd vssd sg13cmos5l_decap_8
XFILLER_2_1253 vccd vssd sg13cmos5l_decap_8
XFILLER_26_84 vccd vssd sg13cmos5l_decap_8
XFILLER_35_2232 vccd vssd sg13cmos5l_decap_8
XFILLER_14_644 vccd vssd sg13cmos5l_decap_8
XFILLER_41_463 vccd vssd sg13cmos5l_decap_8
XFILLER_35_1531 vccd vssd sg13cmos5l_decap_8
XFILLER_31_2107 vccd vssd sg13cmos5l_decap_8
XFILLER_18_1239 vccd vssd sg13cmos5l_decap_8
XFILLER_13_154 vccd vssd sg13cmos5l_decap_8
XFILLER_9_147 vccd vssd sg13cmos5l_decap_8
XFILLER_35_1586 vccd vssd sg13cmos5l_decap_8
XFILLER_31_1428 vccd vssd sg13cmos5l_decap_8
XFILLER_10_861 vccd vssd sg13cmos5l_decap_8
XFILLER_6_854 vccd vssd sg13cmos5l_decap_8
XFILLER_13_1862 vccd vssd sg13cmos5l_decap_8
XFILLER_5_364 vccd vssd sg13cmos5l_decap_8
X_1340_ _1340_/Y _1693_/Q _1453_/B _1439_/B vccd vssd sg13cmos5l_a21oi_1
XFILLER_29_1335 vccd vssd sg13cmos5l_decap_8
XFILLER_9_1407 vccd vssd sg13cmos5l_decap_8
XFILLER_42_2247 vccd vssd sg13cmos5l_decap_8
XFILLER_7_1120 vccd vssd sg13cmos5l_decap_8
X_1271_ _1271_/Y status[42] _1361_/B _1142_/B vccd vssd sg13cmos5l_a21oi_1
XFILLER_3_77 vccd vssd sg13cmos5l_decap_8
XFILLER_1_581 vccd vssd sg13cmos5l_decap_8
XFILLER_42_1568 vccd vssd sg13cmos5l_decap_8
XFILLER_27_1092 vccd vssd sg13cmos5l_decap_8
XFILLER_24_2692 vccd vssd sg13cmos5l_decap_8
XFILLER_20_2534 vccd vssd sg13cmos5l_decap_8
XFILLER_37_747 vccd vssd sg13cmos5l_decap_8
XFILLER_36_224 vccd vssd sg13cmos5l_decap_8
XFILLER_0_2639 vccd vssd sg13cmos5l_decap_8
XFILLER_7_1197 vccd vssd sg13cmos5l_decap_8
XFILLER_45_791 vccd vssd sg13cmos5l_decap_8
XFILLER_20_1877 vccd vssd sg13cmos5l_decap_8
XFILLER_18_994 vccd vssd sg13cmos5l_decap_8
XFILLER_36_1317 vccd vssd sg13cmos5l_decap_8
XFILLER_32_441 vccd vssd sg13cmos5l_decap_8
XFILLER_18_2441 vccd vssd sg13cmos5l_decap_8
XFILLER_33_975 vccd vssd sg13cmos5l_decap_8
XFILLER_20_658 vccd vssd sg13cmos5l_decap_8
XFILLER_34_1074 vccd vssd sg13cmos5l_decap_4
X_0986_ _1045_/A _0985_/A _1074_/A vccd vssd sg13cmos5l_nand2b_1
XFILLER_12_2051 vccd vssd sg13cmos5l_decap_8
XFILLER_14_1659 vccd vssd sg13cmos5l_decap_8
XFILLER_31_2696 vccd vssd sg13cmos5l_decap_8
Xoutbuffers\[87\] control[87] _1755_/Q vccd vssd sg13cmos5l_buf_8
XFILLER_12_1372 vccd vssd sg13cmos5l_decap_8
X_1607_ _1607_/Y _1617_/A _1617_/B_N vccd vssd sg13cmos5l_nor2b_1
Xfanout104 _1445_/A hold524/X vccd vssd sg13cmos5l_buf_1
XFILLER_9_2631 vccd vssd sg13cmos5l_decap_8
X_1538_ _1751_/D hold229/X _1542_/B _1537_/Y vccd vssd sg13cmos5l_a21oi_1
Xfanout115 fanout115/X fanout117/X vccd vssd sg13cmos5l_buf_1
Xfanout137 fanout137/X fanout140/X vccd vssd sg13cmos5l_buf_1
Xfanout126 fanout126/X fanout129/X vccd vssd sg13cmos5l_buf_1
XFILLER_5_2506 vccd vssd sg13cmos5l_decap_8
X_1469_ _1469_/X hold520/X hold340/X _1471_/S vccd vssd sg13cmos5l_mux2_1
XFILLER_25_1722 vccd vssd sg13cmos5l_decap_8
Xfanout148 _1605_/A _1629_/A vccd vssd sg13cmos5l_buf_1
XFILLER_9_1974 vccd vssd sg13cmos5l_decap_8
XFILLER_5_1827 vccd vssd sg13cmos5l_decap_8
XFILLER_41_1078 vccd vssd sg13cmos5l_decap_8
XFILLER_27_224 vccd vssd sg13cmos5l_decap_8
XFILLER_3_1540 vccd vssd sg13cmos5l_decap_8
XFILLER_28_769 vccd vssd sg13cmos5l_decap_8
XFILLER_3_2296 vccd vssd sg13cmos5l_decap_8
XFILLER_42_205 vccd vssd sg13cmos5l_decap_8
XFILLER_36_780 vccd vssd sg13cmos5l_decap_8
XFILLER_24_931 vccd vssd sg13cmos5l_decap_8
XFILLER_19_2227 vccd vssd sg13cmos5l_decap_8
XFILLER_23_441 vccd vssd sg13cmos5l_decap_8
XFILLER_19_1526 vccd vssd sg13cmos5l_decap_8
XFILLER_36_2574 vccd vssd sg13cmos5l_decap_8
XFILLER_32_2416 vccd vssd sg13cmos5l_decap_8
XFILLER_36_1862 vccd vssd sg13cmos5l_decap_8
XFILLER_11_658 vccd vssd sg13cmos5l_decap_8
XFILLER_32_1748 vccd vssd sg13cmos5l_decap_8
XFILLER_10_168 vccd vssd sg13cmos5l_decap_8
XFILLER_12_42 vccd vssd sg13cmos5l_decap_8
XFILLER_30_2184 vccd vssd sg13cmos5l_decap_8
XFILLER_13_1169 vccd vssd sg13cmos5l_decap_8
XFILLER_2_301 vccd vssd sg13cmos5l_decap_8
Xhold180 _0828_/A hold531/X vccd vssd sg13cmos5l_dlygate4sd3_1
XFILLER_3_868 vccd vssd sg13cmos5l_decap_8
XFILLER_43_2534 vccd vssd sg13cmos5l_decap_8
XFILLER_28_2080 vccd vssd sg13cmos5l_decap_8
Xhold191 _0827_/A hold535/X vccd vssd sg13cmos5l_dlygate4sd3_1
XFILLER_2_378 vccd vssd sg13cmos5l_decap_8
XFILLER_8_2163 vccd vssd sg13cmos5l_decap_8
XFILLER_4_2016 vccd vssd sg13cmos5l_decap_8
XFILLER_24_1243 vccd vssd sg13cmos5l_decap_8
XFILLER_19_714 vccd vssd sg13cmos5l_decap_8
XFILLER_8_1484 vccd vssd sg13cmos5l_decap_8
Xtiedowns\[19\] status[19] vccd vssd sg13cmos5l_antennanp
XFILLER_18_224 vccd vssd sg13cmos5l_decap_8
XFILLER_4_1337 vccd vssd sg13cmos5l_decap_8
XFILLER_2_1050 vccd vssd sg13cmos5l_decap_8
XFILLER_37_2338 vccd vssd sg13cmos5l_decap_8
XFILLER_37_2316 vccd vssd sg13cmos5l_decap_4
XFILLER_15_931 vccd vssd sg13cmos5l_decap_8
XFILLER_33_238 vccd vssd sg13cmos5l_decap_8
XFILLER_14_441 vccd vssd sg13cmos5l_decap_8
XFILLER_37_1659 vccd vssd sg13cmos5l_decap_8
XFILLER_19_2783 vccd vssd sg13cmos5l_decap_8
XFILLER_18_1036 vccd vssd sg13cmos5l_decap_8
XFILLER_35_2095 vccd vssd sg13cmos5l_decap_8
XFILLER_30_956 vccd vssd sg13cmos5l_decap_8
XFILLER_35_1361 vccd vssd sg13cmos5l_decap_4
X_0840_ _0840_/Y _0840_/A vccd vssd sg13cmos5l_inv_1
XFILLER_15_1946 vccd vssd sg13cmos5l_decap_8
XFILLER_31_1236 vccd vssd sg13cmos5l_decap_8
XFILLER_6_651 vccd vssd sg13cmos5l_decap_8
XFILLER_5_161 vccd vssd sg13cmos5l_decap_8
XFILLER_9_1204 vccd vssd sg13cmos5l_decap_8
XFILLER_42_2022 vccd vssd sg13cmos5l_decap_4
XFILLER_26_2754 vccd vssd sg13cmos5l_decap_8
X_1323_ _1323_/Y _1321_/Y _1320_/Y _1322_/Y vccd vssd sg13cmos5l_o21ai_1
X_1254_ _1254_/Y mask_rev_in[11] _1064_/Y _1348_/B vccd vssd sg13cmos5l_o21ai_1
XFILLER_20_2353 vccd vssd sg13cmos5l_decap_4
XFILLER_4_2583 vccd vssd sg13cmos5l_decap_8
X_1185_ _1185_/Y status[36] _1363_/A2 _1184_/Y _1183_/Y _1144_/B vccd vssd sg13cmos5l_a221oi_1
XFILLER_25_717 vccd vssd sg13cmos5l_decap_8
XFILLER_0_2436 vccd vssd sg13cmos5l_decap_8
XFILLER_24_238 vccd vssd sg13cmos5l_decap_8
XFILLER_20_1696 vccd vssd sg13cmos5l_decap_8
XFILLER_18_791 vccd vssd sg13cmos5l_decap_8
XFILLER_0_1757 vccd vssd sg13cmos5l_decap_8
XFILLER_33_750 vccd vssd sg13cmos5l_decap_8
XFILLER_18_2271 vccd vssd sg13cmos5l_decap_8
XFILLER_21_945 vccd vssd sg13cmos5l_decap_8
XFILLER_14_2135 vccd vssd sg13cmos5l_decap_8
XFILLER_33_2769 vccd vssd sg13cmos5l_decap_8
XFILLER_20_455 vccd vssd sg13cmos5l_decap_8
XFILLER_31_2460 vccd vssd sg13cmos5l_decap_8
X_0969_ _1077_/A _1046_/A _1074_/B vccd vssd sg13cmos5l_nand2b_2
XFILLER_14_1456 vccd vssd sg13cmos5l_decap_8
XFILLER_10_1309 vccd vssd sg13cmos5l_decap_8
XFILLER_0_805 vccd vssd sg13cmos5l_decap_8
XFILLER_25_2220 vccd vssd sg13cmos5l_decap_8
XFILLER_5_2303 vccd vssd sg13cmos5l_decap_8
XFILLER_9_2450 vccd vssd sg13cmos5l_decap_8
XFILLER_40_2729 vccd vssd sg13cmos5l_decap_8
XFILLER_25_1552 vccd vssd sg13cmos5l_decap_8
XFILLER_5_1624 vccd vssd sg13cmos5l_decap_8
XFILLER_9_1771 vccd vssd sg13cmos5l_decap_8
XFILLER_25_1596 vccd vssd sg13cmos5l_decap_8
XFILLER_21_1438 vccd vssd sg13cmos5l_decap_8
XFILLER_3_2093 vccd vssd sg13cmos5l_decap_8
XFILLER_28_577 vccd vssd sg13cmos5l_decap_8
XFILLER_16_728 vccd vssd sg13cmos5l_decap_8
XFILLER_38_2658 vccd vssd sg13cmos5l_decap_8
XFILLER_15_238 vccd vssd sg13cmos5l_decap_8
XFILLER_38_1968 vccd vssd sg13cmos5l_decap_4
XFILLER_19_2079 vccd vssd sg13cmos5l_decap_8
XFILLER_19_1323 vccd vssd sg13cmos5l_decap_8
XFILLER_12_945 vccd vssd sg13cmos5l_decap_8
XFILLER_32_2268 vccd vssd sg13cmos5l_decap_8
XFILLER_32_1512 vccd vssd sg13cmos5l_decap_8
XFILLER_23_63 vccd vssd sg13cmos5l_decap_8
XFILLER_8_938 vccd vssd sg13cmos5l_decap_8
XFILLER_11_455 vccd vssd sg13cmos5l_decap_8
XFILLER_7_448 vccd vssd sg13cmos5l_decap_8
XFILLER_45_2618 vccd vssd sg13cmos5l_decap_8
XFILLER_26_2017 vccd vssd sg13cmos5l_decap_8
XFILLER_3_0 vccd vssd sg13cmos5l_decap_8
XFILLER_10_1876 vccd vssd sg13cmos5l_decap_8
XFILLER_3_665 vccd vssd sg13cmos5l_decap_8
XFILLER_45_1939 vccd vssd sg13cmos5l_decap_8
XFILLER_43_2331 vccd vssd sg13cmos5l_decap_8
XFILLER_26_1349 vccd vssd sg13cmos5l_decap_8
XFILLER_2_175 vccd vssd sg13cmos5l_decap_8
XFILLER_43_2397 vccd vssd sg13cmos5l_decap_8
XFILLER_38_308 vccd vssd sg13cmos5l_decap_8
XFILLER_19_511 vccd vssd sg13cmos5l_decap_8
XFILLER_1_2723 vccd vssd sg13cmos5l_decap_8
XFILLER_4_1134 vccd vssd sg13cmos5l_decap_8
XFILLER_8_1281 vccd vssd sg13cmos5l_decap_8
XFILLER_24_1095 vccd vssd sg13cmos5l_decap_8
XFILLER_19_588 vccd vssd sg13cmos5l_decap_8
XFILLER_0_56 vccd vssd sg13cmos5l_decap_8
XFILLER_21_1994 vccd vssd sg13cmos5l_decap_8
XFILLER_9_21 vccd vssd sg13cmos5l_decap_8
XFILLER_37_1478 vccd vssd sg13cmos5l_decap_8
XFILLER_19_2580 vccd vssd sg13cmos5l_decap_8
XFILLER_15_2444 vccd vssd sg13cmos5l_decap_8
XFILLER_30_764 vccd vssd sg13cmos5l_decap_8
X_0823_ _0823_/Y SDI vccd vssd sg13cmos5l_inv_1
XFILLER_15_1743 vccd vssd sg13cmos5l_decap_8
XFILLER_9_98 vccd vssd sg13cmos5l_decap_8
XFILLER_11_2319 vccd vssd sg13cmos5l_decap_8
XFILLER_31_1044 vccd vssd sg13cmos5l_decap_8
XFILLER_44_2117 vccd vssd sg13cmos5l_decap_8
XFILLER_6_2601 vccd vssd sg13cmos5l_decap_8
XFILLER_9_1001 vccd vssd sg13cmos5l_decap_8
XFILLER_44_1427 vccd vssd sg13cmos5l_decap_8
XFILLER_36_0 vccd vssd sg13cmos5l_decap_8
XFILLER_26_2562 vccd vssd sg13cmos5l_decap_8
XFILLER_29_308 vccd vssd sg13cmos5l_decap_8
XFILLER_6_1911 vccd vssd sg13cmos5l_decap_8
XFILLER_6_2678 vccd vssd sg13cmos5l_decap_8
X_1306_ _1306_/Y mask_rev_in[9] _1306_/B vccd vssd sg13cmos5l_nand2b_1
XFILLER_9_1078 vccd vssd sg13cmos5l_decap_8
XFILLER_42_1162 vccd vssd sg13cmos5l_decap_8
XFILLER_26_1883 vccd vssd sg13cmos5l_decap_8
XFILLER_22_2459 vccd vssd sg13cmos5l_decap_8
XFILLER_22_1725 vccd vssd sg13cmos5l_decap_8
X_1237_ _1237_/Y _1775_/Q _1568_/B _1235_/Y _1236_/Y _1152_/B vccd vssd sg13cmos5l_a221oi_1
XFILLER_38_842 vccd vssd sg13cmos5l_decap_8
XFILLER_0_2233 vccd vssd sg13cmos5l_decap_8
XFILLER_4_2380 vccd vssd sg13cmos5l_decap_8
XFILLER_6_1988 vccd vssd sg13cmos5l_decap_8
XFILLER_38_897 vccd vssd sg13cmos5l_decap_8
XFILLER_37_385 vccd vssd sg13cmos5l_decap_8
XFILLER_25_525 vccd vssd sg13cmos5l_decap_8
X_1168_ _1168_/Y mask_rev_in[5] _1210_/B _1306_/B vccd vssd sg13cmos5l_a21oi_1
XFILLER_20_1493 vccd vssd sg13cmos5l_decap_8
XFILLER_0_1554 vccd vssd sg13cmos5l_decap_8
X_1099_ _1099_/Y status[22] _1232_/B _1147_/B status[14] _1148_/B vccd vssd sg13cmos5l_a221oi_1
XFILLER_40_539 vccd vssd sg13cmos5l_decap_8
XFILLER_33_591 vccd vssd sg13cmos5l_decap_8
XFILLER_33_2566 vccd vssd sg13cmos5l_decap_8
XFILLER_33_1821 vccd vssd sg13cmos5l_decap_8
XFILLER_21_742 vccd vssd sg13cmos5l_decap_8
XFILLER_20_252 vccd vssd sg13cmos5l_decap_8
XFILLER_10_1106 vccd vssd sg13cmos5l_decap_8
XFILLER_14_1253 vccd vssd sg13cmos5l_decap_8
XFILLER_27_2304 vccd vssd sg13cmos5l_decap_8
XFILLER_0_602 vccd vssd sg13cmos5l_decap_8
XFILLER_27_1636 vccd vssd sg13cmos5l_decap_8
XFILLER_5_2100 vccd vssd sg13cmos5l_decap_8
XFILLER_7_1708 vccd vssd sg13cmos5l_decap_8
XFILLER_44_2695 vccd vssd sg13cmos5l_decap_8
XFILLER_40_2526 vccd vssd sg13cmos5l_decap_8
XFILLER_0_679 vccd vssd sg13cmos5l_decap_8
XFILLER_5_1421 vccd vssd sg13cmos5l_decap_8
XFILLER_5_2177 vccd vssd sg13cmos5l_decap_8
XFILLER_29_842 vccd vssd sg13cmos5l_decap_8
XFILLER_40_1869 vccd vssd sg13cmos5l_decap_8
XFILLER_29_897 vccd vssd sg13cmos5l_decap_8
XFILLER_18_63 vccd vssd sg13cmos5l_decap_8
XFILLER_16_525 vccd vssd sg13cmos5l_decap_8
XFILLER_5_1498 vccd vssd sg13cmos5l_decap_8
XFILLER_44_856 vccd vssd sg13cmos5l_decap_8
XFILLER_28_385 vccd vssd sg13cmos5l_decap_8
XFILLER_43_377 vccd vssd sg13cmos5l_decap_8
XFILLER_34_2308 vccd vssd sg13cmos5l_decap_8
XFILLER_19_1120 vccd vssd sg13cmos5l_decap_8
XFILLER_43_388 vccd vssd sg13cmos5l_decap_8
XFILLER_38_1754 vccd vssd sg13cmos5l_decap_8
XFILLER_16_2720 vccd vssd sg13cmos5l_decap_8
XFILLER_34_1618 vccd vssd sg13cmos5l_decap_8
XFILLER_34_84 vccd vssd sg13cmos5l_decap_8
XFILLER_19_1197 vccd vssd sg13cmos5l_decap_8
XFILLER_12_742 vccd vssd sg13cmos5l_decap_8
XFILLER_12_2617 vccd vssd sg13cmos5l_decap_8
Xtiedowns\[86\] status[86] vccd vssd sg13cmos5l_antennanp
XFILLER_8_735 vccd vssd sg13cmos5l_decap_8
XFILLER_11_252 vccd vssd sg13cmos5l_decap_8
XFILLER_32_1364 vccd vssd sg13cmos5l_decap_8
XFILLER_7_245 vccd vssd sg13cmos5l_decap_8
XFILLER_10_2352 vccd vssd sg13cmos5l_decap_8
XFILLER_45_2415 vccd vssd sg13cmos5l_decap_8
XFILLER_4_952 vccd vssd sg13cmos5l_decap_8
XFILLER_3_462 vccd vssd sg13cmos5l_decap_8
XFILLER_10_1673 vccd vssd sg13cmos5l_decap_8
XFILLER_45_1736 vccd vssd sg13cmos5l_decap_8
XFILLER_39_606 vccd vssd sg13cmos5l_decap_8
XFILLER_26_1146 vccd vssd sg13cmos5l_decap_8
XFILLER_23_2746 vccd vssd sg13cmos5l_decap_8
XFILLER_6_1218 vccd vssd sg13cmos5l_decap_8
XFILLER_38_105 vccd vssd sg13cmos5l_decap_8
XFILLER_1_2520 vccd vssd sg13cmos5l_decap_8
X_1022_ _1568_/B _1036_/A _1064_/A vccd vssd sg13cmos5l_and2_1
XFILLER_39_1507 vccd vssd sg13cmos5l_decap_8
XFILLER_34_322 vccd vssd sg13cmos5l_decap_8
XFILLER_19_385 vccd vssd sg13cmos5l_decap_8
XFILLER_1_2597 vccd vssd sg13cmos5l_decap_8
XFILLER_1_1841 vccd vssd sg13cmos5l_decap_8
XFILLER_17_2506 vccd vssd sg13cmos5l_decap_8
XFILLER_22_539 vccd vssd sg13cmos5l_decap_8
XFILLER_30_550 vccd vssd sg13cmos5l_decap_8
XFILLER_37_1297 vccd vssd sg13cmos5l_decap_8
XFILLER_15_1540 vccd vssd sg13cmos5l_decap_8
XFILLER_30_594 vccd vssd sg13cmos5l_decap_8
XFILLER_11_2149 vccd vssd sg13cmos5l_decap_8
X_1786_ _1786_/Q clkload7/A _1786_/D fanout114/X vccd vssd sg13cmos5l_dfrbpq_1
XFILLER_28_2602 vccd vssd sg13cmos5l_decap_8
Xfanout6 _1541_/S _1531_/Y vccd vssd sg13cmos5l_buf_1
XFILLER_28_2679 vccd vssd sg13cmos5l_decap_8
XFILLER_28_1945 vccd vssd sg13cmos5l_decap_8
XFILLER_44_1224 vccd vssd sg13cmos5l_decap_8
XFILLER_29_105 vccd vssd sg13cmos5l_decap_8
XFILLER_2_2317 vccd vssd sg13cmos5l_decap_8
XFILLER_6_2464 vccd vssd sg13cmos5l_decap_8
XFILLER_45_609 vccd vssd sg13cmos5l_decap_8
XFILLER_22_2256 vccd vssd sg13cmos5l_decap_8
XFILLER_44_119 vccd vssd sg13cmos5l_decap_8
XFILLER_38_672 vccd vssd sg13cmos5l_decap_4
XFILLER_26_812 vccd vssd sg13cmos5l_decap_8
XFILLER_2_1638 vccd vssd sg13cmos5l_decap_8
XFILLER_0_2030 vccd vssd sg13cmos5l_decap_8
XFILLER_6_1785 vccd vssd sg13cmos5l_decap_8
XFILLER_39_2731 vccd vssd sg13cmos5l_decap_8
XFILLER_37_182 vccd vssd sg13cmos5l_decap_8
XFILLER_25_322 vccd vssd sg13cmos5l_decap_8
XFILLER_22_1599 vccd vssd sg13cmos5l_decap_8
XFILLER_26_889 vccd vssd sg13cmos5l_decap_8
XFILLER_0_1351 vccd vssd sg13cmos5l_decap_8
XFILLER_41_859 vccd vssd sg13cmos5l_decap_8
XFILLER_25_399 vccd vssd sg13cmos5l_decap_8
XFILLER_13_539 vccd vssd sg13cmos5l_decap_8
XFILLER_40_336 vccd vssd sg13cmos5l_decap_8
XFILLER_33_2330 vccd vssd sg13cmos5l_decap_8
XFILLER_16_2049 vccd vssd sg13cmos5l_decap_8
XFILLER_16_1337 vccd vssd sg13cmos5l_decap_8
XFILLER_14_1050 vccd vssd sg13cmos5l_decap_8
XFILLER_33_1684 vccd vssd sg13cmos5l_decap_8
XFILLER_20_42 vccd vssd sg13cmos5l_decap_8
XFILLER_5_749 vccd vssd sg13cmos5l_decap_8
XFILLER_11_1960 vccd vssd sg13cmos5l_decap_8
XFILLER_11_2683 vccd vssd sg13cmos5l_decap_8
XFILLER_27_2101 vccd vssd sg13cmos5l_decap_8
XFILLER_4_259 vccd vssd sg13cmos5l_decap_8
XFILLER_27_1455 vccd vssd sg13cmos5l_decap_8
XFILLER_1_966 vccd vssd sg13cmos5l_decap_8
XFILLER_7_1505 vccd vssd sg13cmos5l_decap_8
XFILLER_44_2492 vccd vssd sg13cmos5l_decap_8
XFILLER_40_2345 vccd vssd sg13cmos5l_decap_8
XFILLER_0_476 vccd vssd sg13cmos5l_decap_8
XFILLER_29_84 vccd vssd sg13cmos5l_decap_8
XFILLER_35_119 vccd vssd sg13cmos5l_decap_8
XFILLER_21_1043 vccd vssd sg13cmos5l_decap_8
XFILLER_17_812 vccd vssd sg13cmos5l_decap_8
XFILLER_44_620 vccd vssd sg13cmos5l_decap_8
XFILLER_28_182 vccd vssd sg13cmos5l_decap_8
XFILLER_16_322 vccd vssd sg13cmos5l_decap_8
XFILLER_1_1148 vccd vssd sg13cmos5l_decap_8
XFILLER_5_1295 vccd vssd sg13cmos5l_decap_8
XFILLER_32_804 vccd vssd sg13cmos5l_decap_8
XFILLER_17_889 vccd vssd sg13cmos5l_decap_8
XFILLER_16_399 vccd vssd sg13cmos5l_decap_8
XFILLER_38_1573 vccd vssd sg13cmos5l_decap_8
XFILLER_34_2149 vccd vssd sg13cmos5l_decap_8
XFILLER_31_336 vccd vssd sg13cmos5l_decap_8
XFILLER_34_1448 vccd vssd sg13cmos5l_decap_8
XFILLER_40_892 vccd vssd sg13cmos5l_decap_8
XFILLER_8_532 vccd vssd sg13cmos5l_decap_8
XFILLER_12_1757 vccd vssd sg13cmos5l_decap_8
X_1640_ _1640_/Y _1644_/A _1644_/B_N vccd vssd sg13cmos5l_nor2b_1
XANTENNA_4 RSTB vccd vssd sg13cmos5l_antennanp
X_1571_ _1571_/X _1591_/A0 hold502/X _1577_/S vccd vssd sg13cmos5l_mux2_1
XFILLER_45_2212 vccd vssd sg13cmos5l_decap_8
XFILLER_6_77 vccd vssd sg13cmos5l_decap_8
XFILLER_10_1470 vccd vssd sg13cmos5l_decap_8
XFILLER_28_1219 vccd vssd sg13cmos5l_decap_8
XFILLER_45_2289 vccd vssd sg13cmos5l_decap_8
XFILLER_45_1533 vccd vssd sg13cmos5l_decap_8
XFILLER_41_1419 vccd vssd sg13cmos5l_decap_8
XFILLER_23_2543 vccd vssd sg13cmos5l_decap_8
XFILLER_3_2604 vccd vssd sg13cmos5l_decap_8
XFILLER_6_1015 vccd vssd sg13cmos5l_decap_8
XFILLER_7_2762 vccd vssd sg13cmos5l_decap_8
XFILLER_39_2005 vccd vssd sg13cmos5l_decap_8
XFILLER_26_119 vccd vssd sg13cmos5l_decap_8
XFILLER_3_1925 vccd vssd sg13cmos5l_decap_8
XFILLER_35_620 vccd vssd sg13cmos5l_decap_8
XFILLER_23_1897 vccd vssd sg13cmos5l_decap_8
XFILLER_19_182 vccd vssd sg13cmos5l_decap_8
X_1005_ _1005_/Y status[39] _1142_/B vccd vssd sg13cmos5l_nor2b_1
XFILLER_1_2394 vccd vssd sg13cmos5l_decap_8
XFILLER_23_826 vccd vssd sg13cmos5l_decap_8
XFILLER_34_196 vccd vssd sg13cmos5l_decap_8
XFILLER_22_336 vccd vssd sg13cmos5l_decap_8
XFILLER_17_1624 vccd vssd sg13cmos5l_decap_8
XFILLER_34_2672 vccd vssd sg13cmos5l_decap_8
XFILLER_30_2547 vccd vssd sg13cmos5l_decap_8
XFILLER_15_2093 vccd vssd sg13cmos5l_decap_8
XFILLER_34_1993 vccd vssd sg13cmos5l_decap_8
XFILLER_30_1824 vccd vssd sg13cmos5l_decap_8
Xhold510 _1599_/A reset vccd vssd sg13cmos5l_dlygate4sd3_1
X_1769_ _1769_/Q _1790_/CLK _1769_/D fanout116/X vccd vssd sg13cmos5l_dfrbpq_1
XFILLER_28_2410 vccd vssd sg13cmos5l_decap_8
Xhold521 _1652_/D _1397_/X vccd vssd sg13cmos5l_dlygate4sd3_1
XFILLER_11_1267 vccd vssd sg13cmos5l_decap_8
Xhold532 hold532/X _1657_/Q vccd vssd sg13cmos5l_dlygate4sd3_1
XFILLER_28_2443 vccd vssd sg13cmos5l_decap_8
XFILLER_44_1021 vccd vssd sg13cmos5l_decap_8
XFILLER_28_1742 vccd vssd sg13cmos5l_decap_8
XFILLER_8_2548 vccd vssd sg13cmos5l_decap_8
XFILLER_41_2621 vccd vssd sg13cmos5l_decap_8
XFILLER_6_2261 vccd vssd sg13cmos5l_decap_8
XFILLER_8_1869 vccd vssd sg13cmos5l_decap_8
XFILLER_44_1098 vccd vssd sg13cmos5l_decap_8
XFILLER_22_2053 vccd vssd sg13cmos5l_decap_8
XFILLER_18_609 vccd vssd sg13cmos5l_decap_8
XFILLER_2_2114 vccd vssd sg13cmos5l_decap_8
XFILLER_45_406 vccd vssd sg13cmos5l_decap_8
XFILLER_41_2698 vccd vssd sg13cmos5l_decap_8
XFILLER_41_1964 vccd vssd sg13cmos5l_decap_8
XFILLER_39_970 vccd vssd sg13cmos5l_decap_4
XFILLER_6_1582 vccd vssd sg13cmos5l_decap_8
XFILLER_17_119 vccd vssd sg13cmos5l_decap_8
XFILLER_2_1435 vccd vssd sg13cmos5l_decap_8
XFILLER_26_664 vccd vssd sg13cmos5l_decap_8
XFILLER_39_1860 vccd vssd sg13cmos5l_decap_8
XFILLER_14_826 vccd vssd sg13cmos5l_decap_8
XFILLER_41_656 vccd vssd sg13cmos5l_decap_8
XFILLER_40_133 vccd vssd sg13cmos5l_decap_8
XFILLER_35_1713 vccd vssd sg13cmos5l_decap_8
XFILLER_25_196 vccd vssd sg13cmos5l_decap_8
XFILLER_13_336 vccd vssd sg13cmos5l_decap_8
XFILLER_15_42 vccd vssd sg13cmos5l_decap_8
XFILLER_16_1134 vccd vssd sg13cmos5l_decap_8
XFILLER_9_329 vccd vssd sg13cmos5l_decap_8
XFILLER_35_1779 vccd vssd sg13cmos5l_decap_8
XFILLER_33_1481 vccd vssd sg13cmos5l_decap_8
XFILLER_31_63 vccd vssd sg13cmos5l_decap_8
XFILLER_5_546 vccd vssd sg13cmos5l_decap_8
XFILLER_29_1506 vccd vssd sg13cmos5l_decap_4
Xtiedowns\[49\] status[49] vccd vssd sg13cmos5l_antennanp
XFILLER_1_763 vccd vssd sg13cmos5l_decap_8
XFILLER_7_1302 vccd vssd sg13cmos5l_decap_8
XFILLER_42_1706 vccd vssd sg13cmos5l_decap_8
XFILLER_27_1241 vccd vssd sg13cmos5l_decap_8
XFILLER_23_1105 vccd vssd sg13cmos5l_decap_8
XFILLER_0_273 vccd vssd sg13cmos5l_decap_8
XFILLER_7_2058 vccd vssd sg13cmos5l_decap_8
XFILLER_20_2716 vccd vssd sg13cmos5l_decap_8
XFILLER_7_1379 vccd vssd sg13cmos5l_decap_8
XFILLER_40_2186 vccd vssd sg13cmos5l_decap_4
XFILLER_40_1430 vccd vssd sg13cmos5l_decap_8
XFILLER_37_929 vccd vssd sg13cmos5l_decap_8
XFILLER_29_480 vccd vssd sg13cmos5l_decap_8
XFILLER_2_2681 vccd vssd sg13cmos5l_decap_8
XFILLER_5_1092 vccd vssd sg13cmos5l_decap_8
XFILLER_45_973 vccd vssd sg13cmos5l_decap_8
XFILLER_44_461 vccd vssd sg13cmos5l_decap_8
XFILLER_18_2645 vccd vssd sg13cmos5l_decap_8
XFILLER_17_686 vccd vssd sg13cmos5l_decap_8
XFILLER_31_133 vccd vssd sg13cmos5l_decap_8
XFILLER_18_1911 vccd vssd sg13cmos5l_decap_4
XFILLER_16_196 vccd vssd sg13cmos5l_decap_8
XFILLER_18_1999 vccd vssd sg13cmos5l_decap_8
XFILLER_12_2222 vccd vssd sg13cmos5l_decap_8
XFILLER_34_1289 vccd vssd sg13cmos5l_decap_8
XFILLER_9_896 vccd vssd sg13cmos5l_decap_8
XFILLER_12_1554 vccd vssd sg13cmos5l_decap_8
XFILLER_29_2741 vccd vssd sg13cmos5l_decap_8
X_1554_ _1554_/Y hold278/X _1555_/S _1553_/Y vccd vssd sg13cmos5l_a21oi_1
XFILLER_45_1330 vccd vssd sg13cmos5l_decap_8
X_1485_ _1485_/X hold526/X hold352/X _1485_/S vccd vssd sg13cmos5l_mux2_1
XFILLER_28_1038 vccd vssd sg13cmos5l_decap_8
XFILLER_25_2616 vccd vssd sg13cmos5l_decap_8
XFILLER_45_2086 vccd vssd sg13cmos5l_decap_8
XFILLER_25_1926 vccd vssd sg13cmos5l_decap_4
.ends

.subckt openframe_user_project sub resetb_in flash_csb_ena flash_csb_out flash_clk_ena
+ flash_clk_out flash_io0_ena flash_io0_out flash_io1_ena flash_io1_out gpio0_ena
+ gpio0_out gpio1_ena gpio1_out spi_SDO_ena spi_SDO_out spi_SDI_in spi_SDI_ena spi_SDI_out
+ spi_CSB_in spi_CSB_ena spi_CSB_out spi_SCK_in spi_SCK_ena spi_SCK_out UART_Rx_ena
+ UART_Rx_out UART_Tx_ena UART_Tx_out flash_io2_ena flash_io2_out flash_io3_ena flash_io3_out
+ vbg ref_in idac2_sink idac1_sink voltgen_vout1 voltgen_vout2 idac1_source idac2_source
+ test_source_ibias flash_csb_zero flash_clk_zero flash_io0_zero flash_io1_zero gpio0_zero
+ gpio1_zero spi_SDO_zero spi_SDO_one spi_SDI_zero spi_CSB_zero spi_SCK_zero UART_Rx_zero
+ UART_Tx_zero flash_io2_zero flash_io3_zero flash_io3_one mask_rev[0] mask_rev[1]
+ mask_rev[2] mask_rev[3] mask_rev[4] mask_rev[5] mask_rev[6] mask_rev[7] mask_rev[8]
+ mask_rev[9] mask_rev[10] mask_rev[11] mask_rev[12] mask_rev[13] mask_rev[14] mask_rev[15]
+ mask_rev[16] mask_rev[17] mask_rev[18] mask_rev[19] mask_rev[20] mask_rev[21] mask_rev[22]
+ mask_rev[23] mask_rev[24] mask_rev[25] mask_rev[26] mask_rev[27] mask_rev[28] mask_rev[29]
+ mask_rev[30] mask_rev[31] test_source vddio vccd vssd
Xsg13cmos5l_ocd_ip__bandgap_0 vdda12 sg13cmos5l_ocd_ip__bandgap_0/ibias1_250n housekeeping_top_0/control[29]
+ housekeeping_top_0/control[30] housekeeping_top_0/control[31] housekeeping_top_0/control[32]
+ housekeeping_top_0/control[33] housekeeping_top_0/control[34] housekeeping_top_0/control[35]
+ housekeeping_top_0/control[36] housekeeping_top_0/control[37] housekeeping_top_0/control[38]
+ housekeeping_top_0/control[39] housekeeping_top_0/control[40] housekeeping_top_0/control[41]
+ housekeeping_top_0/control[42] housekeeping_top_0/control[43] housekeeping_top_0/control[44]
+ housekeeping_top_0/control[28] vccd idac1_sink sub vbg vssd sg13cmos5l_ocd_ip__bandgap
Xsg13cmos5l_ocd_ip__voltgen_2 vccd vbg sg13cmos5l_ocd_ip__voltgen_2/ibias1u_1 voltgen_vout2
+ sg13cmos5l_ocd_ip__voltgen_2/ibias1u_2 voltgen_vout1 housekeeping_top_0/control[126]
+ housekeeping_top_0/control[125] sg13cmos5l_ocd_ip__voltgen_2/ibias1u_3 housekeeping_top_0/control[127]
+ housekeeping_top_0/control[116] vdda5 housekeeping_top_0/control[123] sub housekeeping_top_0/control[122]
+ vssd housekeeping_top_0/control[124] sg13cmos5l_ocd_ip__voltgen
Xpower_stage_0[0] vddio vdda1 vccd power_stage_0[0]/enable sub vssd power_stage
Xpower_stage_0[1] vddio vdda2 vccd power_stage_0[1]/enable sub vssd power_stage
Xpower_stage_0[2] vddio vdda3 vccd power_stage_0[2]/enable sub vssd power_stage
Xpower_stage_0[3] vddio vdda4 vccd power_stage_0[3]/enable sub vssd power_stage
Xpower_stage_0[4] vddio vdda5 vccd power_stage_0[4]/enable sub vssd power_stage
Xpower_stage_0[5] vddio vdda6 vccd power_stage_0[5]/enable sub vssd power_stage
Xpower_stage_0[6] vddio vdda7 vccd power_stage_0[6]/enable sub vssd power_stage
Xpower_stage_0[7] vddio vdda8 vccd power_stage_0[7]/enable sub vssd power_stage
Xpower_stage_1[0] vddio vdda16 vccd power_stage_1[0]/enable sub vssd power_stage
Xpower_stage_1[1] vddio vdda15 vccd power_stage_1[1]/enable sub vssd power_stage
Xpower_stage_1[2] vddio vdda14 vccd power_stage_1[2]/enable sub vssd power_stage
Xpower_stage_1[3] vddio vdda13 vccd power_stage_1[3]/enable sub vssd power_stage
Xpower_stage_1[4] vddio vdda12 vccd power_stage_1[4]/enable sub vssd power_stage
Xpower_stage_1[5] vddio vdda11 vccd power_stage_1[5]/enable sub vssd power_stage
Xpower_stage_1[6] vddio vdda10 vccd power_stage_1[6]/enable sub vssd power_stage
Xpower_stage_1[7] vddio vdda9 vccd power_stage_1[7]/enable sub vssd power_stage
Xsg13cmos5l_ocd_ip__biasgen1_0 housekeeping_top_0/control[88] ref_in housekeeping_top_0/control[87]
+ test_source housekeeping_top_0/control[71] housekeeping_top_0/control[72] housekeeping_top_0/control[73]
+ housekeeping_top_0/control[82] housekeeping_top_0/control[83] housekeeping_top_0/control[107]
+ housekeeping_top_0/control[106] housekeeping_top_0/control[105] housekeeping_top_0/control[104]
+ housekeeping_top_0/control[103] housekeeping_top_0/control[58] housekeeping_top_0/control[59]
+ housekeeping_top_0/control[60] housekeeping_top_0/control[61] housekeeping_top_0/control[62]
+ sg13cmos5l_ocd_ip__bandgap_0/ibias1_250n housekeeping_top_0/control[45] housekeeping_top_0/control[46]
+ housekeeping_top_0/control[47] housekeeping_top_0/control[48] housekeeping_top_0/control[49]
+ housekeeping_top_0/control[121] housekeeping_top_0/control[120] housekeeping_top_0/control[119]
+ housekeeping_top_0/control[118] housekeeping_top_0/control[117] sg13cmos5l_ocd_ip__voltgen_2/ibias1u_1
+ housekeeping_top_0/control[94] housekeeping_top_0/control[93] housekeeping_top_0/control[92]
+ housekeeping_top_0/control[91] housekeeping_top_0/control[90] test_source_ibias
+ housekeeping_top_0/control[63] housekeeping_top_0/control[64] housekeeping_top_0/control[65]
+ housekeeping_top_0/control[66] housekeeping_top_0/control[67] housekeeping_top_0/control[68]
+ housekeeping_top_0/control[69] housekeeping_top_0/control[70] sg13cmos5l_ocd_ip__voltgen_2/ibias1u_2
+ sg13cmos5l_ocd_ip__voltgen_2/ibias1u_3 idac1_source idac2_source housekeeping_top_0/control[102]
+ housekeeping_top_0/control[101] housekeeping_top_0/control[100] housekeeping_top_0/control[99]
+ housekeeping_top_0/control[98] housekeeping_top_0/control[97] housekeeping_top_0/control[96]
+ housekeeping_top_0/control[95] housekeeping_top_0/control[50] housekeeping_top_0/control[51]
+ housekeeping_top_0/control[52] housekeeping_top_0/control[53] housekeeping_top_0/control[54]
+ housekeeping_top_0/control[55] housekeeping_top_0/control[56] housekeeping_top_0/control[57]
+ housekeeping_top_0/control[115] housekeeping_top_0/control[114] housekeeping_top_0/control[113]
+ housekeeping_top_0/control[112] housekeeping_top_0/control[111] housekeeping_top_0/control[110]
+ housekeeping_top_0/control[109] housekeeping_top_0/control[108] idac1_sink idac2_sink
+ housekeeping_top_0/control[86] housekeeping_top_0/control[85] vbg vccd vddio sub
+ vssd sg13cmos5l_ocd_ip__biasgen1
Xhousekeeping_top_0 spi_CSB_in resetb_in spi_SCK_in spi_SDI_in spi_SDO_out housekeeping_top_0/control[0]
+ housekeeping_top_0/control[100] housekeeping_top_0/control[101] housekeeping_top_0/control[102]
+ housekeeping_top_0/control[103] housekeeping_top_0/control[104] housekeeping_top_0/control[105]
+ housekeeping_top_0/control[106] housekeeping_top_0/control[107] housekeeping_top_0/control[108]
+ housekeeping_top_0/control[109] housekeeping_top_0/control[10] housekeeping_top_0/control[110]
+ housekeeping_top_0/control[111] housekeeping_top_0/control[112] housekeeping_top_0/control[113]
+ housekeeping_top_0/control[114] housekeeping_top_0/control[115] housekeeping_top_0/control[116]
+ housekeeping_top_0/control[117] housekeeping_top_0/control[118] housekeeping_top_0/control[119]
+ housekeeping_top_0/control[11] housekeeping_top_0/control[120] housekeeping_top_0/control[121]
+ housekeeping_top_0/control[122] housekeeping_top_0/control[123] housekeeping_top_0/control[124]
+ housekeeping_top_0/control[125] housekeeping_top_0/control[126] housekeeping_top_0/control[127]
+ housekeeping_top_0/control[12] housekeeping_top_0/control[13] housekeeping_top_0/control[14]
+ housekeeping_top_0/control[15] housekeeping_top_0/control[16] housekeeping_top_0/control[17]
+ housekeeping_top_0/control[18] housekeeping_top_0/control[19] housekeeping_top_0/control[1]
+ power_stage_1[7]/enable power_stage_1[6]/enable power_stage_1[5]/enable power_stage_1[4]/enable
+ power_stage_1[3]/enable power_stage_1[2]/enable power_stage_1[1]/enable power_stage_1[0]/enable
+ housekeeping_top_0/control[28] housekeeping_top_0/control[29] housekeeping_top_0/control[2]
+ housekeeping_top_0/control[30] housekeeping_top_0/control[31] housekeeping_top_0/control[32]
+ housekeeping_top_0/control[33] housekeeping_top_0/control[34] housekeeping_top_0/control[35]
+ housekeeping_top_0/control[36] housekeeping_top_0/control[37] housekeeping_top_0/control[38]
+ housekeeping_top_0/control[39] housekeeping_top_0/control[3] housekeeping_top_0/control[40]
+ housekeeping_top_0/control[41] housekeeping_top_0/control[42] housekeeping_top_0/control[43]
+ housekeeping_top_0/control[44] housekeeping_top_0/control[45] housekeeping_top_0/control[46]
+ housekeeping_top_0/control[47] housekeeping_top_0/control[48] housekeeping_top_0/control[49]
+ housekeeping_top_0/control[4] housekeeping_top_0/control[50] housekeeping_top_0/control[51]
+ housekeeping_top_0/control[52] housekeeping_top_0/control[53] housekeeping_top_0/control[54]
+ housekeeping_top_0/control[55] housekeeping_top_0/control[56] housekeeping_top_0/control[57]
+ housekeeping_top_0/control[58] housekeeping_top_0/control[59] housekeeping_top_0/control[5]
+ housekeeping_top_0/control[60] housekeeping_top_0/control[61] housekeeping_top_0/control[62]
+ housekeeping_top_0/control[63] housekeeping_top_0/control[64] housekeeping_top_0/control[65]
+ housekeeping_top_0/control[66] housekeeping_top_0/control[67] housekeeping_top_0/control[68]
+ housekeeping_top_0/control[69] housekeeping_top_0/control[6] housekeeping_top_0/control[70]
+ housekeeping_top_0/control[71] housekeeping_top_0/control[72] housekeeping_top_0/control[73]
+ power_stage_0[0]/enable power_stage_0[1]/enable power_stage_0[2]/enable power_stage_0[3]/enable
+ power_stage_0[4]/enable power_stage_0[5]/enable housekeeping_top_0/control[7] power_stage_0[6]/enable
+ power_stage_0[7]/enable housekeeping_top_0/control[82] housekeeping_top_0/control[83]
+ housekeeping_top_0/control[84] housekeeping_top_0/control[85] housekeeping_top_0/control[86]
+ housekeeping_top_0/control[87] housekeeping_top_0/control[88] housekeeping_top_0/control[89]
+ housekeeping_top_0/control[8] housekeeping_top_0/control[90] housekeeping_top_0/control[91]
+ housekeeping_top_0/control[92] housekeeping_top_0/control[93] housekeeping_top_0/control[94]
+ housekeeping_top_0/control[95] housekeeping_top_0/control[96] housekeeping_top_0/control[97]
+ housekeeping_top_0/control[98] housekeeping_top_0/control[99] housekeeping_top_0/control[9]
+ mask_rev[0] mask_rev[10] mask_rev[11] mask_rev[12] mask_rev[13] mask_rev[14] mask_rev[15]
+ mask_rev[16] mask_rev[17] mask_rev[18] mask_rev[19] mask_rev[1] mask_rev[20] mask_rev[21]
+ mask_rev[22] mask_rev[23] mask_rev[24] mask_rev[25] mask_rev[26] mask_rev[27] mask_rev[28]
+ mask_rev[29] mask_rev[2] mask_rev[30] mask_rev[31] mask_rev[3] mask_rev[4] mask_rev[5]
+ mask_rev[6] mask_rev[7] mask_rev[8] mask_rev[9] housekeeping_top_0/reset spi_SDO_ena
+ spi_SDO_one flash_io3_zero flash_io3_zero flash_io3_zero flash_io3_zero flash_io3_zero
+ flash_io3_zero flash_io3_zero flash_io3_zero flash_io3_zero flash_io3_zero spi_SDO_one
+ flash_io3_zero flash_io3_zero flash_io3_zero flash_io3_zero flash_io3_zero flash_io3_zero
+ flash_io3_zero flash_io3_zero flash_io3_zero flash_io3_zero spi_SDO_one flash_io3_zero
+ flash_io3_zero flash_io3_zero flash_io3_zero flash_io3_zero flash_io3_zero flash_io3_zero
+ flash_io3_zero spi_SDO_one spi_SDO_one spi_SDO_one spi_SDO_one spi_SDO_one spi_SDO_one
+ spi_SDO_one spi_SDO_one spi_SDO_one spi_SDO_one spi_SDO_one spi_SDO_one spi_SDO_one
+ spi_SDO_one spi_SDO_one spi_SDO_one spi_SDO_one spi_SDO_one spi_SDO_one spi_SDO_one
+ spi_SDO_one spi_SDO_one spi_SDO_zero spi_SDO_zero spi_SDO_zero spi_SDO_zero spi_SDO_zero
+ spi_SDO_zero spi_SDO_zero spi_SDO_zero spi_SDO_one spi_SDO_zero spi_SDO_zero spi_SDO_zero
+ spi_SDO_zero spi_SDO_zero spi_SDO_zero spi_SDO_zero spi_SDO_zero spi_SDO_zero spi_SDO_zero
+ spi_SDO_one spi_SDO_zero spi_SDO_zero spi_SDO_zero spi_SDO_zero spi_SDO_zero spi_SDO_zero
+ spi_SDO_zero spi_SDO_zero spi_SDO_zero spi_SDO_zero spi_SDO_one spi_SDO_zero spi_SDO_zero
+ spi_SDO_zero spi_SDO_zero flash_io3_one flash_io3_one flash_io3_one flash_io3_one
+ flash_io3_one flash_io3_one spi_SDO_one flash_io3_one flash_io3_one flash_io3_one
+ flash_io3_one flash_io3_one flash_io3_one flash_io3_one flash_io3_one flash_io3_one
+ flash_io3_one spi_SDO_one flash_io3_one flash_io3_one flash_io3_one flash_io3_one
+ flash_io3_one flash_io3_one flash_io3_one flash_io3_one flash_io3_one flash_io3_one
+ spi_SDO_one flash_io3_one flash_io3_one flash_io3_one flash_io3_one flash_io3_one
+ flash_io3_one flash_io3_zero flash_io3_zero flash_io3_zero flash_io3_zero spi_SDO_one
+ vccd vssd housekeeping_top
R0 spi_CSB_zero spi_CSB_ena 0.029333
R1 flash_io2_ena flash_io2_zero 0.029333
R2 flash_io1_zero flash_io1_out 0.017959
R3 gpio1_zero gpio1_ena 0.029333
R4 gpio1_zero gpio1_out 0.029333
R5 spi_CSB_zero spi_CSB_out 0.029333
R6 spi_SDI_zero spi_SDI_ena 0.029333
R7 UART_Rx_zero UART_Rx_ena 0.029333
R8 spi_SDI_zero spi_SDI_out 0.029333
R9 UART_Rx_zero UART_Rx_out 0.029333
R10 flash_csb_zero flash_csb_out 0.017959
R11 gpio0_zero gpio0_out 0.017959
R12 flash_io1_zero flash_io1_ena 0.017959
R13 flash_io0_zero flash_io0_out 0.017959
R14 spi_SCK_zero spi_SCK_ena 0.029333
R15 flash_clk_zero flash_clk_ena 0.017959
R16 spi_SCK_zero spi_SCK_out 0.029333
R17 UART_Tx_zero UART_Tx_out 0.029333
R18 flash_io3_out flash_io3_zero 0.029333
R19 flash_io2_out flash_io2_zero 0.029333
R20 flash_csb_zero flash_csb_ena 0.017959
R21 flash_clk_zero flash_clk_out 0.017959
R22 gpio0_zero gpio0_ena 0.017959
R23 flash_io0_zero flash_io0_ena 0.017959
R24 UART_Tx_zero UART_Tx_ena 0.029333
R25 flash_io3_ena flash_io3_zero 0.029333
.ends

.subckt openframe_project_wrapper vssio resetb_in clock_in flash_csb_in flash_csb_ena
+ flash_csb_out flash_clk_in flash_clk_ena flash_clk_out flash_io0_in flash_io0_ena
+ flash_io0_out flash_io1_in flash_io1_ena flash_io1_out gpio0_in gpio0_ena gpio0_out
+ gpio1_in gpio1_ena gpio1_out spi_SDO_in spi_SDO_ena spi_SDO_out spi_SDI_in spi_SDI_ena
+ spi_SDI_out spi_CSB_in spi_CSB_ena spi_CSB_out spi_SCK_in spi_SCK_ena spi_SCK_out
+ UART_Rx_in UART_Rx_ena UART_Rx_out UART_Tx_in UART_Tx_ena UART_Tx_out option_in
+ flash_io2_in flash_io2_ena flash_io2_out flash_io3_in flash_io3_ena flash_io3_out
+ analog_io_esd[0] analog_io_esd[1] analog_io_esd[2] analog_io_esd[3] analog_io_esd[4]
+ analog_io_esd[5] analog_io_esd[6] analog_io_esd[7] analog_io_esd[8] analog_io_esd[9]
+ analog_io_esd[10] analog_io_esd[11] analog_io_esd[12] analog_io_esd[13] analog_io_esd[14]
+ analog_io_esd[15] analog_io_esd[16] analog_io_esd[17] analog_io_esd[18] analog_io_esd[19]
+ analog_io_esd[20] analog_io_esd[21] analog_io_esd[22] analog_io_esd[23] analog_io_esd[24]
+ analog_io_esd[25] analog_io_esd[26] analog_io_esd[27] analog_io_esd[28] analog_io[0]
+ analog_io[1] analog_io[2] analog_io[3] analog_io[4] analog_io[5] analog_io[6] analog_io[7]
+ analog_io[8] analog_io[9] analog_io[10] analog_io[11] analog_io[12] analog_io[13]
+ analog_io[14] analog_io[15] analog_io[16] analog_io[17] analog_io[18] analog_io[19]
+ analog_io[20] analog_io[21] analog_io[22] analog_io[23] analog_io[24] analog_io[25]
+ analog_io[26] analog_io[27] analog_io[28] flash_csb_zero flash_csb_one flash_clk_zero
+ flash_clk_one flash_io0_zero flash_io0_one flash_io1_zero flash_io1_one gpio0_zero
+ gpio0_one gpio1_zero gpio1_one spi_SDO_zero spi_SDO_one spi_SDI_zero spi_SDI_one
+ spi_CSB_zero spi_CSB_one spi_SCK_zero spi_SCK_one UART_Rx_zero UART_Rx_one UART_Tx_zero
+ UART_Tx_one flash_io2_zero flash_io2_one flash_io3_zero flash_io3_one mask_rev[0]
+ mask_rev[1] mask_rev[2] mask_rev[3] mask_rev[4] mask_rev[5] mask_rev[6] mask_rev[7]
+ mask_rev[8] mask_rev[9] mask_rev[10] mask_rev[11] mask_rev[12] mask_rev[13] mask_rev[14]
+ mask_rev[15] mask_rev[16] mask_rev[17] mask_rev[18] mask_rev[19] mask_rev[20] mask_rev[21]
+ mask_rev[22] mask_rev[23] mask_rev[24] mask_rev[25] mask_rev[26] mask_rev[27] mask_rev[28]
+ mask_rev[29] mask_rev[30] mask_rev[31] vssio_uq0 vssd_uq0 sub vddio vccd vssd
Xopenframe_user_project_0 sub resetb_in flash_csb_ena flash_csb_out flash_clk_ena
+ flash_clk_out flash_io0_ena flash_io0_out flash_io1_ena flash_io1_out gpio0_ena
+ gpio0_out gpio1_ena gpio1_out spi_SDO_ena spi_SDO_out spi_SDI_in spi_SDI_ena spi_SDI_out
+ spi_CSB_in spi_CSB_ena spi_CSB_out spi_SCK_in spi_SCK_ena spi_SCK_out UART_Rx_ena
+ UART_Rx_out UART_Tx_ena UART_Tx_out flash_io2_ena flash_io2_out flash_io3_ena flash_io3_out
+ analog_io[0] analog_io[1] analog_io[18] analog_io[21] analog_io[22] analog_io[23]
+ analog_io[24] analog_io[25] analog_io[27] flash_csb_zero flash_clk_zero flash_io0_zero
+ flash_io1_zero gpio0_zero gpio1_zero spi_SDO_zero spi_SDO_one spi_SDI_zero spi_CSB_zero
+ spi_SCK_zero UART_Rx_zero UART_Tx_zero flash_io2_zero flash_io3_zero flash_io3_one
+ mask_rev[0] mask_rev[1] mask_rev[2] mask_rev[3] mask_rev[4] mask_rev[5] mask_rev[6]
+ mask_rev[7] mask_rev[8] mask_rev[9] mask_rev[10] mask_rev[11] mask_rev[12] mask_rev[13]
+ mask_rev[14] mask_rev[15] mask_rev[16] mask_rev[17] mask_rev[18] mask_rev[19] mask_rev[20]
+ mask_rev[21] mask_rev[22] mask_rev[23] mask_rev[24] mask_rev[25] mask_rev[26] mask_rev[27]
+ mask_rev[28] mask_rev[29] mask_rev[30] mask_rev[31] analog_io[20] vddio vccd vssd
+ openframe_user_project
.ends

.subckt sg13cmos5l_caravel_openframe gpio[38] gpio[39] gpio[43] gpio[2] gpio[8] gpio[10]
+ gpio[12] gpio[13] gpio[14] gpio[15] gpio[16] gpio[18] gpio[19] gpio[22] option gpio[25]
+ gpio[27] gpio[29] gpio[31] gpio[32] gpio[34] gpio[35] gpio[36] vccd gpio[4] gpio[20]
+ gpio[40] gpio[6] gpio[1] gpio[7] gpio[21] gpio[42] gpio[3] gpio[9] gpio[23] gpio[28]
+ gpio[5] gpio[0] gpio[11] vddio gpio[17] gpio[26] gpio[24] gpio[33] gpio[41] gpio[30]
+ resetb gpio[37] vssd
Xsg13cmos5l_padframe_0 gpio[38] gpio[39] gpio[40] gpio[5] gpio[10] gpio[11] gpio[16]
+ gpio[17] gpio[18] gpio[28] gpio[32] gpio[35] gpio[36] gpio[37] sg13cmos5l_padframe_0/resetb_in
+ sg13cmos5l_padframe_0/flash_csb_in sg13cmos5l_padframe_0/flash_csb_ena sg13cmos5l_padframe_0/flash_csb_out
+ sg13cmos5l_padframe_0/flash_clk_out sg13cmos5l_padframe_0/flash_io0_in sg13cmos5l_padframe_0/flash_io1_out
+ sg13cmos5l_padframe_0/gpio1_in sg13cmos5l_padframe_0/gpio1_out sg13cmos5l_padframe_0/spi_SDO_in
+ sg13cmos5l_padframe_0/spi_SDI_in sg13cmos5l_padframe_0/spi_SDI_ena sg13cmos5l_padframe_0/spi_SDI_out
+ sg13cmos5l_padframe_0/spi_CSB_in sg13cmos5l_padframe_0/spi_CSB_ena sg13cmos5l_padframe_0/spi_CSB_out
+ sg13cmos5l_padframe_0/spi_SCK_in sg13cmos5l_padframe_0/UART_Rx_in sg13cmos5l_padframe_0/UART_Rx_ena
+ sg13cmos5l_padframe_0/UART_Rx_out sg13cmos5l_padframe_0/UART_Tx_out sg13cmos5l_padframe_0/option_in
+ sg13cmos5l_padframe_0/flash_io2_in sg13cmos5l_padframe_0/flash_io2_out sg13cmos5l_padframe_0/flash_io3_out
+ sg13cmos5l_padframe_0/analog_io_esd[0] sg13cmos5l_padframe_0/analog_io_esd[1] sg13cmos5l_padframe_0/analog_io_esd[2]
+ sg13cmos5l_padframe_0/analog_io_esd[3] sg13cmos5l_padframe_0/analog_io_esd[4] sg13cmos5l_padframe_0/analog_io_esd[5]
+ sg13cmos5l_padframe_0/analog_io_esd[12] sg13cmos5l_padframe_0/analog_io_esd[13]
+ sg13cmos5l_padframe_0/analog_io_esd[14] sg13cmos5l_padframe_0/analog_io_esd[15]
+ sg13cmos5l_padframe_0/analog_io_esd[17] sg13cmos5l_padframe_0/analog_io_esd[18]
+ sg13cmos5l_padframe_0/analog_io_esd[19] sg13cmos5l_padframe_0/analog_io_esd[21]
+ sg13cmos5l_padframe_0/analog_io_esd[26] sg13cmos5l_padframe_0/analog_io_esd[27]
+ gpio[22] gpio[23] gpio[25] gpio[26] gpio[27] sg13cmos5l_padframe_0/flash_csb_zero
+ sg13cmos5l_padframe_0/flash_csb_one sg13cmos5l_padframe_0/flash_clk_zero sg13cmos5l_padframe_0/flash_clk_one
+ sg13cmos5l_padframe_0/flash_io0_zero sg13cmos5l_padframe_0/flash_io0_one sg13cmos5l_padframe_0/flash_io1_zero
+ sg13cmos5l_padframe_0/flash_io1_one sg13cmos5l_padframe_0/gpio0_zero sg13cmos5l_padframe_0/gpio0_one
+ sg13cmos5l_padframe_0/gpio1_one sg13cmos5l_padframe_0/spi_SDO_one sg13cmos5l_padframe_0/spi_SCK_zero
+ sg13cmos5l_padframe_0/UART_Rx_one sg13cmos5l_padframe_0/UART_Tx_zero sg13cmos5l_padframe_0/flash_io2_zero
+ sg13cmos5l_padframe_0/flash_io2_one sg13cmos5l_padframe_0/flash_io3_zero sg13cmos5l_padframe_0/flash_io3_one
+ sg13cmos5l_padframe_0/mask_rev[7] sg13cmos5l_padframe_0/mask_rev[8] sg13cmos5l_padframe_0/mask_rev[9]
+ sg13cmos5l_padframe_0/mask_rev[10] sg13cmos5l_padframe_0/mask_rev[11] sg13cmos5l_padframe_0/mask_rev[12]
+ sg13cmos5l_padframe_0/mask_rev[13] sg13cmos5l_padframe_0/mask_rev[14] sg13cmos5l_padframe_0/mask_rev[15]
+ sg13cmos5l_padframe_0/mask_rev[16] sg13cmos5l_padframe_0/mask_rev[17] sg13cmos5l_padframe_0/mask_rev[18]
+ sg13cmos5l_padframe_0/mask_rev[19] sg13cmos5l_padframe_0/mask_rev[20] sg13cmos5l_padframe_0/mask_rev[21]
+ sg13cmos5l_padframe_0/mask_rev[22] sg13cmos5l_padframe_0/mask_rev[23] sg13cmos5l_padframe_0/mask_rev[24]
+ sg13cmos5l_padframe_0/mask_rev[25] sg13cmos5l_padframe_0/mask_rev[26] sg13cmos5l_padframe_0/mask_rev[30]
+ sg13cmos5l_padframe_0/mask_rev[31] vddio vccd sg13cmos5l_padframe_0/clock_in gpio[0]
+ sg13cmos5l_padframe_0/analog_io_esd[9] sg13cmos5l_padframe_0/analog_io_esd[20] sg13cmos5l_padframe_0/spi_SDO_zero
+ sg13cmos5l_padframe_0/spi_SCK_ena sg13cmos5l_padframe_0/analog_io_esd[8] gpio[2]
+ sg13cmos5l_padframe_0/spi_SDI_one sg13cmos5l_padframe_0/analog_io_esd[25] sg13cmos5l_padframe_0/spi_SDI_zero
+ sg13cmos5l_padframe_0/spi_CSB_one sg13cmos5l_padframe_0/analog_io_esd[7] sg13cmos5l_padframe_0/flash_io1_in
+ gpio[4] sg13cmos5l_padframe_0/analog_io_esd[24] gpio[20] option gpio[29] sg13cmos5l_padframe_0/spi_CSB_zero
+ gpio[8] sg13cmos5l_padframe_0/analog_io_esd[6] sg13cmos5l_padframe_0/spi_SCK_out
+ gpio[6] sg13cmos5l_padframe_0/analog_io_esd[23] sg13cmos5l_padframe_0/flash_io3_in
+ gpio[1] gpio[41] sg13cmos5l_padframe_0/mask_rev[27] sg13cmos5l_padframe_0/flash_clk_ena
+ sg13cmos5l_padframe_0/UART_Tx_in sg13cmos5l_padframe_0/gpio0_ena resetb gpio[7]
+ sg13cmos5l_padframe_0/mask_rev[28] sg13cmos5l_padframe_0/flash_io0_out gpio[14]
+ sg13cmos5l_padframe_0/spi_SDO_out sg13cmos5l_padframe_0/flash_io3_ena gpio[15] gpio[24]
+ gpio[33] sg13cmos5l_padframe_0/UART_Rx_zero gpio[42] sg13cmos5l_padframe_0/spi_SDO_ena
+ gpio[34] sg13cmos5l_padframe_0/mask_rev[0] sg13cmos5l_padframe_0/analog_io_esd[11]
+ sg13cmos5l_padframe_0/mask_rev[29] gpio[31] sg13cmos5l_padframe_0/gpio0_in sg13cmos5l_padframe_0/mask_rev[1]
+ sg13cmos5l_padframe_0/gpio1_zero sg13cmos5l_padframe_0/analog_io_esd[28] sg13cmos5l_padframe_0/mask_rev[2]
+ sg13cmos5l_padframe_0/gpio0_out gpio[12] gpio[21] gpio[30] sg13cmos5l_padframe_0/analog_io_esd[22]
+ sg13cmos5l_padframe_0/mask_rev[3] sg13cmos5l_padframe_0/flash_clk_in sg13cmos5l_padframe_0/UART_Tx_ena
+ sg13cmos5l_padframe_0/mask_rev[4] sg13cmos5l_padframe_0/flash_io1_ena sg13cmos5l_padframe_0/flash_io0_ena
+ sg13cmos5l_padframe_0/mask_rev[5] gpio[3] gpio[43] gpio[13] sg13cmos5l_padframe_0/UART_Tx_one
+ sg13cmos5l_padframe_0/analog_io_esd[16] sg13cmos5l_padframe_0/spi_SCK_one gpio[9]
+ sg13cmos5l_padframe_0/flash_io2_ena sg13cmos5l_padframe_0/mask_rev[6] gpio[19] sg13cmos5l_padframe_0/gpio1_ena
+ vssd sg13cmos5l_padframe_0/analog_io_esd[10] sg13cmos5l_padframe
Xopenframe_project_wrapper_0 vssd sg13cmos5l_padframe_0/resetb_in sg13cmos5l_padframe_0/clock_in
+ sg13cmos5l_padframe_0/flash_csb_in sg13cmos5l_padframe_0/flash_csb_ena sg13cmos5l_padframe_0/flash_csb_out
+ sg13cmos5l_padframe_0/flash_clk_in sg13cmos5l_padframe_0/flash_clk_ena sg13cmos5l_padframe_0/flash_clk_out
+ sg13cmos5l_padframe_0/flash_io0_in sg13cmos5l_padframe_0/flash_io0_ena sg13cmos5l_padframe_0/flash_io0_out
+ sg13cmos5l_padframe_0/flash_io1_in sg13cmos5l_padframe_0/flash_io1_ena sg13cmos5l_padframe_0/flash_io1_out
+ sg13cmos5l_padframe_0/gpio0_in sg13cmos5l_padframe_0/gpio0_ena sg13cmos5l_padframe_0/gpio0_out
+ sg13cmos5l_padframe_0/gpio1_in sg13cmos5l_padframe_0/gpio1_ena sg13cmos5l_padframe_0/gpio1_out
+ sg13cmos5l_padframe_0/spi_SDO_in sg13cmos5l_padframe_0/spi_SDO_ena sg13cmos5l_padframe_0/spi_SDO_out
+ sg13cmos5l_padframe_0/spi_SDI_in sg13cmos5l_padframe_0/spi_SDI_ena sg13cmos5l_padframe_0/spi_SDI_out
+ sg13cmos5l_padframe_0/spi_CSB_in sg13cmos5l_padframe_0/spi_CSB_ena sg13cmos5l_padframe_0/spi_CSB_out
+ sg13cmos5l_padframe_0/spi_SCK_in sg13cmos5l_padframe_0/spi_SCK_ena sg13cmos5l_padframe_0/spi_SCK_out
+ sg13cmos5l_padframe_0/UART_Rx_in sg13cmos5l_padframe_0/UART_Rx_ena sg13cmos5l_padframe_0/UART_Rx_out
+ sg13cmos5l_padframe_0/UART_Tx_in sg13cmos5l_padframe_0/UART_Tx_ena sg13cmos5l_padframe_0/UART_Tx_out
+ sg13cmos5l_padframe_0/option_in sg13cmos5l_padframe_0/flash_io2_in sg13cmos5l_padframe_0/flash_io2_ena
+ sg13cmos5l_padframe_0/flash_io2_out sg13cmos5l_padframe_0/flash_io3_in sg13cmos5l_padframe_0/flash_io3_ena
+ sg13cmos5l_padframe_0/flash_io3_out sg13cmos5l_padframe_0/analog_io_esd[0] sg13cmos5l_padframe_0/analog_io_esd[1]
+ sg13cmos5l_padframe_0/analog_io_esd[2] sg13cmos5l_padframe_0/analog_io_esd[3] sg13cmos5l_padframe_0/analog_io_esd[4]
+ sg13cmos5l_padframe_0/analog_io_esd[5] sg13cmos5l_padframe_0/analog_io_esd[6] sg13cmos5l_padframe_0/analog_io_esd[7]
+ sg13cmos5l_padframe_0/analog_io_esd[8] sg13cmos5l_padframe_0/analog_io_esd[9] sg13cmos5l_padframe_0/analog_io_esd[10]
+ sg13cmos5l_padframe_0/analog_io_esd[11] sg13cmos5l_padframe_0/analog_io_esd[12]
+ sg13cmos5l_padframe_0/analog_io_esd[13] sg13cmos5l_padframe_0/analog_io_esd[14]
+ sg13cmos5l_padframe_0/analog_io_esd[15] sg13cmos5l_padframe_0/analog_io_esd[16]
+ sg13cmos5l_padframe_0/analog_io_esd[17] sg13cmos5l_padframe_0/analog_io_esd[18]
+ sg13cmos5l_padframe_0/analog_io_esd[19] sg13cmos5l_padframe_0/analog_io_esd[20]
+ sg13cmos5l_padframe_0/analog_io_esd[21] sg13cmos5l_padframe_0/analog_io_esd[22]
+ sg13cmos5l_padframe_0/analog_io_esd[23] sg13cmos5l_padframe_0/analog_io_esd[24]
+ sg13cmos5l_padframe_0/analog_io_esd[25] sg13cmos5l_padframe_0/analog_io_esd[26]
+ sg13cmos5l_padframe_0/analog_io_esd[27] sg13cmos5l_padframe_0/analog_io_esd[28]
+ gpio[7] gpio[8] gpio[9] gpio[10] gpio[11] gpio[12] gpio[13] gpio[14] gpio[15] gpio[16]
+ gpio[17] gpio[18] gpio[19] gpio[20] gpio[21] gpio[22] gpio[23] gpio[24] gpio[25]
+ gpio[26] gpio[27] gpio[28] gpio[29] gpio[30] gpio[31] gpio[32] gpio[33] gpio[34]
+ gpio[35] sg13cmos5l_padframe_0/flash_csb_zero sg13cmos5l_padframe_0/flash_csb_one
+ sg13cmos5l_padframe_0/flash_clk_zero sg13cmos5l_padframe_0/flash_clk_one sg13cmos5l_padframe_0/flash_io0_zero
+ sg13cmos5l_padframe_0/flash_io0_one sg13cmos5l_padframe_0/flash_io1_zero sg13cmos5l_padframe_0/flash_io1_one
+ sg13cmos5l_padframe_0/gpio0_zero sg13cmos5l_padframe_0/gpio0_one sg13cmos5l_padframe_0/gpio1_zero
+ sg13cmos5l_padframe_0/gpio1_one sg13cmos5l_padframe_0/spi_SDO_zero sg13cmos5l_padframe_0/spi_SDO_one
+ sg13cmos5l_padframe_0/spi_SDI_zero sg13cmos5l_padframe_0/spi_SDI_one sg13cmos5l_padframe_0/spi_CSB_zero
+ sg13cmos5l_padframe_0/spi_CSB_one sg13cmos5l_padframe_0/spi_SCK_zero sg13cmos5l_padframe_0/spi_SCK_one
+ sg13cmos5l_padframe_0/UART_Rx_zero sg13cmos5l_padframe_0/UART_Rx_one sg13cmos5l_padframe_0/UART_Tx_zero
+ sg13cmos5l_padframe_0/UART_Tx_one sg13cmos5l_padframe_0/flash_io2_zero sg13cmos5l_padframe_0/flash_io2_one
+ sg13cmos5l_padframe_0/flash_io3_zero sg13cmos5l_padframe_0/flash_io3_one sg13cmos5l_padframe_0/mask_rev[0]
+ sg13cmos5l_padframe_0/mask_rev[1] sg13cmos5l_padframe_0/mask_rev[2] sg13cmos5l_padframe_0/mask_rev[3]
+ sg13cmos5l_padframe_0/mask_rev[4] sg13cmos5l_padframe_0/mask_rev[5] sg13cmos5l_padframe_0/mask_rev[6]
+ sg13cmos5l_padframe_0/mask_rev[7] sg13cmos5l_padframe_0/mask_rev[8] sg13cmos5l_padframe_0/mask_rev[9]
+ sg13cmos5l_padframe_0/mask_rev[10] sg13cmos5l_padframe_0/mask_rev[11] sg13cmos5l_padframe_0/mask_rev[12]
+ sg13cmos5l_padframe_0/mask_rev[13] sg13cmos5l_padframe_0/mask_rev[14] sg13cmos5l_padframe_0/mask_rev[15]
+ sg13cmos5l_padframe_0/mask_rev[16] sg13cmos5l_padframe_0/mask_rev[17] sg13cmos5l_padframe_0/mask_rev[18]
+ sg13cmos5l_padframe_0/mask_rev[19] sg13cmos5l_padframe_0/mask_rev[20] sg13cmos5l_padframe_0/mask_rev[21]
+ sg13cmos5l_padframe_0/mask_rev[22] sg13cmos5l_padframe_0/mask_rev[23] sg13cmos5l_padframe_0/mask_rev[24]
+ sg13cmos5l_padframe_0/mask_rev[25] sg13cmos5l_padframe_0/mask_rev[26] sg13cmos5l_padframe_0/mask_rev[27]
+ sg13cmos5l_padframe_0/mask_rev[28] sg13cmos5l_padframe_0/mask_rev[29] sg13cmos5l_padframe_0/mask_rev[30]
+ sg13cmos5l_padframe_0/mask_rev[31] vssd vssd vssd vddio vccd vssd openframe_project_wrapper
.ends

.subckt sg13cmos5l_caravel_openframe_final resetb gpio[38] vssd gpio[39] gpio[40]
+ gpio[41] gpio[42] gpio[43] gpio[0] gpio[1] gpio[2] gpio[3] gpio[4] gpio[5] gpio[6]
+ gpio[7] gpio[8] gpio[9] gpio[10] gpio[11] gpio[12] gpio[13] gpio[14] gpio[15] gpio[16]
+ gpio[17] gpio[18] gpio[19] gpio[20] gpio[21] gpio[22] gpio[23] option gpio[24] gpio[25]
+ gpio[26] gpio[27] gpio[28] gpio[29] gpio[30] gpio[31] gpio[32] gpio[33] gpio[34]
+ gpio[35] gpio[36] gpio[37] vddio vccd
Xsg13cmos5l_caravel_openframe_0 gpio[38] gpio[39] gpio[43] gpio[2] gpio[8] gpio[10]
+ gpio[12] gpio[13] gpio[14] gpio[15] gpio[16] gpio[18] gpio[19] gpio[22] option gpio[25]
+ gpio[27] gpio[29] gpio[31] gpio[32] gpio[34] gpio[35] gpio[36] vccd gpio[4] gpio[20]
+ gpio[40] gpio[6] gpio[1] gpio[7] gpio[21] gpio[42] gpio[3] gpio[9] gpio[23] gpio[28]
+ gpio[5] gpio[0] gpio[11] vddio gpio[17] gpio[26] gpio[24] gpio[33] gpio[41] gpio[30]
+ resetb gpio[37] vssd sg13cmos5l_caravel_openframe
.ends
